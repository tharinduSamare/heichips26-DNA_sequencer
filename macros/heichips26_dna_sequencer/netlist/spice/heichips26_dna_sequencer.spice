* NGSPICE file created from heichips26_dna_sequencer.ext - technology: ihp-sg13cmos5l

* Black-box entry subcircuit for sg13cmos5l_nand2b_1 abstract view
.subckt sg13cmos5l_nand2b_1 Y A_N B VDD VSS
.ends

* Black-box entry subcircuit for sg13cmos5l_decap_8 abstract view
.subckt sg13cmos5l_decap_8 VDD VSS
.ends

* Black-box entry subcircuit for sg13cmos5l_nand2_1 abstract view
.subckt sg13cmos5l_nand2_1 Y A B VDD VSS
.ends

* Black-box entry subcircuit for sg13cmos5l_dfrbpq_1 abstract view
.subckt sg13cmos5l_dfrbpq_1 Q CLK D RESET_B VDD VSS
.ends

* Black-box entry subcircuit for sg13cmos5l_or3_1 abstract view
.subckt sg13cmos5l_or3_1 X A B C VDD VSS
.ends

* Black-box entry subcircuit for sg13cmos5l_fill_2 abstract view
.subckt sg13cmos5l_fill_2 VDD VSS
.ends

* Black-box entry subcircuit for sg13cmos5l_tiehi abstract view
.subckt sg13cmos5l_tiehi L_HI VDD VSS
.ends

* Black-box entry subcircuit for sg13cmos5l_decap_4 abstract view
.subckt sg13cmos5l_decap_4 VDD VSS
.ends

* Black-box entry subcircuit for sg13cmos5l_fill_1 abstract view
.subckt sg13cmos5l_fill_1 VDD VSS
.ends

* Black-box entry subcircuit for sg13cmos5l_nor2_1 abstract view
.subckt sg13cmos5l_nor2_1 Y A B VDD VSS
.ends

* Black-box entry subcircuit for sg13cmos5l_o21ai_1 abstract view
.subckt sg13cmos5l_o21ai_1 Y A1 A2 B1 VDD VSS
.ends

* Black-box entry subcircuit for sg13cmos5l_and4_1 abstract view
.subckt sg13cmos5l_and4_1 X A B C D VDD VSS
.ends

* Black-box entry subcircuit for sg13cmos5l_a21oi_1 abstract view
.subckt sg13cmos5l_a21oi_1 Y A1 A2 B1 VDD VSS
.ends

* Black-box entry subcircuit for sg13cmos5l_buf_1 abstract view
.subckt sg13cmos5l_buf_1 X A VDD VSS
.ends

* Black-box entry subcircuit for sg13cmos5l_mux2_1 abstract view
.subckt sg13cmos5l_mux2_1 X A0 A1 S VDD VSS
.ends

* Black-box entry subcircuit for sg13cmos5l_nand3_1 abstract view
.subckt sg13cmos5l_nand3_1 Y A B C VDD VSS
.ends

* Black-box entry subcircuit for sg13cmos5l_xnor2_1 abstract view
.subckt sg13cmos5l_xnor2_1 Y A B VDD VSS
.ends

* Black-box entry subcircuit for sg13cmos5l_mux4_1 abstract view
.subckt sg13cmos5l_mux4_1 X A0 A1 A2 A3 S0 S1 VDD VSS
.ends

* Black-box entry subcircuit for sg13cmos5l_dlygate4sd3_1 abstract view
.subckt sg13cmos5l_dlygate4sd3_1 X A VDD VSS
.ends

* Black-box entry subcircuit for sg13cmos5l_inv_1 abstract view
.subckt sg13cmos5l_inv_1 Y A VDD VSS
.ends

* Black-box entry subcircuit for sg13cmos5l_xor2_1 abstract view
.subckt sg13cmos5l_xor2_1 X A B VDD VSS
.ends

* Black-box entry subcircuit for sg13cmos5l_tielo abstract view
.subckt sg13cmos5l_tielo L_LO VDD VSS
.ends

* Black-box entry subcircuit for sg13cmos5l_a221oi_1 abstract view
.subckt sg13cmos5l_a221oi_1 Y A1 A2 B1 B2 C1 VDD VSS
.ends

* Black-box entry subcircuit for sg13cmos5l_and2_1 abstract view
.subckt sg13cmos5l_and2_1 X A B VDD VSS
.ends

* Black-box entry subcircuit for sg13cmos5l_nor2b_1 abstract view
.subckt sg13cmos5l_nor2b_1 Y A B_N VDD VSS
.ends

* Black-box entry subcircuit for sg13cmos5l_and3_1 abstract view
.subckt sg13cmos5l_and3_1 X A B C VDD VSS
.ends

* Black-box entry subcircuit for sg13cmos5l_nor3_1 abstract view
.subckt sg13cmos5l_nor3_1 Y A B C VDD VSS
.ends

* Black-box entry subcircuit for sg13cmos5l_a22oi_1 abstract view
.subckt sg13cmos5l_a22oi_1 Y A1 A2 B1 B2 VDD VSS
.ends

* Black-box entry subcircuit for sg13cmos5l_a21o_1 abstract view
.subckt sg13cmos5l_a21o_1 X A1 A2 B1 VDD VSS
.ends

* Black-box entry subcircuit for sg13cmos5l_or2_1 abstract view
.subckt sg13cmos5l_or2_1 X A B VDD VSS
.ends

* Black-box entry subcircuit for sg13cmos5l_nor4_1 abstract view
.subckt sg13cmos5l_nor4_1 Y A B C D VDD VSS
.ends

* Black-box entry subcircuit for sg13cmos5l_buf_8 abstract view
.subckt sg13cmos5l_buf_8 X A VDD VSS
.ends

* Black-box entry subcircuit for sg13cmos5l_nand4_1 abstract view
.subckt sg13cmos5l_nand4_1 Y A B C D VDD VSS
.ends

* Black-box entry subcircuit for sg13cmos5l_nand3b_1 abstract view
.subckt sg13cmos5l_nand3b_1 Y A_N B C VDD VSS
.ends

* Black-box entry subcircuit for sg13cmos5l_inv_2 abstract view
.subckt sg13cmos5l_inv_2 Y A VDD VSS
.ends

* Black-box entry subcircuit for sg13cmos5l_inv_4 abstract view
.subckt sg13cmos5l_inv_4 Y A VDD VSS
.ends

* Black-box entry subcircuit for sg13cmos5l_or4_1 abstract view
.subckt sg13cmos5l_or4_1 X A B C D VDD VSS
.ends

.subckt heichips26_dna_sequencer VGND VPWR clk ena rst_n ui_in[0] ui_in[1] ui_in[2]
+ ui_in[3] ui_in[4] ui_in[5] ui_in[6] ui_in[7] uio_in[0] uio_in[1] uio_in[2] uio_in[3]
+ uio_in[4] uio_in[5] uio_in[6] uio_in[7] uio_oe[0] uio_oe[1] uio_oe[2] uio_oe[3]
+ uio_oe[4] uio_oe[5] uio_oe[6] uio_oe[7] uio_out[0] uio_out[1] uio_out[2] uio_out[3]
+ uio_out[4] uio_out[5] uio_out[6] uio_out[7] uo_out[0] uo_out[1] uo_out[2] uo_out[3]
+ uo_out[4] uo_out[5] uo_out[6] uo_out[7]
X_3155_ _3320_/A _3431_/B _3254_/A VPWR VGND sg13cmos5l_nand2b_1
XFILLER_28_929 VPWR VGND sg13cmos5l_decap_8
XFILLER_27_439 VPWR VGND sg13cmos5l_decap_8
X_3086_ _3086_/Y _4232_/Q _3092_/B VPWR VGND sg13cmos5l_nand2_1
XFILLER_35_494 VPWR VGND sg13cmos5l_decap_8
X_3988_ _3988_/Q clkload4/A _3988_/D _3988_/RESET_B VPWR VGND sg13cmos5l_dfrbpq_1
X_2939_ _2940_/A _2942_/A _2949_/A _2939_/C VPWR VGND sg13cmos5l_or3_1
XFILLER_22_188 VPWR VGND sg13cmos5l_fill_2
X_3999__404 _3999_/RESET_B VPWR VGND sg13cmos5l_tiehi
XFILLER_26_450 VPWR VGND sg13cmos5l_fill_2
XFILLER_42_954 VPWR VGND sg13cmos5l_decap_8
XFILLER_14_667 VPWR VGND sg13cmos5l_decap_8
XFILLER_42_51 VPWR VGND sg13cmos5l_fill_2
XFILLER_6_866 VPWR VGND sg13cmos5l_decap_8
XFILLER_3_23 VPWR VGND sg13cmos5l_decap_4
XFILLER_3_67 VPWR VGND sg13cmos5l_decap_8
XFILLER_37_748 VPWR VGND sg13cmos5l_fill_1
XFILLER_44_291 VPWR VGND sg13cmos5l_fill_1
X_3911_ _3911_/Y _3911_/A _3911_/B VPWR VGND sg13cmos5l_nor2_1
XFILLER_32_431 VPWR VGND sg13cmos5l_fill_1
X_3842_ _3843_/A _3859_/A _3858_/B _3858_/A VPWR VGND sg13cmos5l_o21ai_1
XFILLER_34_1020 VPWR VGND sg13cmos5l_decap_8
X_3773_ _3773_/Y _3773_/A _3773_/B VPWR VGND sg13cmos5l_nand2_1
XFILLER_8_170 VPWR VGND sg13cmos5l_decap_8
XFILLER_9_682 VPWR VGND sg13cmos5l_fill_1
X_2724_ _2725_/B _2724_/A _2724_/B _2724_/C _2724_/D VPWR VGND sg13cmos5l_and4_1
X_2655_ _2655_/Y _2654_/S _2269_/Y _2657_/A1 VPWR VGND sg13cmos5l_o21ai_1
X_4325_ _4325_/Q _4377_/CLK _4325_/D _4325_/RESET_B VPWR VGND sg13cmos5l_dfrbpq_1
X_2586_ _2586_/Y _2701_/S _3977_/Q _2585_/Y VPWR VGND sg13cmos5l_a21oi_1
Xfanout116 _2436_/A0 input10/X VPWR VGND sg13cmos5l_buf_1
Xfanout105 _3952_/A input8/X VPWR VGND sg13cmos5l_buf_1
Xfanout127 _3616_/A fanout132/X VPWR VGND sg13cmos5l_buf_1
XFILLER_47_18 VPWR VGND sg13cmos5l_decap_8
X_4256_ _4256_/Q _4323_/CLK _4256_/D _4256_/RESET_B VPWR VGND sg13cmos5l_dfrbpq_1
X_4187_ _4187_/Q _4209_/CLK _4187_/D _4187_/RESET_B VPWR VGND sg13cmos5l_dfrbpq_1
X_3207_ _3208_/B _3207_/A _3207_/B VPWR VGND sg13cmos5l_nor2_1
X_3138_ _3138_/Y _4269_/Q _3139_/B VPWR VGND sg13cmos5l_nand2_1
XFILLER_27_225 VPWR VGND sg13cmos5l_fill_1
XFILLER_28_737 VPWR VGND sg13cmos5l_decap_8
XFILLER_42_228 VPWR VGND sg13cmos5l_fill_2
XFILLER_36_781 VPWR VGND sg13cmos5l_fill_2
XFILLER_27_269 VPWR VGND sg13cmos5l_fill_2
X_3069_ _3069_/Y _4227_/Q _3779_/A2 _3254_/A VPWR VGND sg13cmos5l_o21ai_1
XFILLER_23_442 VPWR VGND sg13cmos5l_decap_4
XFILLER_10_125 VPWR VGND sg13cmos5l_fill_1
XFILLER_3_814 VPWR VGND sg13cmos5l_decap_4
XFILLER_46_501 VPWR VGND sg13cmos5l_fill_2
X_4370__538 _4370_/RESET_B VPWR VGND sg13cmos5l_tiehi
XFILLER_46_534 VPWR VGND sg13cmos5l_decap_4
XFILLER_46_512 VPWR VGND sg13cmos5l_fill_1
XFILLER_18_1026 VPWR VGND sg13cmos5l_fill_2
XFILLER_41_272 VPWR VGND sg13cmos5l_decap_8
XFILLER_14_486 VPWR VGND sg13cmos5l_fill_2
XFILLER_30_968 VPWR VGND sg13cmos5l_decap_8
XFILLER_6_652 VPWR VGND sg13cmos5l_fill_1
XFILLER_10_692 VPWR VGND sg13cmos5l_fill_1
XFILLER_6_696 VPWR VGND sg13cmos5l_decap_8
X_2440_ _4110_/D input5/X hold756/X _2440_/S VPWR VGND sg13cmos5l_mux2_1
XFILLER_38_4 VPWR VGND sg13cmos5l_fill_2
X_2371_ _2379_/S _2501_/A _2500_/C _2371_/C VPWR VGND sg13cmos5l_nand3_1
X_4110_ _4110_/Q _4136_/CLK _4110_/D _4110_/RESET_B VPWR VGND sg13cmos5l_dfrbpq_1
XFILLER_1_390 VPWR VGND sg13cmos5l_fill_2
X_4041_ _4041_/Q clkload4/A _4041_/D _4041_/RESET_B VPWR VGND sg13cmos5l_dfrbpq_1
XFILLER_49_383 VPWR VGND sg13cmos5l_decap_8
X_3825_ _3826_/B _4310_/Q _4311_/Q VPWR VGND sg13cmos5l_xnor2_1
X_3756_ _3756_/Y _3756_/A _4363_/Q VPWR VGND sg13cmos5l_nor2_1
X_2707_ _2710_/B _2707_/A _2707_/B VPWR VGND sg13cmos5l_nand2_1
XFILLER_9_490 VPWR VGND sg13cmos5l_fill_2
X_3687_ _3701_/B _4339_/Q _4337_/Q _4338_/Q VPWR VGND sg13cmos5l_or3_1
X_2638_ _2639_/A _4108_/Q _4091_/Q _4074_/Q _4057_/Q _2665_/A _2658_/S1 VPWR VGND
+ sg13cmos5l_mux4_1
X_2569_ _2569_/Y _2570_/B _2556_/Y hold901/X VPWR VGND sg13cmos5l_o21ai_1
X_4308_ _4308_/Q _4333_/CLK _4308_/D _4308_/RESET_B VPWR VGND sg13cmos5l_dfrbpq_1
X_4239_ _4239_/Q _4272_/CLK _4239_/D _4239_/RESET_B VPWR VGND sg13cmos5l_dfrbpq_1
X_4352__257 _4352_/RESET_B VPWR VGND sg13cmos5l_tiehi
XFILLER_28_512 VPWR VGND sg13cmos5l_fill_1
XFILLER_15_206 VPWR VGND sg13cmos5l_decap_4
XFILLER_28_578 VPWR VGND sg13cmos5l_decap_8
XFILLER_12_957 VPWR VGND sg13cmos5l_decap_8
XFILLER_23_42 VPWR VGND sg13cmos5l_decap_8
XFILLER_23_53 VPWR VGND sg13cmos5l_fill_1
XFILLER_7_416 VPWR VGND sg13cmos5l_decap_4
XFILLER_2_132 VPWR VGND sg13cmos5l_decap_8
XFILLER_47_821 VPWR VGND sg13cmos5l_decap_8
XFILLER_46_342 VPWR VGND sg13cmos5l_decap_8
XFILLER_46_331 VPWR VGND sg13cmos5l_fill_1
XFILLER_0_35 VPWR VGND sg13cmos5l_decap_8
XFILLER_47_898 VPWR VGND sg13cmos5l_decap_8
XFILLER_19_567 VPWR VGND sg13cmos5l_fill_2
XFILLER_34_548 VPWR VGND sg13cmos5l_decap_4
XFILLER_15_773 VPWR VGND sg13cmos5l_fill_2
X_3610_ _3610_/Y hold669/X _3613_/A2 _3616_/A VPWR VGND sg13cmos5l_o21ai_1
XFILLER_30_787 VPWR VGND sg13cmos5l_fill_1
X_3541_ _3628_/A _3839_/A _3666_/B VPWR VGND sg13cmos5l_nor2_1
Xhold928 hold928/X _3095_/Y VPWR VGND sg13cmos5l_dlygate4sd3_1
Xhold917 hold917/X _3747_/Y VPWR VGND sg13cmos5l_dlygate4sd3_1
Xhold906 hold906/X _4251_/Q VPWR VGND sg13cmos5l_dlygate4sd3_1
X_3472_ _3476_/A _3490_/A _3472_/B VPWR VGND sg13cmos5l_nor2_1
Xhold939 _2900_/B _2899_/X VPWR VGND sg13cmos5l_dlygate4sd3_1
X_2423_ _4094_/D _3964_/A0 hold742/X _2430_/S VPWR VGND sg13cmos5l_mux2_1
X_2354_ _4037_/D _3954_/A hold787/X _2359_/S VPWR VGND sg13cmos5l_mux2_1
X_2285_ _3217_/B _2285_/A VPWR VGND sg13cmos5l_inv_1
XFILLER_38_843 VPWR VGND sg13cmos5l_decap_8
XFILLER_37_320 VPWR VGND sg13cmos5l_decap_8
X_4024_ _4024_/Q clkload4/A _4024_/D _4024_/RESET_B VPWR VGND sg13cmos5l_dfrbpq_1
X_3808_ _3808_/X _3808_/A _3808_/B VPWR VGND sg13cmos5l_xor2_1
X_3739_ _3739_/Y _4317_/Q _3752_/A _3738_/Y VPWR VGND sg13cmos5l_o21ai_1
XFILLER_0_603 VPWR VGND sg13cmos5l_decap_8
XFILLER_0_658 VPWR VGND sg13cmos5l_fill_1
XFILLER_47_128 VPWR VGND sg13cmos5l_decap_8
XFILLER_47_106 VPWR VGND sg13cmos5l_fill_1
XFILLER_18_31 VPWR VGND sg13cmos5l_decap_8
XFILLER_44_813 VPWR VGND sg13cmos5l_decap_8
XFILLER_18_75 VPWR VGND sg13cmos5l_decap_4
XFILLER_28_375 VPWR VGND sg13cmos5l_decap_8
XFILLER_18_97 VPWR VGND sg13cmos5l_decap_8
XFILLER_12_721 VPWR VGND sg13cmos5l_fill_1
XFILLER_34_52 VPWR VGND sg13cmos5l_fill_1
XFILLER_12_754 VPWR VGND sg13cmos5l_decap_8
X_4363__150 _4363_/D VPWR VGND sg13cmos5l_tielo
X_4226__511 _4226_/RESET_B VPWR VGND sg13cmos5l_tiehi
XFILLER_4_942 VPWR VGND sg13cmos5l_decap_8
X_4376__544 _4376_/RESET_B VPWR VGND sg13cmos5l_tiehi
XFILLER_38_128 VPWR VGND sg13cmos5l_decap_8
X_2972_ _2974_/B _4213_/Q _2977_/A VPWR VGND sg13cmos5l_xor2_1
Xhold703 hold703/X _4046_/Q VPWR VGND sg13cmos5l_dlygate4sd3_1
XFILLER_7_791 VPWR VGND sg13cmos5l_fill_2
XFILLER_7_780 VPWR VGND sg13cmos5l_decap_8
X_3524_ _3524_/Y _3513_/X _3518_/Y _3522_/Y _3523_/X _3519_/X VPWR VGND sg13cmos5l_a221oi_1
Xhold725 hold725/X _3983_/Q VPWR VGND sg13cmos5l_dlygate4sd3_1
Xhold714 hold714/X _4036_/Q VPWR VGND sg13cmos5l_dlygate4sd3_1
Xhold736 hold736/X _3984_/Q VPWR VGND sg13cmos5l_dlygate4sd3_1
Xhold758 hold758/X _3997_/Q VPWR VGND sg13cmos5l_dlygate4sd3_1
XFILLER_6_290 VPWR VGND sg13cmos5l_fill_2
Xhold769 _4040_/D _2357_/X VPWR VGND sg13cmos5l_dlygate4sd3_1
X_3455_ _3455_/Y _4291_/Q _4262_/Q VPWR VGND sg13cmos5l_nand2_1
Xhold747 hold747/X _4088_/Q VPWR VGND sg13cmos5l_dlygate4sd3_1
X_2406_ _4080_/D _2435_/A0 hold780/X _2410_/S VPWR VGND sg13cmos5l_mux2_1
X_3386_ _4278_/D _3444_/B _3452_/A VPWR VGND sg13cmos5l_and2_1
X_2337_ _4025_/D _2266_/Y _2336_/B _2336_/Y VPWR VGND sg13cmos5l_a21oi_1
X_2268_ _2268_/Y _3997_/Q VPWR VGND sg13cmos5l_inv_1
X_4007_ _4007_/Q clkload4/A _4007_/D _4007_/RESET_B VPWR VGND sg13cmos5l_dfrbpq_1
XFILLER_38_695 VPWR VGND sg13cmos5l_fill_2
XFILLER_26_846 VPWR VGND sg13cmos5l_fill_1
XFILLER_38_1007 VPWR VGND sg13cmos5l_decap_8
XFILLER_25_345 VPWR VGND sg13cmos5l_decap_8
XFILLER_21_595 VPWR VGND sg13cmos5l_decap_8
XFILLER_4_227 VPWR VGND sg13cmos5l_decap_8
XFILLER_1_901 VPWR VGND sg13cmos5l_decap_8
XFILLER_1_978 VPWR VGND sg13cmos5l_decap_8
X_4191__562 _4191_/RESET_B VPWR VGND sg13cmos5l_tiehi
XFILLER_35_109 VPWR VGND sg13cmos5l_decap_8
XFILLER_32_816 VPWR VGND sg13cmos5l_fill_1
XFILLER_43_175 VPWR VGND sg13cmos5l_decap_8
XFILLER_6_89 VPWR VGND sg13cmos5l_fill_1
XFILLER_4_772 VPWR VGND sg13cmos5l_decap_8
X_3240_ _3240_/Y _3227_/B _3236_/Y hold923/X VPWR VGND sg13cmos5l_a21oi_1
X_3171_ _3305_/A _3266_/A VPWR VGND sg13cmos5l_inv_1
XFILLER_48_971 VPWR VGND sg13cmos5l_decap_8
XFILLER_35_643 VPWR VGND sg13cmos5l_decap_8
XFILLER_35_654 VPWR VGND sg13cmos5l_fill_2
XFILLER_22_304 VPWR VGND sg13cmos5l_fill_2
XFILLER_35_698 VPWR VGND sg13cmos5l_decap_8
X_2955_ _2957_/A _2955_/A _2958_/A VPWR VGND sg13cmos5l_nor2b_1
X_2886_ _2886_/Y _4209_/Q _3076_/A VPWR VGND sg13cmos5l_nor2b_1
XFILLER_30_370 VPWR VGND sg13cmos5l_fill_2
XFILLER_31_893 VPWR VGND sg13cmos5l_decap_8
XFILLER_2_709 VPWR VGND sg13cmos5l_decap_8
X_3507_ _3523_/B _4307_/Q _4306_/Q _4305_/Q VPWR VGND sg13cmos5l_or3_1
Xhold588 _3254_/B _4230_/Q VPWR VGND sg13cmos5l_dlygate4sd3_1
X_3438_ _4292_/D _3615_/A _3438_/B VPWR VGND sg13cmos5l_and2_1
Xhold599 _2797_/B _4153_/Q VPWR VGND sg13cmos5l_dlygate4sd3_1
X_3369_ _3369_/X _4250_/Q _3369_/B VPWR VGND sg13cmos5l_xor2_1
XFILLER_46_908 VPWR VGND sg13cmos5l_decap_8
X_4216__521 _4216_/RESET_B VPWR VGND sg13cmos5l_tiehi
X_4314__155 _4314_/D VPWR VGND sg13cmos5l_tielo
XFILLER_15_32 VPWR VGND sg13cmos5l_decap_8
XFILLER_13_359 VPWR VGND sg13cmos5l_decap_8
XFILLER_25_186 VPWR VGND sg13cmos5l_fill_1
XFILLER_22_871 VPWR VGND sg13cmos5l_decap_4
XFILLER_31_42 VPWR VGND sg13cmos5l_fill_1
XFILLER_5_525 VPWR VGND sg13cmos5l_fill_1
X_4223__514 _4223_/RESET_B VPWR VGND sg13cmos5l_tiehi
XFILLER_31_64 VPWR VGND sg13cmos5l_fill_2
XFILLER_49_724 VPWR VGND sg13cmos5l_fill_1
XFILLER_0_252 VPWR VGND sg13cmos5l_decap_8
XFILLER_49_757 VPWR VGND sg13cmos5l_decap_8
XFILLER_48_234 VPWR VGND sg13cmos5l_fill_1
XFILLER_37_908 VPWR VGND sg13cmos5l_decap_8
XFILLER_37_919 VPWR VGND sg13cmos5l_fill_1
XFILLER_29_481 VPWR VGND sg13cmos5l_decap_4
XFILLER_45_952 VPWR VGND sg13cmos5l_decap_8
XFILLER_13_860 VPWR VGND sg13cmos5l_decap_8
X_2740_ _2740_/Y _2918_/A _2917_/A VPWR VGND sg13cmos5l_nand2_1
XFILLER_13_882 VPWR VGND sg13cmos5l_fill_1
X_2671_ _2671_/Y _2704_/A1 _2668_/X _2675_/A VPWR VGND sg13cmos5l_o21ai_1
X_4341_ _4341_/Q clkload6/A _4341_/D _4341_/RESET_B VPWR VGND sg13cmos5l_dfrbpq_1
X_4272_ _4272_/Q _4272_/CLK _4272_/D _4272_/RESET_B VPWR VGND sg13cmos5l_dfrbpq_1
X_3223_ _3241_/A _4224_/Q _3221_/Y _3222_/Y VPWR VGND sg13cmos5l_o21ai_1
X_3154_ _3154_/Y _3323_/A _3431_/B VPWR VGND sg13cmos5l_nor2_1
XFILLER_28_908 VPWR VGND sg13cmos5l_decap_8
X_3085_ _3114_/A _4234_/Q _3092_/B VPWR VGND sg13cmos5l_xnor2_1
XFILLER_36_996 VPWR VGND sg13cmos5l_decap_8
XFILLER_35_473 VPWR VGND sg13cmos5l_decap_8
X_3987_ _3987_/Q _4378_/CLK _3987_/D _3987_/RESET_B VPWR VGND sg13cmos5l_dfrbpq_1
XFILLER_10_329 VPWR VGND sg13cmos5l_decap_8
XFILLER_31_690 VPWR VGND sg13cmos5l_fill_1
X_2938_ _2939_/C _2938_/A _2938_/B _2938_/C VPWR VGND sg13cmos5l_and3_1
X_2869_ _2869_/Y _2869_/A _2874_/A VPWR VGND sg13cmos5l_nor2_1
X_4181__572 _4181_/RESET_B VPWR VGND sg13cmos5l_tiehi
XFILLER_46_716 VPWR VGND sg13cmos5l_decap_8
XFILLER_19_908 VPWR VGND sg13cmos5l_decap_8
XFILLER_46_749 VPWR VGND sg13cmos5l_fill_1
XFILLER_46_727 VPWR VGND sg13cmos5l_fill_2
XFILLER_42_933 VPWR VGND sg13cmos5l_decap_8
XFILLER_41_432 VPWR VGND sg13cmos5l_fill_2
XFILLER_14_646 VPWR VGND sg13cmos5l_fill_2
XFILLER_14_657 VPWR VGND sg13cmos5l_fill_2
XFILLER_41_454 VPWR VGND sg13cmos5l_fill_1
XFILLER_9_149 VPWR VGND sg13cmos5l_fill_2
XFILLER_10_863 VPWR VGND sg13cmos5l_decap_4
XFILLER_6_845 VPWR VGND sg13cmos5l_fill_1
XFILLER_10_874 VPWR VGND sg13cmos5l_fill_1
XFILLER_5_355 VPWR VGND sg13cmos5l_decap_8
XFILLER_5_366 VPWR VGND sg13cmos5l_fill_2
XFILLER_49_532 VPWR VGND sg13cmos5l_decap_4
XFILLER_49_587 VPWR VGND sg13cmos5l_decap_8
XFILLER_18_930 VPWR VGND sg13cmos5l_fill_2
XFILLER_36_248 VPWR VGND sg13cmos5l_fill_1
XFILLER_18_985 VPWR VGND sg13cmos5l_fill_1
XFILLER_18_996 VPWR VGND sg13cmos5l_fill_1
X_3910_ _3910_/Y _3916_/A _3910_/B _3910_/C VPWR VGND sg13cmos5l_nor3_1
X_3841_ _3848_/B _3831_/Y _3838_/X _3840_/Y VPWR VGND sg13cmos5l_o21ai_1
XFILLER_33_999 VPWR VGND sg13cmos5l_decap_8
X_3772_ _4346_/D _3772_/A _3772_/B VPWR VGND sg13cmos5l_nor2_1
XFILLER_32_487 VPWR VGND sg13cmos5l_decap_8
XFILLER_9_661 VPWR VGND sg13cmos5l_decap_4
X_2723_ _2724_/D _2723_/A _2723_/B VPWR VGND sg13cmos5l_xnor2_1
X_4206__531 _4206_/RESET_B VPWR VGND sg13cmos5l_tiehi
X_2654_ _2654_/X _4037_/Q _4020_/Q _2654_/S VPWR VGND sg13cmos5l_mux2_1
X_2585_ _2585_/Y _2701_/S _2262_/Y _2704_/A1 VPWR VGND sg13cmos5l_o21ai_1
X_4324_ _4324_/Q _4377_/CLK _4324_/D _4324_/RESET_B VPWR VGND sg13cmos5l_dfrbpq_1
Xfanout106 _3951_/A0 _3965_/A0 VPWR VGND sg13cmos5l_buf_1
Xfanout117 _3956_/A input10/X VPWR VGND sg13cmos5l_buf_1
Xfanout128 _3607_/A _2913_/A VPWR VGND sg13cmos5l_buf_1
X_4255_ _4255_/Q _4302_/CLK _4255_/D _4255_/RESET_B VPWR VGND sg13cmos5l_dfrbpq_1
X_4186_ _4186_/Q _4209_/CLK _4186_/D _4186_/RESET_B VPWR VGND sg13cmos5l_dfrbpq_1
XFILLER_41_1025 VPWR VGND sg13cmos5l_decap_4
X_3206_ _3207_/B _3182_/B _3175_/C _3197_/B _3193_/A _3200_/B VPWR VGND sg13cmos5l_a221oi_1
X_3137_ _3139_/B _4268_/Q _4241_/Q VPWR VGND sg13cmos5l_nand2_1
X_4213__524 _4213_/RESET_B VPWR VGND sg13cmos5l_tiehi
XFILLER_36_771 VPWR VGND sg13cmos5l_decap_4
XFILLER_24_911 VPWR VGND sg13cmos5l_decap_8
X_3068_ _3068_/Y _2228_/Y _3781_/A2 _3067_/Y VPWR VGND sg13cmos5l_a21oi_1
XFILLER_24_955 VPWR VGND sg13cmos5l_decap_8
XFILLER_24_966 VPWR VGND sg13cmos5l_fill_2
XFILLER_12_11 VPWR VGND sg13cmos5l_decap_8
XFILLER_6_119 VPWR VGND sg13cmos5l_decap_4
XFILLER_12_55 VPWR VGND sg13cmos5l_decap_4
XFILLER_12_99 VPWR VGND sg13cmos5l_decap_8
X_4220__517 _4220_/RESET_B VPWR VGND sg13cmos5l_tiehi
XFILLER_2_325 VPWR VGND sg13cmos5l_decap_8
XFILLER_2_347 VPWR VGND sg13cmos5l_decap_8
X_4099__285 _4099_/RESET_B VPWR VGND sg13cmos5l_tiehi
XFILLER_19_738 VPWR VGND sg13cmos5l_decap_8
XFILLER_46_557 VPWR VGND sg13cmos5l_decap_8
XFILLER_42_741 VPWR VGND sg13cmos5l_decap_4
XFILLER_42_763 VPWR VGND sg13cmos5l_fill_1
XFILLER_42_752 VPWR VGND sg13cmos5l_decap_8
XFILLER_14_465 VPWR VGND sg13cmos5l_decap_8
XFILLER_18_1005 VPWR VGND sg13cmos5l_decap_8
XFILLER_26_292 VPWR VGND sg13cmos5l_fill_1
XFILLER_30_947 VPWR VGND sg13cmos5l_decap_8
XFILLER_45_6 VPWR VGND sg13cmos5l_fill_1
XFILLER_5_174 VPWR VGND sg13cmos5l_fill_2
X_2370_ _4050_/D _2439_/A0 hold750/X _2370_/S VPWR VGND sg13cmos5l_mux2_1
X_4040_ _4040_/Q clkload3/A _4040_/D _4040_/RESET_B VPWR VGND sg13cmos5l_dfrbpq_1
XFILLER_49_362 VPWR VGND sg13cmos5l_decap_8
XFILLER_18_793 VPWR VGND sg13cmos5l_decap_4
XFILLER_17_292 VPWR VGND sg13cmos5l_decap_4
X_3824_ _3826_/A _4314_/Q _3819_/A _3819_/B VPWR VGND sg13cmos5l_o21ai_1
XFILLER_20_457 VPWR VGND sg13cmos5l_fill_1
XFILLER_32_295 VPWR VGND sg13cmos5l_fill_1
X_3755_ _3755_/Y _4344_/Q _3749_/X _3754_/Y _4345_/Q VPWR VGND sg13cmos5l_a22oi_1
X_2706_ _2707_/B _4033_/Q _4016_/Q _3999_/Q _3982_/Q _2706_/S0 _2706_/S1 VPWR VGND
+ sg13cmos5l_mux4_1
X_3686_ _3726_/A _4360_/Q _3748_/B VPWR VGND sg13cmos5l_xnor2_1
X_2637_ _2637_/X _4040_/Q _4023_/Q _4006_/Q _3989_/Q _2632_/S _2669_/B1 VPWR VGND
+ sg13cmos5l_mux4_1
X_2568_ _2568_/Y _2568_/A _4144_/Q VPWR VGND sg13cmos5l_nor2b_1
X_4307_ _4307_/Q _4333_/CLK _4307_/D _4307_/RESET_B VPWR VGND sg13cmos5l_dfrbpq_1
X_2499_ _3936_/B _4129_/Q _4128_/Q VPWR VGND sg13cmos5l_nand2_1
X_4238_ _4238_/Q _4238_/CLK _4238_/D _4238_/RESET_B VPWR VGND sg13cmos5l_dfrbpq_1
X_4169_ _4169_/Q _4225_/CLK _4169_/D _4169_/RESET_B VPWR VGND sg13cmos5l_dfrbpq_1
XFILLER_43_505 VPWR VGND sg13cmos5l_decap_8
XFILLER_43_549 VPWR VGND sg13cmos5l_decap_8
X_4287__444 _4287_/RESET_B VPWR VGND sg13cmos5l_tiehi
XFILLER_12_936 VPWR VGND sg13cmos5l_decap_8
XFILLER_23_251 VPWR VGND sg13cmos5l_decap_8
XFILLER_7_439 VPWR VGND sg13cmos5l_decap_8
XFILLER_3_645 VPWR VGND sg13cmos5l_decap_8
XFILLER_3_623 VPWR VGND sg13cmos5l_decap_8
XFILLER_2_122 VPWR VGND sg13cmos5l_fill_1
XFILLER_3_678 VPWR VGND sg13cmos5l_fill_1
XFILLER_3_667 VPWR VGND sg13cmos5l_decap_8
XFILLER_2_199 VPWR VGND sg13cmos5l_fill_1
XFILLER_47_800 VPWR VGND sg13cmos5l_decap_8
XFILLER_48_95 VPWR VGND sg13cmos5l_fill_2
XFILLER_48_84 VPWR VGND sg13cmos5l_decap_8
XFILLER_19_502 VPWR VGND sg13cmos5l_decap_8
XFILLER_0_14 VPWR VGND sg13cmos5l_decap_8
XFILLER_47_877 VPWR VGND sg13cmos5l_decap_8
XFILLER_19_579 VPWR VGND sg13cmos5l_fill_1
XFILLER_31_1013 VPWR VGND sg13cmos5l_decap_8
X_3540_ _3666_/B _3509_/X _3523_/X _3525_/Y VPWR VGND sg13cmos5l_o21ai_1
XFILLER_11_991 VPWR VGND sg13cmos5l_decap_8
Xhold918 _3023_/B _4206_/Q VPWR VGND sg13cmos5l_dlygate4sd3_1
XFILLER_7_984 VPWR VGND sg13cmos5l_decap_8
XFILLER_6_461 VPWR VGND sg13cmos5l_decap_8
Xhold907 hold907/X _3237_/Y VPWR VGND sg13cmos5l_dlygate4sd3_1
X_4203__534 _4203_/RESET_B VPWR VGND sg13cmos5l_tiehi
Xhold929 _2800_/A _4176_/Q VPWR VGND sg13cmos5l_dlygate4sd3_1
X_3471_ _3471_/Y _3471_/A _3471_/B VPWR VGND sg13cmos5l_xnor2_1
X_2422_ _2430_/S _3937_/A _2431_/B VPWR VGND sg13cmos5l_nand2_1
X_4121__256 _4121_/RESET_B VPWR VGND sg13cmos5l_tiehi
XFILLER_9_1014 VPWR VGND sg13cmos5l_decap_8
X_2353_ _4036_/D _3952_/A hold714/X _2359_/S VPWR VGND sg13cmos5l_mux2_1
X_4023_ _4023_/Q _4378_/CLK _4023_/D _4023_/RESET_B VPWR VGND sg13cmos5l_dfrbpq_1
X_2284_ _3224_/B _2284_/A VPWR VGND sg13cmos5l_inv_1
X_4210__527 _4210_/RESET_B VPWR VGND sg13cmos5l_tiehi
XFILLER_40_508 VPWR VGND sg13cmos5l_decap_4
XFILLER_18_590 VPWR VGND sg13cmos5l_decap_8
X_3807_ _3808_/B _4353_/Q _3790_/Y _3787_/Y VPWR VGND sg13cmos5l_a21oi_1
XFILLER_20_243 VPWR VGND sg13cmos5l_decap_8
XFILLER_20_254 VPWR VGND sg13cmos5l_fill_1
XFILLER_21_788 VPWR VGND sg13cmos5l_decap_8
X_4089__295 _4089_/RESET_B VPWR VGND sg13cmos5l_tiehi
X_3738_ _3738_/Y _4318_/Q _4361_/Q VPWR VGND sg13cmos5l_nand2b_1
X_3669_ _3672_/B _3669_/A _3669_/B VPWR VGND sg13cmos5l_nor2_1
XFILLER_29_811 VPWR VGND sg13cmos5l_fill_2
X_4096__288 _4096_/RESET_B VPWR VGND sg13cmos5l_tiehi
XFILLER_43_313 VPWR VGND sg13cmos5l_decap_8
XFILLER_28_387 VPWR VGND sg13cmos5l_decap_8
XFILLER_44_869 VPWR VGND sg13cmos5l_decap_8
XFILLER_43_346 VPWR VGND sg13cmos5l_fill_1
XFILLER_43_379 VPWR VGND sg13cmos5l_decap_8
XFILLER_34_97 VPWR VGND sg13cmos5l_decap_4
XFILLER_11_243 VPWR VGND sg13cmos5l_fill_1
XFILLER_12_788 VPWR VGND sg13cmos5l_decap_8
XFILLER_7_247 VPWR VGND sg13cmos5l_decap_4
XFILLER_4_921 VPWR VGND sg13cmos5l_decap_8
XFILLER_4_998 VPWR VGND sg13cmos5l_decap_8
XFILLER_3_475 VPWR VGND sg13cmos5l_decap_4
XFILLER_19_343 VPWR VGND sg13cmos5l_decap_8
XFILLER_19_387 VPWR VGND sg13cmos5l_fill_1
XFILLER_22_508 VPWR VGND sg13cmos5l_decap_8
X_2971_ _2987_/B _4213_/Q _2977_/A VPWR VGND sg13cmos5l_nor2_1
XFILLER_43_891 VPWR VGND sg13cmos5l_decap_8
XFILLER_15_582 VPWR VGND sg13cmos5l_decap_8
XFILLER_30_541 VPWR VGND sg13cmos5l_fill_1
X_4346__371 _4346_/RESET_B VPWR VGND sg13cmos5l_tiehi
Xhold704 hold704/X _3976_/Q VPWR VGND sg13cmos5l_dlygate4sd3_1
X_3523_ _3523_/X _4308_/Q _3523_/B VPWR VGND sg13cmos5l_xor2_1
Xhold737 hold737/X _4093_/Q VPWR VGND sg13cmos5l_dlygate4sd3_1
Xhold726 hold726/X _3985_/Q VPWR VGND sg13cmos5l_dlygate4sd3_1
Xhold715 hold715/X _4091_/Q VPWR VGND sg13cmos5l_dlygate4sd3_1
Xhold759 _3997_/D _3945_/X VPWR VGND sg13cmos5l_dlygate4sd3_1
X_3454_ _3454_/X _3454_/A _3454_/B VPWR VGND sg13cmos5l_and2_1
Xhold748 hold748/X _4022_/Q VPWR VGND sg13cmos5l_dlygate4sd3_1
X_2405_ _4079_/D _2434_/A0 hold721/X _2410_/S VPWR VGND sg13cmos5l_mux2_1
X_4277__454 _4277_/RESET_B VPWR VGND sg13cmos5l_tiehi
X_3385_ _3452_/A _3151_/X _3388_/B _3385_/B1 VPWR VGND sg13cmos5l_a21o_1
X_2336_ _2336_/Y input5/X _2336_/B VPWR VGND sg13cmos5l_nor2_1
X_2267_ _2267_/Y _2267_/A VPWR VGND sg13cmos5l_inv_1
XFILLER_38_641 VPWR VGND sg13cmos5l_decap_4
XFILLER_38_674 VPWR VGND sg13cmos5l_decap_8
X_4006_ _4006_/Q clkload5/A _4006_/D _4006_/RESET_B VPWR VGND sg13cmos5l_dfrbpq_1
XFILLER_26_858 VPWR VGND sg13cmos5l_decap_4
XFILLER_41_817 VPWR VGND sg13cmos5l_decap_8
XFILLER_40_305 VPWR VGND sg13cmos5l_decap_8
X_4284__447 _4284_/RESET_B VPWR VGND sg13cmos5l_tiehi
XFILLER_34_891 VPWR VGND sg13cmos5l_decap_8
XFILLER_21_552 VPWR VGND sg13cmos5l_decap_8
XFILLER_5_729 VPWR VGND sg13cmos5l_decap_8
XFILLER_4_206 VPWR VGND sg13cmos5l_fill_1
XFILLER_20_66 VPWR VGND sg13cmos5l_decap_4
XFILLER_1_957 VPWR VGND sg13cmos5l_decap_8
XFILLER_49_939 VPWR VGND sg13cmos5l_decap_8
XFILLER_0_489 VPWR VGND sg13cmos5l_decap_8
XFILLER_21_1023 VPWR VGND sg13cmos5l_decap_4
XFILLER_29_674 VPWR VGND sg13cmos5l_fill_2
XFILLER_44_622 VPWR VGND sg13cmos5l_decap_8
XFILLER_16_324 VPWR VGND sg13cmos5l_fill_1
XFILLER_43_110 VPWR VGND sg13cmos5l_decap_4
XFILLER_16_357 VPWR VGND sg13cmos5l_decap_8
XFILLER_17_869 VPWR VGND sg13cmos5l_fill_2
XFILLER_44_688 VPWR VGND sg13cmos5l_fill_2
XFILLER_16_368 VPWR VGND sg13cmos5l_fill_1
XFILLER_25_880 VPWR VGND sg13cmos5l_decap_8
XFILLER_40_850 VPWR VGND sg13cmos5l_decap_4
XFILLER_12_585 VPWR VGND sg13cmos5l_decap_8
XFILLER_4_751 VPWR VGND sg13cmos5l_decap_8
XFILLER_6_1028 VPWR VGND sg13cmos5l_fill_1
X_3170_ _3266_/A _3164_/A _3380_/A _3169_/Y VPWR VGND sg13cmos5l_a21oi_1
XFILLER_13_4 VPWR VGND sg13cmos5l_decap_8
XFILLER_48_950 VPWR VGND sg13cmos5l_decap_8
XFILLER_16_891 VPWR VGND sg13cmos5l_decap_8
X_2954_ _2958_/A _2940_/Y _2941_/X _2953_/Y VPWR VGND sg13cmos5l_o21ai_1
X_2885_ _2885_/Y _2882_/Y _2883_/Y _2884_/Y VPWR VGND sg13cmos5l_o21ai_1
X_4086__298 _4086_/RESET_B VPWR VGND sg13cmos5l_tiehi
X_3506_ _3506_/Y _4320_/Q _3775_/A VPWR VGND sg13cmos5l_nand2b_1
X_3437_ _3437_/Y _2223_/Y _3779_/A2 _3436_/Y VPWR VGND sg13cmos5l_a21oi_1
Xhold589 _3074_/B _4200_/Q VPWR VGND sg13cmos5l_dlygate4sd3_1
XFILLER_44_1023 VPWR VGND sg13cmos5l_decap_4
X_3368_ _3368_/Y _4250_/Q _3369_/B VPWR VGND sg13cmos5l_nand2_1
X_2319_ _2319_/Y _2473_/A hold886/X _3901_/B VPWR VGND sg13cmos5l_a21oi_1
X_4290__440 _4290_/RESET_B VPWR VGND sg13cmos5l_tiehi
X_3299_ _3300_/C _3299_/A _3299_/B _3299_/C VPWR VGND sg13cmos5l_and3_1
XFILLER_15_11 VPWR VGND sg13cmos5l_decap_8
XFILLER_13_349 VPWR VGND sg13cmos5l_fill_1
XFILLER_15_66 VPWR VGND sg13cmos5l_decap_4
XFILLER_40_179 VPWR VGND sg13cmos5l_decap_8
XFILLER_21_360 VPWR VGND sg13cmos5l_fill_2
XFILLER_22_894 VPWR VGND sg13cmos5l_decap_8
XFILLER_31_32 VPWR VGND sg13cmos5l_fill_1
XFILLER_31_98 VPWR VGND sg13cmos5l_decap_8
XFILLER_49_703 VPWR VGND sg13cmos5l_decap_8
XFILLER_49_736 VPWR VGND sg13cmos5l_decap_8
XFILLER_45_931 VPWR VGND sg13cmos5l_decap_8
XFILLER_16_154 VPWR VGND sg13cmos5l_decap_8
XFILLER_16_165 VPWR VGND sg13cmos5l_decap_4
XFILLER_20_809 VPWR VGND sg13cmos5l_decap_8
X_4267__464 _4267_/RESET_B VPWR VGND sg13cmos5l_tiehi
X_2670_ _2670_/Y _2670_/A1 _3988_/Q _2669_/Y VPWR VGND sg13cmos5l_a21oi_1
XFILLER_8_397 VPWR VGND sg13cmos5l_decap_8
XFILLER_4_570 VPWR VGND sg13cmos5l_fill_1
X_4340_ _4340_/Q clkload6/A _4340_/D _4340_/RESET_B VPWR VGND sg13cmos5l_dfrbpq_1
X_4271_ _4271_/Q _4272_/CLK _4271_/D _4271_/RESET_B VPWR VGND sg13cmos5l_dfrbpq_1
X_3222_ _3222_/Y _3222_/A _3445_/A _3222_/C VPWR VGND sg13cmos5l_nand3_1
X_4274__457 _4274_/RESET_B VPWR VGND sg13cmos5l_tiehi
X_3153_ _3153_/Y _3156_/A VPWR VGND sg13cmos5l_inv_1
X_3084_ _3084_/Y _3089_/A _3092_/B VPWR VGND sg13cmos5l_nand2_1
XFILLER_36_975 VPWR VGND sg13cmos5l_decap_8
XFILLER_23_614 VPWR VGND sg13cmos5l_fill_2
X_3986_ _3986_/Q clkload4/A _3986_/D _3986_/RESET_B VPWR VGND sg13cmos5l_dfrbpq_1
X_2937_ _2949_/A _2934_/A _2948_/B _2936_/Y VPWR VGND sg13cmos5l_a21o_1
XFILLER_30_190 VPWR VGND sg13cmos5l_decap_8
X_2868_ _2872_/A _2868_/A _2868_/B VPWR VGND sg13cmos5l_or2_1
X_2799_ _2808_/A _2806_/B _2798_/Y _2795_/Y VPWR VGND sg13cmos5l_o21ai_1
XFILLER_2_529 VPWR VGND sg13cmos5l_decap_8
Xhold1020 _2987_/A _4214_/Q VPWR VGND sg13cmos5l_dlygate4sd3_1
XFILLER_45_227 VPWR VGND sg13cmos5l_fill_1
XFILLER_42_912 VPWR VGND sg13cmos5l_decap_8
XFILLER_26_43 VPWR VGND sg13cmos5l_fill_2
XFILLER_26_463 VPWR VGND sg13cmos5l_decap_8
XFILLER_26_474 VPWR VGND sg13cmos5l_fill_1
XFILLER_13_102 VPWR VGND sg13cmos5l_fill_1
XFILLER_13_113 VPWR VGND sg13cmos5l_decap_4
XFILLER_42_989 VPWR VGND sg13cmos5l_decap_8
XFILLER_13_135 VPWR VGND sg13cmos5l_fill_1
XFILLER_9_128 VPWR VGND sg13cmos5l_decap_8
XFILLER_10_831 VPWR VGND sg13cmos5l_decap_8
XFILLER_5_334 VPWR VGND sg13cmos5l_decap_8
XFILLER_3_47 VPWR VGND sg13cmos5l_fill_2
XFILLER_49_566 VPWR VGND sg13cmos5l_decap_8
XFILLER_37_739 VPWR VGND sg13cmos5l_fill_1
XFILLER_37_728 VPWR VGND sg13cmos5l_decap_8
XFILLER_17_430 VPWR VGND sg13cmos5l_fill_2
XFILLER_44_271 VPWR VGND sg13cmos5l_fill_2
XFILLER_32_400 VPWR VGND sg13cmos5l_decap_4
XFILLER_33_956 VPWR VGND sg13cmos5l_decap_4
X_3840_ _3840_/Y _3729_/B _3835_/X _3858_/B _3859_/A VPWR VGND sg13cmos5l_a22oi_1
X_3771_ _3772_/B _3759_/B _2216_/Y _3771_/S VPWR VGND sg13cmos5l_mux2_1
XFILLER_13_680 VPWR VGND sg13cmos5l_fill_1
X_2722_ _2724_/C _2722_/A _2722_/B VPWR VGND sg13cmos5l_xnor2_1
X_2653_ _2653_/Y _2659_/A _2652_/X _2651_/Y VPWR VGND sg13cmos5l_a21oi_1
X_2584_ _2584_/X _4028_/Q _4011_/Q _2680_/A VPWR VGND sg13cmos5l_mux2_1
XFILLER_5_890 VPWR VGND sg13cmos5l_decap_4
X_4323_ _4323_/Q _4323_/CLK _4323_/D _4323_/RESET_B VPWR VGND sg13cmos5l_dfrbpq_1
Xfanout118 _2449_/A _2501_/A VPWR VGND sg13cmos5l_buf_1
Xfanout107 _3965_/A0 input7/X VPWR VGND sg13cmos5l_buf_1
Xfanout129 _2913_/A fanout132/X VPWR VGND sg13cmos5l_buf_1
X_4254_ _4254_/Q _4302_/CLK _4254_/D _4254_/RESET_B VPWR VGND sg13cmos5l_dfrbpq_1
X_4185_ _4185_/Q _4209_/CLK _4185_/D _4185_/RESET_B VPWR VGND sg13cmos5l_dfrbpq_1
XFILLER_41_1004 VPWR VGND sg13cmos5l_decap_8
X_3205_ _3207_/A _3205_/A _3205_/B VPWR VGND sg13cmos5l_nor2_1
X_3136_ _3371_/A _4269_/Q _4270_/Q VPWR VGND sg13cmos5l_xnor2_1
XFILLER_27_205 VPWR VGND sg13cmos5l_fill_1
XFILLER_43_709 VPWR VGND sg13cmos5l_decap_8
X_3067_ _3067_/Y _4226_/Q _3781_/A2 _3607_/A VPWR VGND sg13cmos5l_o21ai_1
X_4131__236 _4131_/RESET_B VPWR VGND sg13cmos5l_tiehi
XFILLER_24_934 VPWR VGND sg13cmos5l_decap_8
XFILLER_35_271 VPWR VGND sg13cmos5l_fill_1
XFILLER_10_116 VPWR VGND sg13cmos5l_decap_8
XFILLER_11_617 VPWR VGND sg13cmos5l_fill_2
X_3969_ _4014_/D _3958_/A hold746/X _3971_/S VPWR VGND sg13cmos5l_mux2_1
XFILLER_12_45 VPWR VGND sg13cmos5l_fill_1
XFILLER_2_337 VPWR VGND sg13cmos5l_fill_2
XFILLER_46_503 VPWR VGND sg13cmos5l_fill_1
XFILLER_42_720 VPWR VGND sg13cmos5l_fill_2
XFILLER_14_422 VPWR VGND sg13cmos5l_fill_2
XFILLER_15_923 VPWR VGND sg13cmos5l_decap_8
XFILLER_15_989 VPWR VGND sg13cmos5l_decap_8
XFILLER_18_1028 VPWR VGND sg13cmos5l_fill_1
XFILLER_30_904 VPWR VGND sg13cmos5l_fill_2
XFILLER_30_915 VPWR VGND sg13cmos5l_fill_2
XFILLER_14_488 VPWR VGND sg13cmos5l_fill_1
XFILLER_6_610 VPWR VGND sg13cmos5l_decap_8
X_4264__467 _4264_/RESET_B VPWR VGND sg13cmos5l_tiehi
XFILLER_6_643 VPWR VGND sg13cmos5l_decap_8
XFILLER_37_547 VPWR VGND sg13cmos5l_decap_4
XFILLER_37_536 VPWR VGND sg13cmos5l_decap_4
XFILLER_32_230 VPWR VGND sg13cmos5l_decap_4
XFILLER_33_753 VPWR VGND sg13cmos5l_decap_8
X_3823_ _3834_/B _3815_/X _3816_/Y _3822_/Y VPWR VGND sg13cmos5l_a21oi_1
XFILLER_21_937 VPWR VGND sg13cmos5l_decap_8
XFILLER_20_425 VPWR VGND sg13cmos5l_decap_8
X_3754_ _3754_/Y _3754_/A VPWR VGND sg13cmos5l_inv_1
X_2705_ _2705_/Y _2703_/Y _2704_/Y _2607_/Y VPWR VGND sg13cmos5l_o21ai_1
X_3685_ _3685_/Y _3684_/A _3775_/A VPWR VGND sg13cmos5l_nand2b_1
X_2636_ _2636_/Y _2634_/Y _2635_/Y _2607_/Y VPWR VGND sg13cmos5l_o21ai_1
X_2567_ _4142_/D _2567_/A _2725_/A VPWR VGND sg13cmos5l_nor2_1
X_4306_ _4306_/Q _4333_/CLK _4306_/D _4306_/RESET_B VPWR VGND sg13cmos5l_dfrbpq_1
X_2498_ _2498_/Y _2500_/B _2500_/C _2500_/A VPWR VGND sg13cmos5l_a21oi_1
X_4237_ _4237_/Q _4238_/CLK _4237_/D _4237_/RESET_B VPWR VGND sg13cmos5l_dfrbpq_1
X_4168_ _4168_/Q _4234_/CLK _4168_/D _4168_/RESET_B VPWR VGND sg13cmos5l_dfrbpq_1
XFILLER_28_547 VPWR VGND sg13cmos5l_decap_8
X_4099_ _4099_/Q clkload9/A _4099_/D _4099_/RESET_B VPWR VGND sg13cmos5l_dfrbpq_1
X_3119_ _3122_/S _3002_/Y _3095_/Y _3118_/Y VPWR VGND sg13cmos5l_o21ai_1
XFILLER_12_904 VPWR VGND sg13cmos5l_fill_2
XFILLER_11_403 VPWR VGND sg13cmos5l_decap_8
XFILLER_23_285 VPWR VGND sg13cmos5l_decap_8
XFILLER_11_458 VPWR VGND sg13cmos5l_decap_8
XFILLER_23_88 VPWR VGND sg13cmos5l_decap_4
XFILLER_3_602 VPWR VGND sg13cmos5l_decap_8
XFILLER_24_1010 VPWR VGND sg13cmos5l_decap_8
XFILLER_48_63 VPWR VGND sg13cmos5l_decap_8
XFILLER_47_856 VPWR VGND sg13cmos5l_decap_8
XFILLER_19_569 VPWR VGND sg13cmos5l_fill_1
XFILLER_46_377 VPWR VGND sg13cmos5l_decap_4
X_4368__211 _4368_/RESET_B VPWR VGND sg13cmos5l_tiehi
XFILLER_15_764 VPWR VGND sg13cmos5l_decap_4
XFILLER_42_561 VPWR VGND sg13cmos5l_decap_4
XFILLER_14_252 VPWR VGND sg13cmos5l_decap_8
XFILLER_14_263 VPWR VGND sg13cmos5l_fill_2
XFILLER_15_775 VPWR VGND sg13cmos5l_fill_1
XFILLER_9_68 VPWR VGND sg13cmos5l_decap_8
XFILLER_14_296 VPWR VGND sg13cmos5l_decap_8
XFILLER_11_970 VPWR VGND sg13cmos5l_decap_8
XFILLER_30_767 VPWR VGND sg13cmos5l_fill_2
XFILLER_10_480 VPWR VGND sg13cmos5l_fill_1
Xhold919 _4215_/D _3025_/Y VPWR VGND sg13cmos5l_dlygate4sd3_1
XFILLER_7_963 VPWR VGND sg13cmos5l_decap_8
XFILLER_6_451 VPWR VGND sg13cmos5l_fill_2
Xhold908 _4251_/D _3238_/Y VPWR VGND sg13cmos5l_dlygate4sd3_1
X_3470_ _3471_/B _4295_/Q _3477_/B _3455_/Y VPWR VGND sg13cmos5l_a21oi_1
XFILLER_43_4 VPWR VGND sg13cmos5l_decap_8
X_2421_ _2431_/B _4129_/Q _2500_/B _4127_/Q VPWR VGND sg13cmos5l_nor3_1
X_2352_ _4035_/D _3951_/A0 hold738/X _2359_/S VPWR VGND sg13cmos5l_mux2_1
X_2283_ _3064_/A _4224_/Q VPWR VGND sg13cmos5l_inv_1
X_4022_ _4022_/Q _4225_/CLK _4022_/D _4022_/RESET_B VPWR VGND sg13cmos5l_dfrbpq_1
XFILLER_49_182 VPWR VGND sg13cmos5l_decap_8
XFILLER_25_517 VPWR VGND sg13cmos5l_fill_2
XFILLER_25_539 VPWR VGND sg13cmos5l_fill_1
XFILLER_20_233 VPWR VGND sg13cmos5l_fill_1
X_3806_ _3877_/A _3858_/A _3806_/B VPWR VGND sg13cmos5l_nand2b_1
X_3737_ _3737_/Y _4317_/Q _3752_/A _2246_/Y _4316_/Q _3736_/Y VPWR VGND sg13cmos5l_a221oi_1
X_3668_ _3669_/B _3668_/A _3668_/B VPWR VGND sg13cmos5l_xnor2_1
XFILLER_47_1010 VPWR VGND sg13cmos5l_decap_8
X_3599_ _3599_/Y _3745_/A _3599_/B VPWR VGND sg13cmos5l_nand2b_1
X_2619_ _2619_/Y _2632_/S _2264_/Y _2657_/A1 VPWR VGND sg13cmos5l_o21ai_1
XFILLER_0_638 VPWR VGND sg13cmos5l_decap_8
XFILLER_0_649 VPWR VGND sg13cmos5l_decap_8
XFILLER_18_11 VPWR VGND sg13cmos5l_fill_2
XFILLER_44_848 VPWR VGND sg13cmos5l_decap_8
XFILLER_43_358 VPWR VGND sg13cmos5l_fill_1
XFILLER_34_21 VPWR VGND sg13cmos5l_decap_8
XFILLER_34_32 VPWR VGND sg13cmos5l_fill_2
XFILLER_8_727 VPWR VGND sg13cmos5l_decap_8
XFILLER_4_900 VPWR VGND sg13cmos5l_decap_8
XFILLER_4_977 VPWR VGND sg13cmos5l_decap_8
XFILLER_3_454 VPWR VGND sg13cmos5l_decap_8
XFILLER_3_487 VPWR VGND sg13cmos5l_decap_8
XFILLER_1_0 VPWR VGND sg13cmos5l_decap_8
XFILLER_47_631 VPWR VGND sg13cmos5l_decap_8
XFILLER_19_322 VPWR VGND sg13cmos5l_decap_8
XFILLER_46_152 VPWR VGND sg13cmos5l_decap_8
XFILLER_34_325 VPWR VGND sg13cmos5l_decap_8
XFILLER_43_870 VPWR VGND sg13cmos5l_decap_8
X_2970_ _2977_/A _4212_/Q _4210_/Q _4211_/Q VPWR VGND sg13cmos5l_or3_1
XFILLER_30_597 VPWR VGND sg13cmos5l_fill_2
Xhold705 hold705/X _3978_/Q VPWR VGND sg13cmos5l_dlygate4sd3_1
Xhold716 hold716/X _4009_/Q VPWR VGND sg13cmos5l_dlygate4sd3_1
X_3522_ _3522_/Y _3822_/B _3539_/B VPWR VGND sg13cmos5l_nand2b_1
Xhold727 hold727/X _3981_/Q VPWR VGND sg13cmos5l_dlygate4sd3_1
X_3453_ _3454_/B _3483_/B _3483_/C _3350_/B VPWR VGND sg13cmos5l_a21o_1
Xhold749 hold749/X _4019_/Q VPWR VGND sg13cmos5l_dlygate4sd3_1
Xhold738 hold738/X _4035_/Q VPWR VGND sg13cmos5l_dlygate4sd3_1
X_2404_ _4078_/D _3951_/A0 hold670/X _2410_/S VPWR VGND sg13cmos5l_mux2_1
X_3384_ _3384_/Y _3367_/X _3368_/Y _3381_/Y _3168_/A _3384_/C1 VPWR VGND sg13cmos5l_a221oi_1
XFILLER_34_0 VPWR VGND sg13cmos5l_decap_8
X_2335_ _4024_/D _3971_/A0 hold686/X _2336_/B VPWR VGND sg13cmos5l_mux2_1
X_2266_ _2266_/Y _2266_/A VPWR VGND sg13cmos5l_inv_1
X_4005_ _4005_/Q clkload4/A _4005_/D _4005_/RESET_B VPWR VGND sg13cmos5l_dfrbpq_1
XFILLER_38_697 VPWR VGND sg13cmos5l_fill_1
XFILLER_1_80 VPWR VGND sg13cmos5l_fill_2
XFILLER_37_196 VPWR VGND sg13cmos5l_decap_8
XFILLER_37_185 VPWR VGND sg13cmos5l_decap_8
XFILLER_21_564 VPWR VGND sg13cmos5l_fill_2
XFILLER_21_575 VPWR VGND sg13cmos5l_decap_8
XFILLER_0_413 VPWR VGND sg13cmos5l_decap_4
XFILLER_1_936 VPWR VGND sg13cmos5l_decap_8
X_4358__243 _4358_/RESET_B VPWR VGND sg13cmos5l_tiehi
XFILLER_0_446 VPWR VGND sg13cmos5l_decap_8
XFILLER_49_918 VPWR VGND sg13cmos5l_decap_8
XFILLER_17_804 VPWR VGND sg13cmos5l_decap_4
XFILLER_29_653 VPWR VGND sg13cmos5l_fill_2
XFILLER_17_815 VPWR VGND sg13cmos5l_decap_8
XFILLER_17_848 VPWR VGND sg13cmos5l_decap_8
XFILLER_45_86 VPWR VGND sg13cmos5l_decap_4
XFILLER_25_870 VPWR VGND sg13cmos5l_decap_4
XFILLER_31_328 VPWR VGND sg13cmos5l_fill_1
XFILLER_40_895 VPWR VGND sg13cmos5l_fill_1
XFILLER_8_524 VPWR VGND sg13cmos5l_fill_2
XFILLER_6_47 VPWR VGND sg13cmos5l_decap_4
XFILLER_6_69 VPWR VGND sg13cmos5l_decap_8
XFILLER_4_730 VPWR VGND sg13cmos5l_fill_1
XFILLER_3_295 VPWR VGND sg13cmos5l_decap_8
XFILLER_39_417 VPWR VGND sg13cmos5l_decap_4
XFILLER_6_1007 VPWR VGND sg13cmos5l_decap_8
XFILLER_39_428 VPWR VGND sg13cmos5l_decap_8
XFILLER_0_991 VPWR VGND sg13cmos5l_decap_8
XFILLER_47_483 VPWR VGND sg13cmos5l_decap_8
XFILLER_35_623 VPWR VGND sg13cmos5l_decap_8
XFILLER_34_122 VPWR VGND sg13cmos5l_decap_8
XFILLER_23_829 VPWR VGND sg13cmos5l_fill_1
X_2953_ _2953_/Y _2953_/A _2953_/B VPWR VGND sg13cmos5l_nor2_1
XFILLER_31_862 VPWR VGND sg13cmos5l_decap_4
X_2884_ _2884_/Y _3079_/A _4168_/Q _2272_/Y _4208_/Q VPWR VGND sg13cmos5l_a22oi_1
X_3505_ _3505_/Y _4370_/D _3775_/B VPWR VGND sg13cmos5l_nor2_1
XFILLER_44_1002 VPWR VGND sg13cmos5l_decap_8
X_3436_ _3436_/Y _4291_/Q _3779_/A2 _3255_/A VPWR VGND sg13cmos5l_o21ai_1
X_3367_ _3367_/X _4250_/Q _3369_/B VPWR VGND sg13cmos5l_or2_1
X_2318_ _2318_/Y _3907_/A _2522_/C VPWR VGND sg13cmos5l_nand2_1
Xheichips26_dna_sequencer_140 uio_out[0] VPWR VGND sg13cmos5l_tielo
X_3298_ _3298_/Y _3298_/A _3298_/B _3298_/C VPWR VGND sg13cmos5l_nor3_1
XFILLER_39_984 VPWR VGND sg13cmos5l_decap_8
X_2249_ _3621_/A _2249_/A VPWR VGND sg13cmos5l_inv_1
XFILLER_5_538 VPWR VGND sg13cmos5l_decap_8
XFILLER_31_66 VPWR VGND sg13cmos5l_fill_1
XFILLER_0_221 VPWR VGND sg13cmos5l_decap_8
XFILLER_45_910 VPWR VGND sg13cmos5l_decap_8
XFILLER_29_450 VPWR VGND sg13cmos5l_fill_2
XFILLER_44_420 VPWR VGND sg13cmos5l_decap_4
XFILLER_45_987 VPWR VGND sg13cmos5l_decap_8
XFILLER_31_136 VPWR VGND sg13cmos5l_decap_8
XFILLER_13_895 VPWR VGND sg13cmos5l_decap_4
XFILLER_9_866 VPWR VGND sg13cmos5l_decap_8
XFILLER_12_383 VPWR VGND sg13cmos5l_decap_8
XFILLER_8_387 VPWR VGND sg13cmos5l_decap_4
XFILLER_4_560 VPWR VGND sg13cmos5l_fill_1
X_4270_ _4270_/Q _4302_/CLK _4270_/D _4270_/RESET_B VPWR VGND sg13cmos5l_dfrbpq_1
X_3221_ _3221_/Y _4222_/Q _3221_/B VPWR VGND sg13cmos5l_nand2_1
X_3152_ _3156_/A _3148_/Y _3151_/X _3150_/Y VPWR VGND sg13cmos5l_a21oi_1
XFILLER_39_236 VPWR VGND sg13cmos5l_decap_8
X_3083_ _3092_/B _3081_/Y _3082_/Y _3080_/Y VPWR VGND sg13cmos5l_a21oi_1
XFILLER_47_291 VPWR VGND sg13cmos5l_decap_4
XFILLER_36_954 VPWR VGND sg13cmos5l_decap_8
XFILLER_35_431 VPWR VGND sg13cmos5l_decap_8
X_4092__292 _4092_/RESET_B VPWR VGND sg13cmos5l_tiehi
XFILLER_22_114 VPWR VGND sg13cmos5l_decap_8
X_3985_ _3985_/Q clkload3/A _3985_/D _3985_/RESET_B VPWR VGND sg13cmos5l_dfrbpq_1
X_2936_ _2936_/Y _2942_/A _2935_/Y VPWR VGND sg13cmos5l_nor2b_1
XFILLER_10_309 VPWR VGND sg13cmos5l_decap_8
X_2867_ _2868_/B _2860_/X _2864_/Y _2874_/A _2869_/A _2866_/X VPWR VGND sg13cmos5l_a221oi_1
XFILLER_11_1012 VPWR VGND sg13cmos5l_decap_8
X_2798_ _2798_/Y _2802_/A _2802_/B VPWR VGND sg13cmos5l_nand2_1
X_3419_ _3421_/B _3414_/Y _3415_/Y _3418_/Y VPWR VGND sg13cmos5l_o21ai_1
Xhold1010 _2831_/A _4184_/Q VPWR VGND sg13cmos5l_dlygate4sd3_1
Xhold1021 hold1021/X _4372_/Q VPWR VGND sg13cmos5l_dlygate4sd3_1
XFILLER_18_409 VPWR VGND sg13cmos5l_decap_8
XFILLER_27_921 VPWR VGND sg13cmos5l_decap_8
XFILLER_38_280 VPWR VGND sg13cmos5l_decap_8
XFILLER_27_943 VPWR VGND sg13cmos5l_fill_2
XFILLER_27_987 VPWR VGND sg13cmos5l_decap_8
XFILLER_42_968 VPWR VGND sg13cmos5l_decap_8
XFILLER_41_434 VPWR VGND sg13cmos5l_fill_1
XFILLER_9_107 VPWR VGND sg13cmos5l_decap_8
XFILLER_42_32 VPWR VGND sg13cmos5l_decap_8
XFILLER_41_478 VPWR VGND sg13cmos5l_fill_1
XFILLER_10_810 VPWR VGND sg13cmos5l_decap_8
XFILLER_6_803 VPWR VGND sg13cmos5l_decap_8
XFILLER_49_545 VPWR VGND sg13cmos5l_decap_8
XFILLER_18_921 VPWR VGND sg13cmos5l_fill_1
XFILLER_45_751 VPWR VGND sg13cmos5l_decap_8
XFILLER_17_453 VPWR VGND sg13cmos5l_decap_8
XFILLER_45_784 VPWR VGND sg13cmos5l_decap_8
XFILLER_17_475 VPWR VGND sg13cmos5l_fill_2
XFILLER_32_445 VPWR VGND sg13cmos5l_decap_8
XFILLER_32_456 VPWR VGND sg13cmos5l_fill_1
X_3770_ _4345_/D _2217_/Y hold824/X _3769_/Y VPWR VGND sg13cmos5l_a21oi_1
XFILLER_41_990 VPWR VGND sg13cmos5l_decap_8
XFILLER_13_692 VPWR VGND sg13cmos5l_decap_4
X_2721_ _4152_/D _2721_/A _2722_/B VPWR VGND sg13cmos5l_nor2b_1
X_4280__451 _4280_/RESET_B VPWR VGND sg13cmos5l_tiehi
X_2652_ _2652_/X _4103_/Q _4086_/Q _4069_/Q _4052_/Q _2665_/A _2658_/S1 VPWR VGND
+ sg13cmos5l_mux4_1
X_2583_ _2583_/Y _2709_/A _2582_/X _2581_/Y VPWR VGND sg13cmos5l_a21oi_1
X_4322_ _4322_/Q _4323_/CLK _4322_/D _4322_/RESET_B VPWR VGND sg13cmos5l_dfrbpq_1
Xfanout119 _2509_/B1 _2501_/A VPWR VGND sg13cmos5l_buf_1
X_4253_ _4253_/Q _4302_/CLK _4253_/D _4253_/RESET_B VPWR VGND sg13cmos5l_dfrbpq_1
Xfanout108 _3950_/A0 input6/X VPWR VGND sg13cmos5l_buf_1
X_3204_ _4247_/D _3258_/B _3204_/B VPWR VGND sg13cmos5l_nor2_1
X_4184_ _4184_/Q _4209_/CLK _4184_/D _4184_/RESET_B VPWR VGND sg13cmos5l_dfrbpq_1
X_3135_ _3135_/X _3144_/B _3135_/B VPWR VGND sg13cmos5l_and2_1
X_3066_ _4225_/D _3066_/A _3066_/B VPWR VGND sg13cmos5l_and2_1
XFILLER_36_740 VPWR VGND sg13cmos5l_fill_1
XFILLER_23_423 VPWR VGND sg13cmos5l_fill_2
X_3968_ _4013_/D _3956_/A hold782/X _3971_/S VPWR VGND sg13cmos5l_mux2_1
X_2919_ _2919_/Y _2941_/A _2941_/B VPWR VGND sg13cmos5l_nor2b_1
XFILLER_12_24 VPWR VGND sg13cmos5l_decap_8
X_3899_ _3899_/Y _2289_/B _3911_/B _3909_/A VPWR VGND sg13cmos5l_o21ai_1
XFILLER_37_98 VPWR VGND sg13cmos5l_fill_1
XFILLER_15_968 VPWR VGND sg13cmos5l_decap_8
XFILLER_15_979 VPWR VGND sg13cmos5l_fill_2
XFILLER_26_283 VPWR VGND sg13cmos5l_decap_8
XFILLER_41_286 VPWR VGND sg13cmos5l_decap_8
XFILLER_23_990 VPWR VGND sg13cmos5l_decap_8
XFILLER_5_143 VPWR VGND sg13cmos5l_fill_2
XFILLER_2_883 VPWR VGND sg13cmos5l_decap_8
X_4171__584 _4171_/RESET_B VPWR VGND sg13cmos5l_tiehi
XFILLER_21_905 VPWR VGND sg13cmos5l_decap_8
X_3822_ _3822_/Y _3822_/A _3822_/B _3839_/B _3822_/D VPWR VGND sg13cmos5l_nor4_1
XFILLER_20_404 VPWR VGND sg13cmos5l_fill_1
XFILLER_20_448 VPWR VGND sg13cmos5l_decap_8
XFILLER_32_286 VPWR VGND sg13cmos5l_decap_8
X_3753_ _3754_/A _3602_/Y _3752_/Y _3757_/B VPWR VGND sg13cmos5l_mux2_1
X_2704_ _2704_/Y _2704_/A1 _2701_/X _2675_/A VPWR VGND sg13cmos5l_o21ai_1
X_3684_ _3783_/B _3684_/A _4370_/D VPWR VGND sg13cmos5l_nor2_1
X_2635_ _2635_/Y _2669_/B1 _2632_/X _2300_/A VPWR VGND sg13cmos5l_o21ai_1
X_2566_ _2566_/Y _2566_/A _2566_/B _2566_/C VPWR VGND sg13cmos5l_nor3_1
X_4305_ _4305_/Q _4333_/CLK _4305_/D _4305_/RESET_B VPWR VGND sg13cmos5l_dfrbpq_1
XFILLER_0_809 VPWR VGND sg13cmos5l_decap_8
X_2497_ _4128_/D _2500_/B _2500_/C _2496_/Y VPWR VGND sg13cmos5l_a21oi_1
X_4236_ _4236_/Q _4262_/CLK _4236_/D _4236_/RESET_B VPWR VGND sg13cmos5l_dfrbpq_1
X_4167_ _4167_/Q _4209_/CLK _4167_/D _4167_/RESET_B VPWR VGND sg13cmos5l_dfrbpq_1
X_3118_ _3118_/Y _3110_/Y _3116_/Y _3117_/Y VPWR VGND sg13cmos5l_o21ai_1
X_4098_ _4098_/Q clkload8/A _4098_/D _4098_/RESET_B VPWR VGND sg13cmos5l_dfrbpq_1
X_3049_ _3059_/A _3047_/C _3048_/Y _3047_/Y VPWR VGND sg13cmos5l_a21oi_1
XFILLER_24_765 VPWR VGND sg13cmos5l_decap_8
XFILLER_24_787 VPWR VGND sg13cmos5l_decap_8
XFILLER_24_798 VPWR VGND sg13cmos5l_fill_2
XFILLER_20_960 VPWR VGND sg13cmos5l_fill_1
XFILLER_3_4 VPWR VGND sg13cmos5l_fill_1
XFILLER_2_146 VPWR VGND sg13cmos5l_decap_8
XFILLER_2_157 VPWR VGND sg13cmos5l_fill_1
XFILLER_48_42 VPWR VGND sg13cmos5l_decap_8
XFILLER_47_835 VPWR VGND sg13cmos5l_decap_8
XFILLER_0_49 VPWR VGND sg13cmos5l_decap_8
X_4270__461 _4270_/RESET_B VPWR VGND sg13cmos5l_tiehi
XFILLER_42_540 VPWR VGND sg13cmos5l_decap_8
XFILLER_9_36 VPWR VGND sg13cmos5l_fill_2
XFILLER_15_787 VPWR VGND sg13cmos5l_decap_8
XFILLER_9_47 VPWR VGND sg13cmos5l_fill_2
Xfanout90 _2654_/S _2632_/S VPWR VGND sg13cmos5l_buf_1
XFILLER_7_942 VPWR VGND sg13cmos5l_decap_8
Xhold909 _2776_/B _4167_/Q VPWR VGND sg13cmos5l_dlygate4sd3_1
X_2420_ _4093_/D input5/X hold737/X _2420_/S VPWR VGND sg13cmos5l_mux2_1
X_2351_ _4034_/D _3950_/A0 hold733/X _2359_/S VPWR VGND sg13cmos5l_mux2_1
X_2282_ _2282_/Y _4253_/Q VPWR VGND sg13cmos5l_inv_1
X_4021_ _4021_/Q _4378_/CLK _4021_/D _4021_/RESET_B VPWR VGND sg13cmos5l_dfrbpq_1
XFILLER_49_161 VPWR VGND sg13cmos5l_decap_8
XFILLER_38_824 VPWR VGND sg13cmos5l_decap_8
XFILLER_37_334 VPWR VGND sg13cmos5l_decap_8
XFILLER_37_378 VPWR VGND sg13cmos5l_decap_8
XFILLER_33_573 VPWR VGND sg13cmos5l_decap_8
XFILLER_33_584 VPWR VGND sg13cmos5l_fill_1
X_3805_ _3805_/Y _3806_/B VPWR VGND sg13cmos5l_inv_1
X_3736_ _3736_/Y _3745_/B _4358_/Q _3748_/B _2221_/Y VPWR VGND sg13cmos5l_a22oi_1
XFILLER_9_290 VPWR VGND sg13cmos5l_decap_8
X_3667_ _3668_/B _3667_/A _3667_/B VPWR VGND sg13cmos5l_xor2_1
X_3598_ _3598_/Y _3590_/Y _3600_/S _3597_/Y VPWR VGND sg13cmos5l_a21oi_1
X_2618_ _2618_/X _4036_/Q _4019_/Q _2647_/A VPWR VGND sg13cmos5l_mux2_1
XFILLER_0_617 VPWR VGND sg13cmos5l_decap_8
X_2549_ _4139_/D _2549_/A _2550_/A _2549_/C VPWR VGND sg13cmos5l_nor3_1
XFILLER_29_813 VPWR VGND sg13cmos5l_fill_1
X_4219_ _4219_/Q _4272_/CLK _4219_/D _4219_/RESET_B VPWR VGND sg13cmos5l_dfrbpq_1
XFILLER_29_879 VPWR VGND sg13cmos5l_fill_2
XFILLER_44_827 VPWR VGND sg13cmos5l_decap_8
XFILLER_8_706 VPWR VGND sg13cmos5l_decap_8
XFILLER_11_234 VPWR VGND sg13cmos5l_decap_8
XFILLER_12_768 VPWR VGND sg13cmos5l_fill_2
X_4144__214 _4144_/RESET_B VPWR VGND sg13cmos5l_tiehi
XFILLER_4_956 VPWR VGND sg13cmos5l_decap_8
XFILLER_35_805 VPWR VGND sg13cmos5l_decap_4
XFILLER_19_378 VPWR VGND sg13cmos5l_decap_4
XFILLER_34_315 VPWR VGND sg13cmos5l_decap_4
XFILLER_34_337 VPWR VGND sg13cmos5l_decap_4
XFILLER_15_540 VPWR VGND sg13cmos5l_fill_1
XFILLER_42_381 VPWR VGND sg13cmos5l_decap_8
X_3521_ _3539_/B _4334_/Q _4333_/Q _4335_/Q VPWR VGND sg13cmos5l_o21ai_1
Xhold728 hold728/X _4032_/Q VPWR VGND sg13cmos5l_dlygate4sd3_1
Xhold717 hold717/X _4051_/Q VPWR VGND sg13cmos5l_dlygate4sd3_1
Xhold706 hold706/X _4020_/Q VPWR VGND sg13cmos5l_dlygate4sd3_1
X_3452_ _3454_/A _3452_/A _3483_/B _3483_/C VPWR VGND sg13cmos5l_nand3_1
Xhold739 hold739/X _4041_/Q VPWR VGND sg13cmos5l_dlygate4sd3_1
X_2403_ _4077_/D _3964_/A0 hold797/X _2410_/S VPWR VGND sg13cmos5l_mux2_1
X_3383_ _3388_/B _3376_/X _3379_/Y _3382_/Y VPWR VGND sg13cmos5l_o21ai_1
X_2334_ _4023_/D _3946_/A hold767/X _2334_/S VPWR VGND sg13cmos5l_mux2_1
XFILLER_27_0 VPWR VGND sg13cmos5l_decap_8
X_2265_ _2265_/Y _2265_/A VPWR VGND sg13cmos5l_inv_1
XFILLER_26_805 VPWR VGND sg13cmos5l_decap_8
X_4004_ _4004_/Q _4378_/CLK _4004_/D _4004_/RESET_B VPWR VGND sg13cmos5l_dfrbpq_1
XFILLER_25_359 VPWR VGND sg13cmos5l_decap_8
XFILLER_33_370 VPWR VGND sg13cmos5l_decap_8
XFILLER_34_882 VPWR VGND sg13cmos5l_fill_1
X_3719_ _3719_/X _4337_/Q _3718_/Y _3731_/S VPWR VGND sg13cmos5l_mux2_1
X_4260__471 _4260_/RESET_B VPWR VGND sg13cmos5l_tiehi
XFILLER_1_915 VPWR VGND sg13cmos5l_decap_8
XFILLER_29_11 VPWR VGND sg13cmos5l_decap_8
XFILLER_29_55 VPWR VGND sg13cmos5l_decap_8
XFILLER_28_120 VPWR VGND sg13cmos5l_fill_1
XFILLER_28_131 VPWR VGND sg13cmos5l_decap_4
XFILLER_29_665 VPWR VGND sg13cmos5l_fill_1
XFILLER_45_21 VPWR VGND sg13cmos5l_fill_2
XFILLER_44_602 VPWR VGND sg13cmos5l_decap_4
XFILLER_16_315 VPWR VGND sg13cmos5l_decap_8
XFILLER_45_32 VPWR VGND sg13cmos5l_decap_8
XFILLER_44_646 VPWR VGND sg13cmos5l_decap_4
XFILLER_43_123 VPWR VGND sg13cmos5l_decap_8
XFILLER_31_307 VPWR VGND sg13cmos5l_decap_8
XFILLER_43_189 VPWR VGND sg13cmos5l_decap_8
XFILLER_8_536 VPWR VGND sg13cmos5l_fill_2
XFILLER_3_263 VPWR VGND sg13cmos5l_fill_1
XFILLER_0_970 VPWR VGND sg13cmos5l_decap_8
XFILLER_48_985 VPWR VGND sg13cmos5l_decap_8
XFILLER_47_462 VPWR VGND sg13cmos5l_decap_8
XFILLER_19_175 VPWR VGND sg13cmos5l_fill_1
XFILLER_37_1010 VPWR VGND sg13cmos5l_decap_8
XFILLER_16_860 VPWR VGND sg13cmos5l_decap_8
XFILLER_23_808 VPWR VGND sg13cmos5l_fill_1
XFILLER_34_167 VPWR VGND sg13cmos5l_decap_8
X_2952_ _2953_/B _2940_/Y _2941_/X _2947_/Y _2950_/Y _2951_/Y VPWR VGND sg13cmos5l_a221oi_1
X_4309__419 _4309_/RESET_B VPWR VGND sg13cmos5l_tiehi
XFILLER_30_340 VPWR VGND sg13cmos5l_decap_8
X_2883_ _2883_/Y _2851_/A _2890_/B _2881_/Y VPWR VGND sg13cmos5l_o21ai_1
X_3504_ _4303_/D _3493_/A _3500_/A _3503_/Y VPWR VGND sg13cmos5l_a21oi_1
X_3435_ _3435_/Y _2224_/Y _3779_/A2 _3434_/Y VPWR VGND sg13cmos5l_a21oi_1
X_3366_ _3369_/B _4248_/Q _4249_/Q _4247_/Q _4246_/Q VPWR VGND sg13cmos5l_nor4_1
X_2317_ _4377_/D _4375_/D _4372_/D VPWR VGND sg13cmos5l_or2_1
X_3297_ _3298_/C _3308_/A _3297_/B VPWR VGND sg13cmos5l_nor2_1
XFILLER_39_963 VPWR VGND sg13cmos5l_decap_8
Xheichips26_dna_sequencer_141 uio_out[1] VPWR VGND sg13cmos5l_tielo
X_2248_ _3619_/A _2248_/A VPWR VGND sg13cmos5l_inv_1
XFILLER_38_473 VPWR VGND sg13cmos5l_decap_4
XFILLER_38_462 VPWR VGND sg13cmos5l_fill_2
XFILLER_26_613 VPWR VGND sg13cmos5l_fill_1
XFILLER_41_616 VPWR VGND sg13cmos5l_fill_1
XFILLER_14_819 VPWR VGND sg13cmos5l_decap_8
XFILLER_40_126 VPWR VGND sg13cmos5l_fill_2
XFILLER_15_46 VPWR VGND sg13cmos5l_decap_4
XFILLER_15_79 VPWR VGND sg13cmos5l_fill_2
XFILLER_22_852 VPWR VGND sg13cmos5l_decap_4
X_4141__217 _4141_/RESET_B VPWR VGND sg13cmos5l_tiehi
XFILLER_0_200 VPWR VGND sg13cmos5l_decap_8
XFILLER_0_266 VPWR VGND sg13cmos5l_decap_8
XFILLER_44_410 VPWR VGND sg13cmos5l_fill_1
XFILLER_45_966 VPWR VGND sg13cmos5l_decap_8
XFILLER_9_845 VPWR VGND sg13cmos5l_decap_8
XFILLER_12_340 VPWR VGND sg13cmos5l_fill_1
XFILLER_13_874 VPWR VGND sg13cmos5l_fill_2
XFILLER_8_344 VPWR VGND sg13cmos5l_decap_8
XFILLER_12_373 VPWR VGND sg13cmos5l_decap_8
XFILLER_4_594 VPWR VGND sg13cmos5l_fill_2
XFILLER_4_583 VPWR VGND sg13cmos5l_decap_8
XFILLER_28_1009 VPWR VGND sg13cmos5l_decap_8
X_4198__549 _4198_/RESET_B VPWR VGND sg13cmos5l_tiehi
X_3220_ _3220_/Y _3221_/B _3217_/Y _3222_/C _3219_/Y VPWR VGND sg13cmos5l_a22oi_1
X_3151_ _3151_/X _3441_/A _3164_/A VPWR VGND sg13cmos5l_and2_1
XFILLER_39_259 VPWR VGND sg13cmos5l_fill_2
XFILLER_48_782 VPWR VGND sg13cmos5l_decap_8
XFILLER_36_911 VPWR VGND sg13cmos5l_decap_4
X_4272__161 _4272_/D VPWR VGND sg13cmos5l_tielo
X_3082_ _3082_/Y _4227_/Q _4200_/Q VPWR VGND sg13cmos5l_xnor2_1
XFILLER_35_487 VPWR VGND sg13cmos5l_decap_8
XFILLER_22_137 VPWR VGND sg13cmos5l_fill_2
X_3984_ _3984_/Q clkload4/A _3984_/D _3984_/RESET_B VPWR VGND sg13cmos5l_dfrbpq_1
X_2935_ _2935_/Y _4204_/Q _2948_/B _2942_/B VPWR VGND sg13cmos5l_a21oi_1
X_2866_ _2866_/X _2866_/A _2866_/B _2866_/C VPWR VGND sg13cmos5l_and3_1
XFILLER_30_170 VPWR VGND sg13cmos5l_fill_1
X_2797_ _2802_/B _2797_/A _2797_/B _2807_/A VPWR VGND sg13cmos5l_nand3_1
X_3418_ _3418_/Y _3429_/B _3416_/Y _3417_/Y VPWR VGND sg13cmos5l_a21oi_1
Xhold1000 hold1000/X _4207_/Q VPWR VGND sg13cmos5l_dlygate4sd3_1
X_3349_ _3350_/B _3561_/A hold960/X _3349_/S VPWR VGND sg13cmos5l_mux2_1
Xhold1022 _3715_/A _4342_/Q VPWR VGND sg13cmos5l_dlygate4sd3_1
Xhold1011 _3802_/A _4353_/Q VPWR VGND sg13cmos5l_dlygate4sd3_1
XFILLER_26_23 VPWR VGND sg13cmos5l_decap_4
XFILLER_27_933 VPWR VGND sg13cmos5l_fill_1
XFILLER_42_947 VPWR VGND sg13cmos5l_decap_8
XFILLER_42_22 VPWR VGND sg13cmos5l_fill_1
XFILLER_5_325 VPWR VGND sg13cmos5l_decap_4
XFILLER_3_16 VPWR VGND sg13cmos5l_fill_2
XFILLER_49_513 VPWR VGND sg13cmos5l_fill_1
XFILLER_36_229 VPWR VGND sg13cmos5l_decap_4
XFILLER_17_443 VPWR VGND sg13cmos5l_fill_1
XFILLER_44_273 VPWR VGND sg13cmos5l_fill_1
XFILLER_44_284 VPWR VGND sg13cmos5l_decap_8
XFILLER_34_1013 VPWR VGND sg13cmos5l_decap_8
X_2720_ _4151_/D _2723_/B _2721_/A VPWR VGND sg13cmos5l_nor2_1
XFILLER_8_163 VPWR VGND sg13cmos5l_decap_8
X_2651_ _2651_/Y _2657_/A1 _2648_/Y _2649_/Y _2650_/Y _2659_/A VPWR VGND sg13cmos5l_a221oi_1
X_4304__157 _4304_/D VPWR VGND sg13cmos5l_tielo
X_2582_ _2582_/X _4094_/Q _4077_/Q _4060_/Q _4043_/Q _2708_/S0 _2708_/S1 VPWR VGND
+ sg13cmos5l_mux4_1
X_4321_ _4321_/Q _4377_/CLK _4321_/D _4321_/RESET_B VPWR VGND sg13cmos5l_dfrbpq_1
Xfanout109 _3964_/A0 input6/X VPWR VGND sg13cmos5l_buf_1
X_4252_ _4252_/Q _4323_/CLK _4252_/D _4252_/RESET_B VPWR VGND sg13cmos5l_dfrbpq_1
X_3203_ _3293_/A _3194_/X _3201_/Y _3199_/Y VPWR VGND sg13cmos5l_a21o_1
X_4183_ _4183_/Q _4209_/CLK _4183_/D _4183_/RESET_B VPWR VGND sg13cmos5l_dfrbpq_1
X_3134_ _3135_/B _4241_/Q _4242_/Q _4243_/Q VPWR VGND sg13cmos5l_o21ai_1
XFILLER_48_590 VPWR VGND sg13cmos5l_decap_4
X_3065_ _3065_/Y _3052_/Y hold871/X _3079_/B VPWR VGND sg13cmos5l_a21oi_1
XFILLER_24_925 VPWR VGND sg13cmos5l_decap_4
XFILLER_23_435 VPWR VGND sg13cmos5l_decap_8
XFILLER_23_446 VPWR VGND sg13cmos5l_fill_2
XFILLER_35_295 VPWR VGND sg13cmos5l_decap_8
X_3967_ _4012_/D _3954_/A hold707/X _3971_/S VPWR VGND sg13cmos5l_mux2_1
XFILLER_11_619 VPWR VGND sg13cmos5l_fill_1
X_2918_ _4205_/D _2918_/A _2918_/B VPWR VGND sg13cmos5l_nor2_1
X_3898_ _3909_/A _2289_/B _2535_/A _3897_/Y VPWR VGND sg13cmos5l_a21oi_1
X_2849_ _2960_/A _3066_/B _2913_/A VPWR VGND sg13cmos5l_nand2b_1
XFILLER_3_818 VPWR VGND sg13cmos5l_fill_1
XFILLER_3_807 VPWR VGND sg13cmos5l_decap_8
XFILLER_5_8 VPWR VGND sg13cmos5l_decap_8
XFILLER_42_722 VPWR VGND sg13cmos5l_fill_1
XFILLER_26_251 VPWR VGND sg13cmos5l_decap_8
XFILLER_27_796 VPWR VGND sg13cmos5l_fill_2
XFILLER_41_210 VPWR VGND sg13cmos5l_fill_1
XFILLER_15_958 VPWR VGND sg13cmos5l_decap_4
XFILLER_18_1019 VPWR VGND sg13cmos5l_decap_8
XFILLER_30_906 VPWR VGND sg13cmos5l_fill_1
XFILLER_41_265 VPWR VGND sg13cmos5l_decap_8
XFILLER_14_479 VPWR VGND sg13cmos5l_decap_8
XFILLER_30_928 VPWR VGND sg13cmos5l_decap_4
Xclkbuf_leaf_21_clk _4353_/CLK clkbuf_leaf_3_clk/A VPWR VGND sg13cmos5l_buf_8
XFILLER_10_663 VPWR VGND sg13cmos5l_fill_1
XFILLER_6_689 VPWR VGND sg13cmos5l_decap_8
X_4078__306 _4078_/RESET_B VPWR VGND sg13cmos5l_tiehi
XFILLER_2_862 VPWR VGND sg13cmos5l_fill_2
XFILLER_49_321 VPWR VGND sg13cmos5l_decap_8
XFILLER_49_376 VPWR VGND sg13cmos5l_decap_8
X_3821_ _3822_/D _4332_/Q _3819_/B _3820_/X VPWR VGND sg13cmos5l_o21ai_1
XFILLER_14_980 VPWR VGND sg13cmos5l_decap_8
XFILLER_32_276 VPWR VGND sg13cmos5l_fill_2
X_3752_ _3752_/Y _3752_/A _4363_/Q VPWR VGND sg13cmos5l_nor2_1
Xclkbuf_leaf_12_clk _4234_/CLK clkload1/A VPWR VGND sg13cmos5l_buf_8
X_2703_ _2703_/Y _2706_/S0 _3980_/Q _2702_/Y VPWR VGND sg13cmos5l_a21oi_1
X_3683_ _4335_/D _3672_/A _3680_/A _3682_/Y VPWR VGND sg13cmos5l_a21oi_1
XFILLER_9_483 VPWR VGND sg13cmos5l_decap_8
X_2634_ _2634_/Y _2632_/S _3987_/Q _2633_/Y VPWR VGND sg13cmos5l_a21oi_1
X_2565_ _4141_/D _2567_/A _2565_/B VPWR VGND sg13cmos5l_nor2_1
X_4304_ _4304_/Q _4333_/CLK _4304_/D _4304_/RESET_B VPWR VGND sg13cmos5l_dfrbpq_1
XFILLER_4_70 VPWR VGND sg13cmos5l_fill_2
X_2496_ _2496_/Y _2500_/B _2500_/C _2501_/A VPWR VGND sg13cmos5l_o21ai_1
X_4235_ _4235_/Q _4238_/CLK _4235_/D _4235_/RESET_B VPWR VGND sg13cmos5l_dfrbpq_1
XFILLER_4_81 VPWR VGND sg13cmos5l_decap_4
X_4166_ _4166_/Q _4209_/CLK _4166_/D _4166_/RESET_B VPWR VGND sg13cmos5l_dfrbpq_1
X_3117_ _3117_/Y _3002_/Y _3095_/Y _3113_/Y _3115_/X VPWR VGND sg13cmos5l_a22oi_1
XFILLER_28_527 VPWR VGND sg13cmos5l_fill_2
X_4097_ _4097_/Q clkload8/A _4097_/D _4097_/RESET_B VPWR VGND sg13cmos5l_dfrbpq_1
XFILLER_43_519 VPWR VGND sg13cmos5l_decap_4
XFILLER_36_571 VPWR VGND sg13cmos5l_decap_8
X_3048_ _3048_/Y _3257_/A _4240_/Q VPWR VGND sg13cmos5l_nor2_1
XFILLER_23_232 VPWR VGND sg13cmos5l_fill_2
XFILLER_23_265 VPWR VGND sg13cmos5l_decap_4
XFILLER_11_438 VPWR VGND sg13cmos5l_decap_4
XFILLER_23_35 VPWR VGND sg13cmos5l_decap_8
XFILLER_7_409 VPWR VGND sg13cmos5l_decap_8
XFILLER_20_972 VPWR VGND sg13cmos5l_decap_8
XFILLER_48_21 VPWR VGND sg13cmos5l_decap_8
XFILLER_47_814 VPWR VGND sg13cmos5l_decap_8
XFILLER_0_28 VPWR VGND sg13cmos5l_decap_8
XFILLER_27_560 VPWR VGND sg13cmos5l_decap_8
Xfanout91 _2632_/S _2670_/A1 VPWR VGND sg13cmos5l_buf_1
Xfanout80 _2657_/A1 _2706_/S1 VPWR VGND sg13cmos5l_buf_1
XFILLER_7_921 VPWR VGND sg13cmos5l_decap_8
XFILLER_31_1027 VPWR VGND sg13cmos5l_fill_2
XFILLER_7_998 VPWR VGND sg13cmos5l_decap_8
XFILLER_6_475 VPWR VGND sg13cmos5l_fill_1
XFILLER_9_1028 VPWR VGND sg13cmos5l_fill_1
X_2350_ _2357_/S _3949_/A _2350_/B VPWR VGND sg13cmos5l_nand2_1
X_2281_ _2281_/Y _4254_/Q VPWR VGND sg13cmos5l_inv_1
Xclkbuf_leaf_1_clk clkload2/A clkbuf_leaf_4_clk/A VPWR VGND sg13cmos5l_buf_8
X_4020_ _4020_/Q clkload3/A _4020_/D _4020_/RESET_B VPWR VGND sg13cmos5l_dfrbpq_1
XFILLER_29_4 VPWR VGND sg13cmos5l_decap_8
X_4351__261 _4351_/RESET_B VPWR VGND sg13cmos5l_tiehi
XFILLER_46_880 VPWR VGND sg13cmos5l_decap_8
XFILLER_18_560 VPWR VGND sg13cmos5l_fill_2
XFILLER_25_508 VPWR VGND sg13cmos5l_decap_4
XFILLER_25_519 VPWR VGND sg13cmos5l_fill_1
XFILLER_33_563 VPWR VGND sg13cmos5l_decap_4
XFILLER_20_224 VPWR VGND sg13cmos5l_fill_1
XFILLER_21_736 VPWR VGND sg13cmos5l_decap_4
X_3804_ _3806_/B _3804_/A _3861_/A _3860_/A VPWR VGND sg13cmos5l_nand3_1
XFILLER_21_769 VPWR VGND sg13cmos5l_decap_4
X_3735_ _4341_/D _3772_/A _3858_/A VPWR VGND sg13cmos5l_nor2_1
X_3666_ _3672_/A _3839_/A _3666_/B _3666_/C VPWR VGND sg13cmos5l_nor3_1
X_3597_ _3597_/Y _2222_/A _3600_/S _3620_/B VPWR VGND sg13cmos5l_o21ai_1
X_2617_ _2617_/Y _2659_/A _2616_/X _2615_/Y VPWR VGND sg13cmos5l_a21oi_1
X_2548_ _2549_/C _2544_/A _2710_/A _2679_/A VPWR VGND sg13cmos5l_a21oi_1
X_2479_ _2486_/B _2480_/A _2480_/B VPWR VGND sg13cmos5l_nand2_1
X_4218_ _4218_/Q _4238_/CLK _4218_/D _4218_/RESET_B VPWR VGND sg13cmos5l_dfrbpq_1
XFILLER_18_24 VPWR VGND sg13cmos5l_decap_8
XFILLER_28_302 VPWR VGND sg13cmos5l_decap_8
XFILLER_28_313 VPWR VGND sg13cmos5l_fill_2
XFILLER_44_806 VPWR VGND sg13cmos5l_decap_8
XFILLER_18_68 VPWR VGND sg13cmos5l_fill_2
XFILLER_28_346 VPWR VGND sg13cmos5l_fill_1
X_4149_ _4149_/Q _4225_/CLK _4149_/D _4149_/RESET_B VPWR VGND sg13cmos5l_dfrbpq_1
XFILLER_16_508 VPWR VGND sg13cmos5l_fill_1
XFILLER_18_79 VPWR VGND sg13cmos5l_fill_2
XFILLER_28_368 VPWR VGND sg13cmos5l_decap_8
XFILLER_43_327 VPWR VGND sg13cmos5l_decap_4
XFILLER_12_703 VPWR VGND sg13cmos5l_fill_1
XFILLER_12_714 VPWR VGND sg13cmos5l_fill_2
X_4068__316 _4068_/RESET_B VPWR VGND sg13cmos5l_tiehi
XFILLER_24_574 VPWR VGND sg13cmos5l_fill_2
XFILLER_24_585 VPWR VGND sg13cmos5l_decap_8
Xclkload0 clkload0/X clkload0/A VPWR VGND sg13cmos5l_buf_8
XFILLER_4_935 VPWR VGND sg13cmos5l_decap_8
XFILLER_3_412 VPWR VGND sg13cmos5l_decap_8
X_4339__381 _4339_/RESET_B VPWR VGND sg13cmos5l_tiehi
X_4075__309 _4075_/RESET_B VPWR VGND sg13cmos5l_tiehi
XFILLER_19_302 VPWR VGND sg13cmos5l_decap_4
XFILLER_47_699 VPWR VGND sg13cmos5l_decap_4
XFILLER_46_198 VPWR VGND sg13cmos5l_decap_8
X_3520_ _3822_/B _4334_/Q _3783_/A _4335_/Q VPWR VGND sg13cmos5l_nor3_1
Xhold718 hold718/X _4063_/Q VPWR VGND sg13cmos5l_dlygate4sd3_1
Xhold707 hold707/X _4012_/Q VPWR VGND sg13cmos5l_dlygate4sd3_1
XFILLER_7_773 VPWR VGND sg13cmos5l_decap_8
XFILLER_7_762 VPWR VGND sg13cmos5l_fill_1
Xhold729 hold729/X _3977_/Q VPWR VGND sg13cmos5l_dlygate4sd3_1
X_3451_ _3483_/C _3451_/A _3487_/B VPWR VGND sg13cmos5l_or2_1
X_3382_ _3382_/Y _3168_/A _3369_/X _3380_/B _3380_/A VPWR VGND sg13cmos5l_a22oi_1
X_2402_ _2410_/S _3963_/B _2411_/C VPWR VGND sg13cmos5l_nand2_1
X_2333_ _4022_/D _3958_/A hold748/X _2334_/S VPWR VGND sg13cmos5l_mux2_1
X_2264_ _2264_/Y _2264_/A VPWR VGND sg13cmos5l_inv_1
X_4003_ _4003_/Q clkload3/A _4003_/D _4003_/RESET_B VPWR VGND sg13cmos5l_dfrbpq_1
XFILLER_38_688 VPWR VGND sg13cmos5l_decap_8
XFILLER_26_828 VPWR VGND sg13cmos5l_decap_4
XFILLER_26_839 VPWR VGND sg13cmos5l_decap_8
XFILLER_18_390 VPWR VGND sg13cmos5l_fill_1
XFILLER_34_872 VPWR VGND sg13cmos5l_decap_4
XFILLER_40_319 VPWR VGND sg13cmos5l_fill_2
XFILLER_14_1022 VPWR VGND sg13cmos5l_decap_8
X_3718_ _3718_/Y _3718_/A _3730_/B VPWR VGND sg13cmos5l_nand2_1
X_3649_ _3669_/A _3647_/X _3648_/X _3640_/Y VPWR VGND sg13cmos5l_o21ai_1
XFILLER_29_655 VPWR VGND sg13cmos5l_fill_1
XFILLER_44_636 VPWR VGND sg13cmos5l_fill_2
XFILLER_28_187 VPWR VGND sg13cmos5l_decap_4
XFILLER_45_66 VPWR VGND sg13cmos5l_fill_2
XFILLER_43_168 VPWR VGND sg13cmos5l_decap_8
X_4365__227 _4365_/RESET_B VPWR VGND sg13cmos5l_tiehi
XFILLER_25_894 VPWR VGND sg13cmos5l_decap_8
XFILLER_12_533 VPWR VGND sg13cmos5l_decap_8
XFILLER_8_526 VPWR VGND sg13cmos5l_fill_1
XFILLER_4_765 VPWR VGND sg13cmos5l_decap_8
XFILLER_48_964 VPWR VGND sg13cmos5l_decap_8
XFILLER_19_143 VPWR VGND sg13cmos5l_fill_2
XFILLER_35_636 VPWR VGND sg13cmos5l_decap_8
X_2951_ _2951_/Y _2951_/A _2959_/A VPWR VGND sg13cmos5l_nor2_1
X_2882_ _2882_/Y _2851_/A _2890_/B _2888_/B _3076_/A VPWR VGND sg13cmos5l_a22oi_1
XFILLER_31_875 VPWR VGND sg13cmos5l_fill_2
XFILLER_31_886 VPWR VGND sg13cmos5l_decap_8
X_4162__178 _4162_/D VPWR VGND sg13cmos5l_tielo
XFILLER_7_592 VPWR VGND sg13cmos5l_decap_8
XFILLER_7_570 VPWR VGND sg13cmos5l_decap_8
X_3503_ _3503_/Y hold950/X _3500_/A _3323_/Y VPWR VGND sg13cmos5l_o21ai_1
X_3434_ _3434_/Y _4290_/Q _3779_/A2 _3254_/A VPWR VGND sg13cmos5l_o21ai_1
X_3365_ _3377_/B _4248_/Q _4247_/Q _4246_/Q VPWR VGND sg13cmos5l_or3_1
X_2316_ _4372_/D _3897_/A _3897_/B _3916_/A VPWR VGND sg13cmos5l_a21oi_1
X_3296_ _3297_/B _3296_/A _3296_/B VPWR VGND sg13cmos5l_xnor2_1
X_4058__326 _4058_/RESET_B VPWR VGND sg13cmos5l_tiehi
XFILLER_39_942 VPWR VGND sg13cmos5l_decap_8
X_2247_ _3618_/A _2247_/A VPWR VGND sg13cmos5l_inv_1
Xheichips26_dna_sequencer_142 uio_out[2] VPWR VGND sg13cmos5l_tielo
XFILLER_38_485 VPWR VGND sg13cmos5l_fill_2
XFILLER_13_308 VPWR VGND sg13cmos5l_fill_2
XFILLER_15_25 VPWR VGND sg13cmos5l_decap_8
XFILLER_40_138 VPWR VGND sg13cmos5l_decap_8
XFILLER_21_330 VPWR VGND sg13cmos5l_decap_4
XFILLER_22_875 VPWR VGND sg13cmos5l_fill_2
X_4065__319 _4065_/RESET_B VPWR VGND sg13cmos5l_tiehi
X_4329__391 _4329_/RESET_B VPWR VGND sg13cmos5l_tiehi
XFILLER_0_245 VPWR VGND sg13cmos5l_decap_8
XFILLER_49_717 VPWR VGND sg13cmos5l_decap_8
XFILLER_29_430 VPWR VGND sg13cmos5l_decap_8
X_4336__384 _4336_/RESET_B VPWR VGND sg13cmos5l_tiehi
XFILLER_29_452 VPWR VGND sg13cmos5l_fill_1
XFILLER_45_945 VPWR VGND sg13cmos5l_decap_8
XFILLER_29_474 VPWR VGND sg13cmos5l_decap_8
XFILLER_29_485 VPWR VGND sg13cmos5l_fill_1
XFILLER_44_455 VPWR VGND sg13cmos5l_decap_8
XFILLER_16_179 VPWR VGND sg13cmos5l_decap_4
XFILLER_31_105 VPWR VGND sg13cmos5l_fill_2
XFILLER_32_617 VPWR VGND sg13cmos5l_decap_4
XFILLER_13_831 VPWR VGND sg13cmos5l_decap_8
XFILLER_13_853 VPWR VGND sg13cmos5l_decap_8
XFILLER_25_691 VPWR VGND sg13cmos5l_decap_8
X_4308__420 _4308_/RESET_B VPWR VGND sg13cmos5l_tiehi
XFILLER_12_352 VPWR VGND sg13cmos5l_decap_8
XFILLER_40_694 VPWR VGND sg13cmos5l_decap_8
X_4343__377 _4343_/RESET_B VPWR VGND sg13cmos5l_tiehi
XFILLER_4_551 VPWR VGND sg13cmos5l_fill_2
X_3150_ _3150_/Y _3133_/Y _3148_/Y _3149_/X VPWR VGND sg13cmos5l_a21oi_1
X_4315__413 _4315_/RESET_B VPWR VGND sg13cmos5l_tiehi
X_3081_ _3081_/Y _4226_/Q _4199_/Q VPWR VGND sg13cmos5l_xnor2_1
XFILLER_48_761 VPWR VGND sg13cmos5l_decap_8
XFILLER_11_4 VPWR VGND sg13cmos5l_decap_8
XFILLER_36_989 VPWR VGND sg13cmos5l_decap_8
XFILLER_35_466 VPWR VGND sg13cmos5l_decap_8
X_3983_ _3983_/Q clkload3/A _3983_/D _3983_/RESET_B VPWR VGND sg13cmos5l_dfrbpq_1
X_2934_ _2942_/B _2934_/A _2948_/B VPWR VGND sg13cmos5l_nor2_1
X_2865_ _2874_/A _2865_/A _2866_/B VPWR VGND sg13cmos5l_xnor2_1
XFILLER_30_160 VPWR VGND sg13cmos5l_fill_2
XFILLER_31_683 VPWR VGND sg13cmos5l_fill_1
X_2796_ _2806_/B _2800_/A _2800_/B VPWR VGND sg13cmos5l_and2_1
X_3417_ _3417_/Y _3580_/B _3427_/A VPWR VGND sg13cmos5l_nor2_1
X_3348_ _3561_/A _3617_/A _3356_/B VPWR VGND sg13cmos5l_nand2_1
Xhold1012 _2859_/B1 _4163_/Q VPWR VGND sg13cmos5l_dlygate4sd3_1
Xhold1001 _3667_/A _4330_/Q VPWR VGND sg13cmos5l_dlygate4sd3_1
X_4372__540 _4372_/RESET_B VPWR VGND sg13cmos5l_tiehi
Xhold1023 _3140_/B _4242_/Q VPWR VGND sg13cmos5l_dlygate4sd3_1
XFILLER_39_772 VPWR VGND sg13cmos5l_fill_1
X_3279_ _3279_/Y _3279_/A _3296_/B VPWR VGND sg13cmos5l_nand2_1
XFILLER_42_926 VPWR VGND sg13cmos5l_decap_8
XFILLER_41_469 VPWR VGND sg13cmos5l_decap_4
XFILLER_10_845 VPWR VGND sg13cmos5l_decap_4
XFILLER_21_160 VPWR VGND sg13cmos5l_fill_1
XFILLER_22_683 VPWR VGND sg13cmos5l_fill_2
XFILLER_10_856 VPWR VGND sg13cmos5l_decap_8
XFILLER_10_867 VPWR VGND sg13cmos5l_fill_1
XFILLER_21_193 VPWR VGND sg13cmos5l_decap_8
Xhold890 _2478_/A _4121_/Q VPWR VGND sg13cmos5l_dlygate4sd3_1
XFILLER_49_525 VPWR VGND sg13cmos5l_decap_8
XFILLER_18_912 VPWR VGND sg13cmos5l_decap_8
X_4117__264 _4117_/RESET_B VPWR VGND sg13cmos5l_tiehi
XFILLER_18_978 VPWR VGND sg13cmos5l_decap_8
XFILLER_33_904 VPWR VGND sg13cmos5l_decap_8
XFILLER_12_160 VPWR VGND sg13cmos5l_fill_1
X_4048__336 _4048_/RESET_B VPWR VGND sg13cmos5l_tiehi
XFILLER_12_193 VPWR VGND sg13cmos5l_decap_4
X_2650_ _2650_/Y _2654_/S _4018_/Q _2657_/A1 VPWR VGND sg13cmos5l_a21oi_1
X_2581_ _2581_/Y _2690_/A1 _2579_/Y _2580_/Y _2577_/Y _2659_/A VPWR VGND sg13cmos5l_a221oi_1
X_4320_ _4320_/Q _4377_/CLK _4320_/D _4320_/RESET_B VPWR VGND sg13cmos5l_dfrbpq_1
X_4251_ _4251_/Q _4323_/CLK _4251_/D _4251_/RESET_B VPWR VGND sg13cmos5l_dfrbpq_1
X_3202_ _3204_/B _3194_/X _3201_/Y _3199_/Y VPWR VGND sg13cmos5l_a21oi_1
XFILLER_41_1018 VPWR VGND sg13cmos5l_decap_8
X_4182_ _4182_/Q _4209_/CLK _4182_/D _4182_/RESET_B VPWR VGND sg13cmos5l_dfrbpq_1
X_3133_ _3133_/Y _3133_/A VPWR VGND sg13cmos5l_inv_1
X_4055__329 _4055_/RESET_B VPWR VGND sg13cmos5l_tiehi
X_3064_ _3064_/Y _3064_/A _3064_/B VPWR VGND sg13cmos5l_nand2_1
XFILLER_36_764 VPWR VGND sg13cmos5l_decap_8
XFILLER_36_775 VPWR VGND sg13cmos5l_fill_1
XFILLER_24_948 VPWR VGND sg13cmos5l_decap_8
X_3966_ _4011_/D _3952_/A hold708/X _3971_/S VPWR VGND sg13cmos5l_mux2_1
XFILLER_23_469 VPWR VGND sg13cmos5l_fill_1
X_2917_ _4204_/D _2917_/A _2962_/A VPWR VGND sg13cmos5l_and2_1
XFILLER_32_981 VPWR VGND sg13cmos5l_decap_8
X_4168__184 _4168_/RESET_B VPWR VGND sg13cmos5l_tiehi
X_3897_ _3897_/Y _3897_/A _3897_/B _3897_/C VPWR VGND sg13cmos5l_nand3_1
X_4209__170 _4209_/D VPWR VGND sg13cmos5l_tielo
XFILLER_12_59 VPWR VGND sg13cmos5l_fill_1
X_4326__394 _4326_/RESET_B VPWR VGND sg13cmos5l_tiehi
X_2848_ _2962_/A _3323_/A _3066_/B VPWR VGND sg13cmos5l_nor2_1
X_2779_ _2779_/Y _4170_/Q _2784_/A2 _2718_/A VPWR VGND sg13cmos5l_o21ai_1
X_4257__477 _4257_/RESET_B VPWR VGND sg13cmos5l_tiehi
XFILLER_2_1023 VPWR VGND sg13cmos5l_decap_4
X_4333__387 _4333_/RESET_B VPWR VGND sg13cmos5l_tiehi
XFILLER_42_745 VPWR VGND sg13cmos5l_fill_1
XFILLER_42_734 VPWR VGND sg13cmos5l_decap_8
XFILLER_42_789 VPWR VGND sg13cmos5l_decap_4
XFILLER_14_458 VPWR VGND sg13cmos5l_decap_8
XFILLER_10_631 VPWR VGND sg13cmos5l_decap_8
XFILLER_6_624 VPWR VGND sg13cmos5l_fill_2
X_4305__423 _4305_/RESET_B VPWR VGND sg13cmos5l_tiehi
XFILLER_5_145 VPWR VGND sg13cmos5l_fill_1
XFILLER_10_697 VPWR VGND sg13cmos5l_decap_8
XFILLER_5_167 VPWR VGND sg13cmos5l_decap_8
X_4312__416 _4312_/RESET_B VPWR VGND sg13cmos5l_tiehi
XFILLER_18_742 VPWR VGND sg13cmos5l_decap_4
XFILLER_18_797 VPWR VGND sg13cmos5l_fill_1
XFILLER_17_285 VPWR VGND sg13cmos5l_fill_2
X_3820_ _3820_/X _4335_/Q _4314_/Q VPWR VGND sg13cmos5l_or2_1
XFILLER_33_767 VPWR VGND sg13cmos5l_decap_4
X_3751_ _3751_/X _3751_/A _3751_/B VPWR VGND sg13cmos5l_or2_1
X_2702_ _2702_/Y _2706_/S0 _2268_/Y _2704_/A1 VPWR VGND sg13cmos5l_o21ai_1
X_3682_ _3682_/Y _3682_/A1 _3680_/A _3505_/Y VPWR VGND sg13cmos5l_o21ai_1
XFILLER_9_495 VPWR VGND sg13cmos5l_decap_8
X_2633_ _2633_/Y _2632_/S _2265_/Y _2669_/B1 VPWR VGND sg13cmos5l_o21ai_1
X_2564_ _2564_/Y hold881/X _2560_/Y _2563_/Y VPWR VGND sg13cmos5l_a21oi_1
XFILLER_5_690 VPWR VGND sg13cmos5l_decap_8
X_4303_ _4303_/Q _4303_/CLK _4303_/D _4303_/RESET_B VPWR VGND sg13cmos5l_dfrbpq_1
X_2495_ _4127_/D _2500_/C _2495_/B VPWR VGND sg13cmos5l_nor2_1
X_4234_ _4234_/Q _4234_/CLK _4234_/D _4234_/RESET_B VPWR VGND sg13cmos5l_dfrbpq_1
X_4165_ _4165_/Q _4209_/CLK _4165_/D _4165_/RESET_B VPWR VGND sg13cmos5l_dfrbpq_1
X_3116_ _3116_/Y _3113_/Y _3115_/X _3111_/Y VPWR VGND sg13cmos5l_o21ai_1
X_4096_ _4096_/Q _4128_/CLK _4096_/D _4096_/RESET_B VPWR VGND sg13cmos5l_dfrbpq_1
X_3047_ _3047_/Y _4194_/Q _3047_/B _3047_/C VPWR VGND sg13cmos5l_nor3_1
XFILLER_12_929 VPWR VGND sg13cmos5l_decap_8
XFILLER_23_244 VPWR VGND sg13cmos5l_decap_8
XFILLER_23_299 VPWR VGND sg13cmos5l_fill_2
XFILLER_20_951 VPWR VGND sg13cmos5l_decap_8
X_3949_ _3949_/Y _3949_/A _3949_/B VPWR VGND sg13cmos5l_nand2_1
X_3983__552 _3983_/RESET_B VPWR VGND sg13cmos5l_tiehi
XFILLER_3_616 VPWR VGND sg13cmos5l_decap_8
XFILLER_3_638 VPWR VGND sg13cmos5l_decap_8
XFILLER_24_1024 VPWR VGND sg13cmos5l_decap_4
XFILLER_48_77 VPWR VGND sg13cmos5l_decap_8
X_4038__346 _4038_/RESET_B VPWR VGND sg13cmos5l_tiehi
XFILLER_15_723 VPWR VGND sg13cmos5l_fill_1
XFILLER_15_745 VPWR VGND sg13cmos5l_fill_2
XFILLER_9_49 VPWR VGND sg13cmos5l_fill_1
XFILLER_14_288 VPWR VGND sg13cmos5l_decap_4
X_4084__300 _4084_/RESET_B VPWR VGND sg13cmos5l_tiehi
Xfanout92 _2680_/A _2706_/S0 VPWR VGND sg13cmos5l_buf_1
Xfanout81 _2669_/B1 _2706_/S1 VPWR VGND sg13cmos5l_buf_1
Xfanout70 _2441_/B hold879/X VPWR VGND sg13cmos5l_buf_1
XFILLER_31_1006 VPWR VGND sg13cmos5l_decap_8
XFILLER_11_984 VPWR VGND sg13cmos5l_decap_8
X_4045__339 _4045_/RESET_B VPWR VGND sg13cmos5l_tiehi
XFILLER_7_977 VPWR VGND sg13cmos5l_decap_8
XFILLER_6_432 VPWR VGND sg13cmos5l_fill_2
XFILLER_6_421 VPWR VGND sg13cmos5l_decap_8
XFILLER_6_498 VPWR VGND sg13cmos5l_decap_8
XFILLER_9_1007 VPWR VGND sg13cmos5l_decap_8
X_2280_ _3244_/A _4255_/Q VPWR VGND sg13cmos5l_inv_1
X_3995__412 _3995_/RESET_B VPWR VGND sg13cmos5l_tiehi
XFILLER_49_141 VPWR VGND sg13cmos5l_decap_8
X_4158__194 _4158_/RESET_B VPWR VGND sg13cmos5l_tiehi
XFILLER_49_196 VPWR VGND sg13cmos5l_decap_4
XFILLER_37_358 VPWR VGND sg13cmos5l_fill_2
XFILLER_18_583 VPWR VGND sg13cmos5l_decap_8
X_3803_ _3868_/A _3804_/A _3801_/B _3802_/X VPWR VGND sg13cmos5l_o21ai_1
X_3734_ _3858_/A _3712_/A _3730_/B _3733_/Y VPWR VGND sg13cmos5l_a21oi_1
X_4247__487 _4247_/RESET_B VPWR VGND sg13cmos5l_tiehi
X_4165__187 _4165_/RESET_B VPWR VGND sg13cmos5l_tiehi
X_3665_ _3665_/Y _3656_/Y _3659_/Y _3661_/X _3679_/A _3664_/Y VPWR VGND sg13cmos5l_a221oi_1
X_2616_ _2616_/X _4102_/Q _4085_/Q _4068_/Q _4051_/Q _2629_/A _2658_/S1 VPWR VGND
+ sg13cmos5l_mux4_1
X_3596_ _3600_/S _3745_/A _3596_/B _3596_/C VPWR VGND sg13cmos5l_or3_1
XFILLER_47_1024 VPWR VGND sg13cmos5l_decap_4
X_2547_ _2550_/A _3775_/A _2547_/B VPWR VGND sg13cmos5l_nand2_1
X_2478_ _2480_/B _2478_/A _2484_/B VPWR VGND sg13cmos5l_xor2_1
X_4000__401 _4000_/RESET_B VPWR VGND sg13cmos5l_tiehi
X_4217_ _4217_/Q _4238_/CLK _4217_/D _4217_/RESET_B VPWR VGND sg13cmos5l_dfrbpq_1
XFILLER_29_804 VPWR VGND sg13cmos5l_decap_8
X_4148_ _4148_/Q _4378_/CLK _4148_/D _4148_/RESET_B VPWR VGND sg13cmos5l_dfrbpq_1
XFILLER_28_336 VPWR VGND sg13cmos5l_decap_4
XFILLER_43_306 VPWR VGND sg13cmos5l_decap_8
X_4079_ _4079_/Q _4128_/CLK _4079_/D _4079_/RESET_B VPWR VGND sg13cmos5l_dfrbpq_1
XFILLER_28_358 VPWR VGND sg13cmos5l_decap_8
XFILLER_36_391 VPWR VGND sg13cmos5l_decap_8
XFILLER_24_597 VPWR VGND sg13cmos5l_decap_8
Xclkload1 clkload1/X clkload1/A VPWR VGND sg13cmos5l_buf_8
XFILLER_4_914 VPWR VGND sg13cmos5l_decap_8
X_4302__426 _4302_/RESET_B VPWR VGND sg13cmos5l_tiehi
XFILLER_3_468 VPWR VGND sg13cmos5l_decap_8
XFILLER_47_601 VPWR VGND sg13cmos5l_fill_2
XFILLER_19_336 VPWR VGND sg13cmos5l_decap_8
XFILLER_47_678 VPWR VGND sg13cmos5l_fill_2
XFILLER_43_884 VPWR VGND sg13cmos5l_decap_8
XFILLER_15_575 VPWR VGND sg13cmos5l_decap_8
XFILLER_11_792 VPWR VGND sg13cmos5l_decap_8
Xhold708 hold708/X _4011_/Q VPWR VGND sg13cmos5l_dlygate4sd3_1
Xhold719 hold719/X _4086_/Q VPWR VGND sg13cmos5l_dlygate4sd3_1
XFILLER_6_273 VPWR VGND sg13cmos5l_fill_2
X_3450_ _3483_/B _3446_/Y _3448_/Y _3449_/Y VPWR VGND sg13cmos5l_o21ai_1
XFILLER_41_4 VPWR VGND sg13cmos5l_decap_4
X_3381_ _3381_/Y _3376_/X _3379_/Y _3380_/Y VPWR VGND sg13cmos5l_o21ai_1
X_2401_ _2411_/C _2401_/A _2500_/B VPWR VGND sg13cmos5l_nor2_1
X_2332_ _4021_/D _3956_/A hold745/X _2336_/B VPWR VGND sg13cmos5l_mux2_1
XFILLER_38_612 VPWR VGND sg13cmos5l_fill_1
XFILLER_38_601 VPWR VGND sg13cmos5l_decap_8
X_4002_ _4002_/Q clkload3/A _4002_/D _4002_/RESET_B VPWR VGND sg13cmos5l_dfrbpq_1
X_2263_ _2263_/Y _2263_/A VPWR VGND sg13cmos5l_inv_1
XFILLER_38_645 VPWR VGND sg13cmos5l_fill_2
XFILLER_38_634 VPWR VGND sg13cmos5l_decap_8
XFILLER_37_133 VPWR VGND sg13cmos5l_decap_8
XFILLER_19_892 VPWR VGND sg13cmos5l_decap_4
XFILLER_33_350 VPWR VGND sg13cmos5l_fill_2
XFILLER_21_545 VPWR VGND sg13cmos5l_decap_8
XFILLER_14_1001 VPWR VGND sg13cmos5l_decap_8
XFILLER_21_589 VPWR VGND sg13cmos5l_fill_2
X_3717_ _3731_/S _3709_/Y _3713_/Y _3733_/B VPWR VGND sg13cmos5l_a21o_1
X_4028__356 _4028_/RESET_B VPWR VGND sg13cmos5l_tiehi
X_3648_ _3648_/X _4330_/Q _3667_/B _3639_/Y VPWR VGND sg13cmos5l_a21o_1
XFILLER_20_37 VPWR VGND sg13cmos5l_fill_2
X_3579_ _3586_/S _3822_/A _3429_/A _3578_/Y VPWR VGND sg13cmos5l_o21ai_1
X_4074__310 _4074_/RESET_B VPWR VGND sg13cmos5l_tiehi
XFILLER_21_1016 VPWR VGND sg13cmos5l_decap_8
XFILLER_21_1027 VPWR VGND sg13cmos5l_fill_2
XFILLER_16_306 VPWR VGND sg13cmos5l_decap_4
XFILLER_17_829 VPWR VGND sg13cmos5l_decap_4
X_4035__349 _4035_/RESET_B VPWR VGND sg13cmos5l_tiehi
XFILLER_43_147 VPWR VGND sg13cmos5l_fill_2
XFILLER_25_862 VPWR VGND sg13cmos5l_fill_2
XFILLER_40_854 VPWR VGND sg13cmos5l_fill_1
XFILLER_40_843 VPWR VGND sg13cmos5l_decap_8
XFILLER_8_549 VPWR VGND sg13cmos5l_decap_4
X_4081__303 _4081_/RESET_B VPWR VGND sg13cmos5l_tiehi
XFILLER_4_744 VPWR VGND sg13cmos5l_decap_8
XFILLER_3_210 VPWR VGND sg13cmos5l_fill_1
XFILLER_3_221 VPWR VGND sg13cmos5l_fill_2
XFILLER_10_81 VPWR VGND sg13cmos5l_fill_2
XFILLER_39_409 VPWR VGND sg13cmos5l_fill_2
XFILLER_48_943 VPWR VGND sg13cmos5l_decap_8
XFILLER_19_100 VPWR VGND sg13cmos5l_fill_1
XFILLER_19_111 VPWR VGND sg13cmos5l_decap_8
X_4237__497 _4237_/RESET_B VPWR VGND sg13cmos5l_tiehi
XFILLER_35_604 VPWR VGND sg13cmos5l_fill_2
X_4155__197 _4155_/RESET_B VPWR VGND sg13cmos5l_tiehi
XFILLER_34_136 VPWR VGND sg13cmos5l_fill_2
XFILLER_34_147 VPWR VGND sg13cmos5l_fill_2
XFILLER_43_681 VPWR VGND sg13cmos5l_decap_8
X_2950_ _2950_/Y _2949_/Y _2955_/A VPWR VGND sg13cmos5l_nand2b_1
XFILLER_15_372 VPWR VGND sg13cmos5l_decap_4
XFILLER_16_884 VPWR VGND sg13cmos5l_decap_8
X_2881_ _2881_/Y _3078_/A _4167_/Q VPWR VGND sg13cmos5l_nand2_1
X_4127__244 _4127_/RESET_B VPWR VGND sg13cmos5l_tiehi
X_3502_ _4302_/D _3502_/A _3502_/B _3502_/C VPWR VGND sg13cmos5l_nor3_1
X_3433_ _3433_/Y _2225_/Y _3781_/A2 _3432_/Y VPWR VGND sg13cmos5l_a21oi_1
XFILLER_44_1027 VPWR VGND sg13cmos5l_fill_2
XFILLER_44_1016 VPWR VGND sg13cmos5l_decap_8
X_3364_ _4276_/D _3442_/B _3364_/B VPWR VGND sg13cmos5l_nor2_1
X_2315_ _3897_/B _2315_/A _2315_/B VPWR VGND sg13cmos5l_nand2_1
X_3295_ _3295_/Y _3295_/A _3295_/B _3295_/C VPWR VGND sg13cmos5l_nand3_1
X_2246_ _2246_/Y _3748_/B VPWR VGND sg13cmos5l_inv_1
Xheichips26_dna_sequencer_143 uio_out[3] VPWR VGND sg13cmos5l_tielo
XFILLER_39_998 VPWR VGND sg13cmos5l_decap_8
XFILLER_40_128 VPWR VGND sg13cmos5l_fill_1
XFILLER_21_342 VPWR VGND sg13cmos5l_decap_8
XFILLER_22_887 VPWR VGND sg13cmos5l_decap_8
XFILLER_33_191 VPWR VGND sg13cmos5l_fill_1
Xoutput14 uo_out[0] _4114_/Q VPWR VGND sg13cmos5l_buf_1
XFILLER_0_235 VPWR VGND sg13cmos5l_fill_1
XFILLER_49_729 VPWR VGND sg13cmos5l_decap_8
XFILLER_5_1010 VPWR VGND sg13cmos5l_decap_8
XFILLER_29_464 VPWR VGND sg13cmos5l_fill_1
XFILLER_45_924 VPWR VGND sg13cmos5l_decap_8
XFILLER_29_497 VPWR VGND sg13cmos5l_decap_8
XFILLER_44_445 VPWR VGND sg13cmos5l_decap_4
XFILLER_44_434 VPWR VGND sg13cmos5l_decap_8
XFILLER_31_128 VPWR VGND sg13cmos5l_decap_4
XFILLER_40_662 VPWR VGND sg13cmos5l_decap_8
XFILLER_12_397 VPWR VGND sg13cmos5l_decap_8
X_3080_ _3080_/Y _4228_/Q _4201_/Q VPWR VGND sg13cmos5l_nand2_1
XFILLER_36_968 VPWR VGND sg13cmos5l_decap_8
X_4018__366 _4018_/RESET_B VPWR VGND sg13cmos5l_tiehi
X_3982_ _3982_/Q _4161_/CLK _3982_/D _3982_/RESET_B VPWR VGND sg13cmos5l_dfrbpq_1
XFILLER_23_607 VPWR VGND sg13cmos5l_decap_8
XFILLER_22_139 VPWR VGND sg13cmos5l_fill_1
X_2933_ _2942_/A _2938_/B _2938_/C _2938_/A VPWR VGND sg13cmos5l_a21oi_1
XFILLER_31_640 VPWR VGND sg13cmos5l_decap_8
X_2864_ _2864_/Y _2861_/Y _2862_/Y _2863_/Y _4180_/Q VPWR VGND sg13cmos5l_a22oi_1
X_4064__320 _4064_/RESET_B VPWR VGND sg13cmos5l_tiehi
XFILLER_30_183 VPWR VGND sg13cmos5l_decap_8
X_2795_ _2795_/Y _4178_/Q _2800_/B VPWR VGND sg13cmos5l_nand2_1
XFILLER_11_1026 VPWR VGND sg13cmos5l_fill_2
X_4025__359 _4025_/RESET_B VPWR VGND sg13cmos5l_tiehi
X_3416_ _3416_/Y _3620_/A _3621_/A _3244_/A _3244_/B VPWR VGND sg13cmos5l_a22oi_1
X_3347_ _3349_/S _3357_/B _3357_/D VPWR VGND sg13cmos5l_and2_1
X_4355__249 _4355_/RESET_B VPWR VGND sg13cmos5l_tiehi
Xhold1013 _3340_/A _4276_/Q VPWR VGND sg13cmos5l_dlygate4sd3_1
Xhold1002 _3682_/A1 _3672_/B VPWR VGND sg13cmos5l_dlygate4sd3_1
Xhold1024 _3144_/A _4244_/Q VPWR VGND sg13cmos5l_dlygate4sd3_1
XFILLER_39_751 VPWR VGND sg13cmos5l_decap_8
X_3278_ _3278_/Y _4267_/Q _3296_/B VPWR VGND sg13cmos5l_nor2_1
X_4071__313 _4071_/RESET_B VPWR VGND sg13cmos5l_tiehi
X_2229_ _3047_/B _2229_/A VPWR VGND sg13cmos5l_inv_1
XFILLER_42_905 VPWR VGND sg13cmos5l_decap_8
XFILLER_38_294 VPWR VGND sg13cmos5l_decap_4
XFILLER_26_456 VPWR VGND sg13cmos5l_decap_8
XFILLER_14_618 VPWR VGND sg13cmos5l_fill_1
XFILLER_13_117 VPWR VGND sg13cmos5l_fill_2
XFILLER_13_128 VPWR VGND sg13cmos5l_decap_8
XFILLER_22_662 VPWR VGND sg13cmos5l_decap_8
XFILLER_10_824 VPWR VGND sg13cmos5l_decap_8
XFILLER_21_172 VPWR VGND sg13cmos5l_decap_8
XFILLER_22_695 VPWR VGND sg13cmos5l_decap_8
Xhold880 _2553_/A _4143_/Q VPWR VGND sg13cmos5l_dlygate4sd3_1
XFILLER_3_18 VPWR VGND sg13cmos5l_fill_1
Xhold891 _3620_/A _4303_/Q VPWR VGND sg13cmos5l_dlygate4sd3_1
XFILLER_27_1022 VPWR VGND sg13cmos5l_decap_8
X_4197__551 _4197_/RESET_B VPWR VGND sg13cmos5l_tiehi
XFILLER_49_559 VPWR VGND sg13cmos5l_decap_8
XFILLER_18_946 VPWR VGND sg13cmos5l_decap_8
XFILLER_45_798 VPWR VGND sg13cmos5l_decap_8
XFILLER_45_765 VPWR VGND sg13cmos5l_decap_8
XFILLER_44_264 VPWR VGND sg13cmos5l_decap_8
XFILLER_26_990 VPWR VGND sg13cmos5l_decap_8
XFILLER_33_949 VPWR VGND sg13cmos5l_decap_8
XFILLER_9_633 VPWR VGND sg13cmos5l_decap_4
XFILLER_13_673 VPWR VGND sg13cmos5l_decap_8
X_2580_ _2580_/Y _2680_/A _4009_/Q _2690_/A1 VPWR VGND sg13cmos5l_a21oi_1
XFILLER_4_360 VPWR VGND sg13cmos5l_decap_4
XFILLER_4_393 VPWR VGND sg13cmos5l_decap_8
X_4250_ _4250_/Q _4303_/CLK _4250_/D _4250_/RESET_B VPWR VGND sg13cmos5l_dfrbpq_1
X_4181_ _4181_/Q _4181_/CLK _4181_/D _4181_/RESET_B VPWR VGND sg13cmos5l_dfrbpq_1
X_3201_ _3201_/Y _3201_/A VPWR VGND sg13cmos5l_inv_1
X_3132_ _3133_/A _3169_/A _3168_/A VPWR VGND sg13cmos5l_nor2_1
X_3063_ _3063_/Y _3045_/Y _3059_/B _3062_/Y VPWR VGND sg13cmos5l_a21oi_1
XFILLER_24_905 VPWR VGND sg13cmos5l_fill_1
X_3965_ _4010_/D _3965_/A0 hold761/X _3971_/S VPWR VGND sg13cmos5l_mux2_1
XFILLER_23_459 VPWR VGND sg13cmos5l_decap_4
X_2916_ _4203_/D _2916_/A _2918_/B VPWR VGND sg13cmos5l_nor2_1
XFILLER_10_109 VPWR VGND sg13cmos5l_decap_8
X_3896_ _3897_/C _2517_/Y _3896_/B VPWR VGND sg13cmos5l_nand2b_1
X_2847_ _2847_/Y _2847_/A _2847_/B VPWR VGND sg13cmos5l_nand2_1
X_2778_ _4169_/D _3066_/A _2778_/B VPWR VGND sg13cmos5l_and2_1
XFILLER_46_518 VPWR VGND sg13cmos5l_fill_2
XFILLER_2_1002 VPWR VGND sg13cmos5l_decap_8
XFILLER_27_754 VPWR VGND sg13cmos5l_fill_1
XFILLER_15_916 VPWR VGND sg13cmos5l_decap_8
XFILLER_41_223 VPWR VGND sg13cmos5l_decap_4
XFILLER_42_768 VPWR VGND sg13cmos5l_decap_4
XFILLER_6_636 VPWR VGND sg13cmos5l_decap_8
XFILLER_2_820 VPWR VGND sg13cmos5l_fill_1
XFILLER_2_864 VPWR VGND sg13cmos5l_fill_1
XFILLER_2_897 VPWR VGND sg13cmos5l_decap_8
XFILLER_49_334 VPWR VGND sg13cmos5l_fill_2
X_4054__330 _4054_/RESET_B VPWR VGND sg13cmos5l_tiehi
XFILLER_45_562 VPWR VGND sg13cmos5l_decap_4
XFILLER_45_595 VPWR VGND sg13cmos5l_decap_8
XFILLER_32_201 VPWR VGND sg13cmos5l_fill_2
XFILLER_21_919 VPWR VGND sg13cmos5l_decap_4
XFILLER_32_234 VPWR VGND sg13cmos5l_fill_2
XFILLER_32_245 VPWR VGND sg13cmos5l_decap_4
X_3750_ _3751_/B _4344_/Q _3749_/X _3747_/Y VPWR VGND sg13cmos5l_o21ai_1
XFILLER_20_418 VPWR VGND sg13cmos5l_decap_8
X_2701_ _2701_/X _4031_/Q _4014_/Q _2701_/S VPWR VGND sg13cmos5l_mux2_1
XFILLER_9_441 VPWR VGND sg13cmos5l_decap_8
X_3681_ _4334_/D _3681_/A _3681_/B _3681_/C VPWR VGND sg13cmos5l_nor3_1
X_2632_ _2632_/X _4038_/Q _4021_/Q _2632_/S VPWR VGND sg13cmos5l_mux2_1
X_2563_ _2563_/Y _2566_/A _2757_/A _2562_/Y VPWR VGND sg13cmos5l_o21ai_1
X_4061__323 _4061_/RESET_B VPWR VGND sg13cmos5l_tiehi
X_4302_ _4302_/Q _4302_/CLK _4302_/D _4302_/RESET_B VPWR VGND sg13cmos5l_dfrbpq_1
X_4233_ _4233_/Q _4234_/CLK _4233_/D _4233_/RESET_B VPWR VGND sg13cmos5l_dfrbpq_1
XFILLER_4_50 VPWR VGND sg13cmos5l_decap_4
X_2494_ _2495_/B _2324_/A _2474_/A _2501_/A VPWR VGND sg13cmos5l_o21ai_1
X_4164_ _4164_/Q _4209_/CLK _4164_/D _4164_/RESET_B VPWR VGND sg13cmos5l_dfrbpq_1
X_4095_ _4095_/Q clkload8/A _4095_/D _4095_/RESET_B VPWR VGND sg13cmos5l_dfrbpq_1
X_3115_ _3115_/X _3115_/A _3115_/B _3115_/C VPWR VGND sg13cmos5l_or3_1
XFILLER_49_890 VPWR VGND sg13cmos5l_decap_8
X_3046_ _3046_/Y _4222_/Q _3046_/B VPWR VGND sg13cmos5l_nand2b_1
XFILLER_36_595 VPWR VGND sg13cmos5l_decap_8
XFILLER_24_746 VPWR VGND sg13cmos5l_fill_2
XFILLER_24_779 VPWR VGND sg13cmos5l_decap_4
X_3948_ _3999_/D _3971_/A0 hold798/X _3948_/S VPWR VGND sg13cmos5l_mux2_1
XFILLER_20_930 VPWR VGND sg13cmos5l_decap_8
X_3879_ _4361_/D _3879_/A _3879_/B _3879_/C VPWR VGND sg13cmos5l_nor3_1
XFILLER_24_1003 VPWR VGND sg13cmos5l_decap_8
XFILLER_48_56 VPWR VGND sg13cmos5l_decap_8
XFILLER_46_315 VPWR VGND sg13cmos5l_fill_2
XFILLER_47_849 VPWR VGND sg13cmos5l_decap_8
XFILLER_15_702 VPWR VGND sg13cmos5l_decap_8
XFILLER_42_565 VPWR VGND sg13cmos5l_fill_1
XFILLER_42_554 VPWR VGND sg13cmos5l_decap_8
XFILLER_15_757 VPWR VGND sg13cmos5l_decap_8
XFILLER_15_768 VPWR VGND sg13cmos5l_fill_1
Xfanout60 _2289_/B hold945/X VPWR VGND sg13cmos5l_buf_1
Xfanout82 _2704_/A1 _2690_/A1 VPWR VGND sg13cmos5l_buf_1
Xfanout71 _2607_/A _4137_/Q VPWR VGND sg13cmos5l_buf_1
Xfanout93 _2687_/S _2706_/S0 VPWR VGND sg13cmos5l_buf_1
XFILLER_11_963 VPWR VGND sg13cmos5l_decap_8
XFILLER_7_956 VPWR VGND sg13cmos5l_decap_8
XFILLER_6_444 VPWR VGND sg13cmos5l_decap_8
XFILLER_10_473 VPWR VGND sg13cmos5l_decap_8
XFILLER_13_70 VPWR VGND sg13cmos5l_decap_8
XFILLER_6_488 VPWR VGND sg13cmos5l_decap_8
XFILLER_2_683 VPWR VGND sg13cmos5l_fill_1
XFILLER_49_120 VPWR VGND sg13cmos5l_decap_8
XFILLER_49_175 VPWR VGND sg13cmos5l_decap_8
XFILLER_38_838 VPWR VGND sg13cmos5l_fill_1
XFILLER_18_573 VPWR VGND sg13cmos5l_fill_2
XFILLER_45_392 VPWR VGND sg13cmos5l_decap_8
X_3802_ _3802_/X _3802_/A _3802_/B VPWR VGND sg13cmos5l_xor2_1
X_3733_ _3733_/Y _3733_/A _3733_/B VPWR VGND sg13cmos5l_nor2_1
X_3664_ _3664_/Y _3656_/B _3656_/C _3656_/A VPWR VGND sg13cmos5l_a21oi_1
X_2615_ _2615_/Y _2657_/A1 _2613_/Y _2614_/Y _2611_/Y _2659_/A VPWR VGND sg13cmos5l_a221oi_1
XFILLER_47_1003 VPWR VGND sg13cmos5l_decap_8
X_3595_ _3596_/C _3605_/B _3595_/B VPWR VGND sg13cmos5l_nor2_1
X_4323__398 _4323_/RESET_B VPWR VGND sg13cmos5l_tiehi
X_2546_ _4138_/D _4370_/D _2546_/B _2549_/A _2546_/D VPWR VGND sg13cmos5l_nor4_1
X_2477_ _2486_/A _4121_/Q _2484_/B VPWR VGND sg13cmos5l_nand2_1
X_4216_ _4216_/Q _4238_/CLK _4216_/D _4216_/RESET_B VPWR VGND sg13cmos5l_dfrbpq_1
X_4137__224 _4137_/RESET_B VPWR VGND sg13cmos5l_tiehi
X_4147_ _4147_/Q _4378_/CLK _4147_/D _4147_/RESET_B VPWR VGND sg13cmos5l_dfrbpq_1
X_4078_ _4078_/Q clkload8/A _4078_/D _4078_/RESET_B VPWR VGND sg13cmos5l_dfrbpq_1
XFILLER_37_871 VPWR VGND sg13cmos5l_decap_4
X_3029_ _4216_/D _3029_/A _3107_/A VPWR VGND sg13cmos5l_nor2_1
XFILLER_34_14 VPWR VGND sg13cmos5l_decap_8
Xclkload2 clkload2/Y clkload2/A VPWR VGND sg13cmos5l_inv_1
X_4044__340 _4044_/RESET_B VPWR VGND sg13cmos5l_tiehi
XFILLER_3_447 VPWR VGND sg13cmos5l_decap_8
XFILLER_47_613 VPWR VGND sg13cmos5l_fill_2
XFILLER_47_624 VPWR VGND sg13cmos5l_decap_8
XFILLER_19_315 VPWR VGND sg13cmos5l_fill_2
XFILLER_43_830 VPWR VGND sg13cmos5l_decap_8
XFILLER_43_863 VPWR VGND sg13cmos5l_decap_8
XFILLER_42_340 VPWR VGND sg13cmos5l_decap_8
X_4051__333 _4051_/RESET_B VPWR VGND sg13cmos5l_tiehi
XFILLER_6_230 VPWR VGND sg13cmos5l_decap_8
Xhold709 hold709/X _4000_/Q VPWR VGND sg13cmos5l_dlygate4sd3_1
X_2400_ _4076_/D input5/X hold674/X _2400_/S VPWR VGND sg13cmos5l_mux2_1
X_3380_ _3380_/Y _3380_/A _3380_/B VPWR VGND sg13cmos5l_nand2_1
XFILLER_3_992 VPWR VGND sg13cmos5l_decap_8
X_2331_ _4020_/D _3954_/A hold706/X _2336_/B VPWR VGND sg13cmos5l_mux2_1
X_2262_ _2262_/Y _2262_/A VPWR VGND sg13cmos5l_inv_1
X_4001_ _4001_/Q clkload4/A _4001_/D _4001_/RESET_B VPWR VGND sg13cmos5l_dfrbpq_1
XFILLER_37_112 VPWR VGND sg13cmos5l_decap_8
XFILLER_1_73 VPWR VGND sg13cmos5l_decap_8
X_4253__481 _4253_/RESET_B VPWR VGND sg13cmos5l_tiehi
XFILLER_18_381 VPWR VGND sg13cmos5l_decap_8
XFILLER_34_830 VPWR VGND sg13cmos5l_decap_8
XFILLER_34_852 VPWR VGND sg13cmos5l_fill_2
XFILLER_33_384 VPWR VGND sg13cmos5l_fill_1
X_3716_ _3733_/B _3716_/A _3716_/B VPWR VGND sg13cmos5l_and2_1
X_3647_ _3647_/X _3668_/A _3647_/B VPWR VGND sg13cmos5l_and2_1
X_3578_ _3578_/Y _3574_/Y _3576_/Y _3577_/Y VPWR VGND sg13cmos5l_o21ai_1
XFILLER_0_406 VPWR VGND sg13cmos5l_decap_8
XFILLER_0_417 VPWR VGND sg13cmos5l_fill_2
XFILLER_1_929 VPWR VGND sg13cmos5l_decap_8
X_2529_ _2529_/Y _3897_/A _2529_/B VPWR VGND sg13cmos5l_nand2_1
XFILLER_29_25 VPWR VGND sg13cmos5l_fill_2
XFILLER_45_46 VPWR VGND sg13cmos5l_fill_2
XFILLER_43_104 VPWR VGND sg13cmos5l_fill_2
XFILLER_45_79 VPWR VGND sg13cmos5l_decap_8
XFILLER_45_68 VPWR VGND sg13cmos5l_fill_1
XFILLER_43_159 VPWR VGND sg13cmos5l_decap_4
XFILLER_43_137 VPWR VGND sg13cmos5l_decap_4
XFILLER_25_852 VPWR VGND sg13cmos5l_decap_4
XFILLER_40_800 VPWR VGND sg13cmos5l_decap_8
XFILLER_25_874 VPWR VGND sg13cmos5l_fill_2
XFILLER_40_822 VPWR VGND sg13cmos5l_decap_8
XFILLER_24_373 VPWR VGND sg13cmos5l_fill_2
XFILLER_40_877 VPWR VGND sg13cmos5l_fill_1
XFILLER_4_723 VPWR VGND sg13cmos5l_decap_8
XFILLER_48_922 VPWR VGND sg13cmos5l_decap_8
XFILLER_0_984 VPWR VGND sg13cmos5l_decap_8
XFILLER_19_134 VPWR VGND sg13cmos5l_fill_1
XFILLER_48_999 VPWR VGND sg13cmos5l_decap_8
XFILLER_47_476 VPWR VGND sg13cmos5l_decap_8
XFILLER_37_1024 VPWR VGND sg13cmos5l_decap_4
XFILLER_15_362 VPWR VGND sg13cmos5l_decap_4
X_2880_ _4189_/D _2918_/B _2941_/B VPWR VGND sg13cmos5l_nor2_1
XFILLER_31_822 VPWR VGND sg13cmos5l_fill_1
XFILLER_30_354 VPWR VGND sg13cmos5l_fill_1
XFILLER_31_877 VPWR VGND sg13cmos5l_fill_1
X_3501_ _3502_/C _3501_/A _3500_/A VPWR VGND sg13cmos5l_nor2b_1
X_3432_ _3432_/Y _4289_/Q _3781_/A2 _2913_/A VPWR VGND sg13cmos5l_o21ai_1
X_3363_ _3487_/A _3451_/A VPWR VGND sg13cmos5l_inv_1
X_2314_ _2539_/A _2473_/A _2315_/A VPWR VGND sg13cmos5l_nand2b_1
X_3294_ _3294_/X _3295_/B _3295_/C VPWR VGND sg13cmos5l_and2_1
X_2245_ _3752_/A _4360_/Q VPWR VGND sg13cmos5l_inv_1
Xheichips26_dna_sequencer_144 uio_out[4] VPWR VGND sg13cmos5l_tielo
Xheichips26_dna_sequencer_133 uio_oe[1] VPWR VGND sg13cmos5l_tielo
XFILLER_39_977 VPWR VGND sg13cmos5l_decap_8
XFILLER_38_432 VPWR VGND sg13cmos5l_fill_1
XFILLER_25_104 VPWR VGND sg13cmos5l_decap_4
X_4034__350 _4034_/RESET_B VPWR VGND sg13cmos5l_tiehi
XFILLER_22_811 VPWR VGND sg13cmos5l_fill_1
Xoutput15 uo_out[1] _4115_/Q VPWR VGND sg13cmos5l_buf_1
X_4041__343 _4041_/RESET_B VPWR VGND sg13cmos5l_tiehi
XFILLER_0_214 VPWR VGND sg13cmos5l_decap_8
XFILLER_29_421 VPWR VGND sg13cmos5l_decap_4
XFILLER_45_903 VPWR VGND sg13cmos5l_decap_8
XFILLER_44_479 VPWR VGND sg13cmos5l_decap_4
XFILLER_13_811 VPWR VGND sg13cmos5l_decap_4
XFILLER_40_641 VPWR VGND sg13cmos5l_fill_2
XFILLER_8_314 VPWR VGND sg13cmos5l_fill_2
XFILLER_9_859 VPWR VGND sg13cmos5l_decap_8
XFILLER_13_888 VPWR VGND sg13cmos5l_decap_8
XFILLER_8_358 VPWR VGND sg13cmos5l_fill_2
X_4243__491 _4243_/RESET_B VPWR VGND sg13cmos5l_tiehi
X_4161__191 _4161_/RESET_B VPWR VGND sg13cmos5l_tiehi
XFILLER_4_553 VPWR VGND sg13cmos5l_fill_1
XFILLER_48_796 VPWR VGND sg13cmos5l_decap_8
XFILLER_47_273 VPWR VGND sg13cmos5l_fill_1
XFILLER_36_947 VPWR VGND sg13cmos5l_decap_8
XFILLER_47_284 VPWR VGND sg13cmos5l_decap_8
X_4250__484 _4250_/RESET_B VPWR VGND sg13cmos5l_tiehi
X_3981_ _3981_/Q _4181_/CLK _3981_/D _3981_/RESET_B VPWR VGND sg13cmos5l_dfrbpq_1
X_2932_ _2938_/C _4198_/Q _4175_/Q _4203_/Q VPWR VGND sg13cmos5l_nand3_1
X_2863_ _2863_/Y _4161_/Q _4162_/Q VPWR VGND sg13cmos5l_xnor2_1
XFILLER_30_140 VPWR VGND sg13cmos5l_fill_2
XFILLER_30_151 VPWR VGND sg13cmos5l_fill_1
XFILLER_11_1005 VPWR VGND sg13cmos5l_decap_8
X_2794_ _2802_/A _2794_/A _2800_/B VPWR VGND sg13cmos5l_or2_1
XFILLER_7_72 VPWR VGND sg13cmos5l_fill_1
X_3415_ _3415_/Y _4284_/Q _3410_/Y _3407_/Y VPWR VGND sg13cmos5l_o21ai_1
X_3346_ _3357_/D _3336_/Y _3342_/Y _3345_/Y VPWR VGND sg13cmos5l_o21ai_1
Xhold1014 _3364_/B _3451_/A VPWR VGND sg13cmos5l_dlygate4sd3_1
Xhold1003 _3384_/C1 _4246_/Q VPWR VGND sg13cmos5l_dlygate4sd3_1
XFILLER_39_730 VPWR VGND sg13cmos5l_decap_4
X_3277_ _3306_/B _3275_/Y _3276_/Y _3274_/Y VPWR VGND sg13cmos5l_a21oi_1
XFILLER_27_903 VPWR VGND sg13cmos5l_fill_2
Xhold1025 _2401_/A _4129_/Q VPWR VGND sg13cmos5l_dlygate4sd3_1
X_2228_ _2228_/Y _2228_/A VPWR VGND sg13cmos5l_inv_1
XFILLER_26_446 VPWR VGND sg13cmos5l_decap_4
XFILLER_10_803 VPWR VGND sg13cmos5l_fill_2
XFILLER_21_151 VPWR VGND sg13cmos5l_decap_8
Xhold881 hold881/X _2554_/B VPWR VGND sg13cmos5l_dlygate4sd3_1
Xhold870 _3064_/B _4223_/Q VPWR VGND sg13cmos5l_dlygate4sd3_1
XFILLER_27_1001 VPWR VGND sg13cmos5l_decap_8
XFILLER_49_505 VPWR VGND sg13cmos5l_decap_4
Xhold892 _3429_/B _4286_/Q VPWR VGND sg13cmos5l_dlygate4sd3_1
XFILLER_44_232 VPWR VGND sg13cmos5l_decap_8
XFILLER_45_777 VPWR VGND sg13cmos5l_decap_8
Xclkbuf_leaf_24_clk clkload6/A clkbuf_leaf_4_clk/A VPWR VGND sg13cmos5l_buf_8
XFILLER_41_983 VPWR VGND sg13cmos5l_decap_8
XFILLER_40_471 VPWR VGND sg13cmos5l_fill_2
XFILLER_9_612 VPWR VGND sg13cmos5l_decap_8
XFILLER_12_151 VPWR VGND sg13cmos5l_decap_8
XFILLER_13_685 VPWR VGND sg13cmos5l_decap_8
XFILLER_34_1027 VPWR VGND sg13cmos5l_fill_2
XFILLER_8_177 VPWR VGND sg13cmos5l_decap_4
XFILLER_5_840 VPWR VGND sg13cmos5l_decap_8
X_4378__206 _4378_/RESET_B VPWR VGND sg13cmos5l_tiehi
X_4024__360 _4024_/RESET_B VPWR VGND sg13cmos5l_tiehi
X_4180_ _4180_/Q _4181_/CLK _4180_/D _4180_/RESET_B VPWR VGND sg13cmos5l_dfrbpq_1
X_3200_ _3201_/A _3200_/A _3200_/B VPWR VGND sg13cmos5l_or2_1
X_3131_ _3131_/Y _4272_/Q _3131_/B VPWR VGND sg13cmos5l_xnor2_1
XFILLER_36_711 VPWR VGND sg13cmos5l_decap_4
X_3062_ _3062_/Y hold920/X _3059_/B _3123_/A VPWR VGND sg13cmos5l_o21ai_1
XFILLER_36_733 VPWR VGND sg13cmos5l_decap_8
X_4031__353 _4031_/RESET_B VPWR VGND sg13cmos5l_tiehi
X_3964_ _4009_/D _3964_/A0 hold716/X _3971_/S VPWR VGND sg13cmos5l_mux2_1
Xclkbuf_leaf_15_clk _4272_/CLK clkload1/A VPWR VGND sg13cmos5l_buf_8
XFILLER_32_961 VPWR VGND sg13cmos5l_decap_8
X_3895_ _4366_/D _3916_/A _3895_/B VPWR VGND sg13cmos5l_nor2_1
X_2915_ _4202_/D _2915_/A _2962_/A VPWR VGND sg13cmos5l_and2_1
X_2846_ _2847_/B _3076_/A _2846_/B VPWR VGND sg13cmos5l_nand2_1
X_4168__175 _4168_/D VPWR VGND sg13cmos5l_tielo
X_2777_ _4167_/D _2740_/Y hold910/X _2818_/A VPWR VGND sg13cmos5l_a21oi_1
X_4378_ _4378_/Q _4378_/CLK _4378_/D _4378_/RESET_B VPWR VGND sg13cmos5l_dfrbpq_1
X_3329_ _3339_/B _4301_/Q _4302_/Q VPWR VGND sg13cmos5l_nor2_1
XFILLER_27_722 VPWR VGND sg13cmos5l_fill_2
XFILLER_41_202 VPWR VGND sg13cmos5l_decap_4
XFILLER_26_265 VPWR VGND sg13cmos5l_decap_4
XFILLER_26_276 VPWR VGND sg13cmos5l_decap_8
XFILLER_41_279 VPWR VGND sg13cmos5l_decap_8
XFILLER_10_611 VPWR VGND sg13cmos5l_decap_8
XFILLER_22_460 VPWR VGND sg13cmos5l_decap_8
XFILLER_5_136 VPWR VGND sg13cmos5l_decap_8
XFILLER_10_688 VPWR VGND sg13cmos5l_decap_4
XFILLER_2_876 VPWR VGND sg13cmos5l_decap_8
X_4240__494 _4240_/RESET_B VPWR VGND sg13cmos5l_tiehi
XFILLER_1_386 VPWR VGND sg13cmos5l_decap_4
XFILLER_49_346 VPWR VGND sg13cmos5l_decap_8
XFILLER_17_254 VPWR VGND sg13cmos5l_fill_2
XFILLER_17_287 VPWR VGND sg13cmos5l_fill_1
XFILLER_14_994 VPWR VGND sg13cmos5l_decap_8
X_2700_ _2700_/Y _2696_/Y _2697_/Y _2699_/Y _2700_/B2 _2707_/A VPWR VGND sg13cmos5l_a221oi_1
XFILLER_13_482 VPWR VGND sg13cmos5l_decap_8
XFILLER_13_493 VPWR VGND sg13cmos5l_fill_1
X_3680_ _3681_/C _3680_/A _3661_/X VPWR VGND sg13cmos5l_nor2b_1
X_2631_ _2631_/Y _2627_/Y _2628_/Y _2630_/Y _2667_/B2 _2300_/A VPWR VGND sg13cmos5l_a221oi_1
X_2562_ _2562_/Y _2804_/A _2566_/B _2561_/Y VPWR VGND sg13cmos5l_a21oi_1
X_4301_ _4301_/Q _4303_/CLK _4301_/D _4301_/RESET_B VPWR VGND sg13cmos5l_dfrbpq_1
X_4232_ _4232_/Q _4234_/CLK _4232_/D _4232_/RESET_B VPWR VGND sg13cmos5l_dfrbpq_1
X_2493_ _2493_/Y hold829/X _2491_/Y _2492_/Y VPWR VGND sg13cmos5l_a21oi_1
Xclkbuf_leaf_4_clk clkload4/A clkbuf_leaf_4_clk/A VPWR VGND sg13cmos5l_buf_8
X_4163_ _4163_/Q _4209_/CLK _4163_/D _4163_/RESET_B VPWR VGND sg13cmos5l_dfrbpq_1
XFILLER_28_508 VPWR VGND sg13cmos5l_decap_4
X_4094_ _4094_/Q _4128_/CLK _4094_/D _4094_/RESET_B VPWR VGND sg13cmos5l_dfrbpq_1
X_3114_ _3115_/C _3114_/A _3114_/B _3114_/C VPWR VGND sg13cmos5l_and3_1
X_3045_ _3045_/Y _3046_/B VPWR VGND sg13cmos5l_inv_1
XFILLER_48_390 VPWR VGND sg13cmos5l_fill_2
XFILLER_24_758 VPWR VGND sg13cmos5l_decap_8
XFILLER_17_1011 VPWR VGND sg13cmos5l_decap_8
X_3947_ _3947_/Y _2263_/Y _3946_/B _3946_/Y VPWR VGND sg13cmos5l_a21oi_1
XFILLER_23_49 VPWR VGND sg13cmos5l_decap_4
X_3878_ _3879_/C _3877_/A _3877_/C _3865_/A VPWR VGND sg13cmos5l_a21oi_1
XFILLER_20_986 VPWR VGND sg13cmos5l_decap_4
X_2829_ _2829_/Y _3076_/A _4183_/Q VPWR VGND sg13cmos5l_nand2_1
XFILLER_2_106 VPWR VGND sg13cmos5l_decap_8
XFILLER_2_139 VPWR VGND sg13cmos5l_decap_8
XFILLER_48_35 VPWR VGND sg13cmos5l_decap_8
XFILLER_47_828 VPWR VGND sg13cmos5l_decap_8
XFILLER_46_349 VPWR VGND sg13cmos5l_decap_8
XFILLER_46_327 VPWR VGND sg13cmos5l_decap_4
XFILLER_39_390 VPWR VGND sg13cmos5l_fill_2
XFILLER_27_596 VPWR VGND sg13cmos5l_fill_1
XFILLER_42_533 VPWR VGND sg13cmos5l_decap_8
XFILLER_15_747 VPWR VGND sg13cmos5l_fill_1
Xfanout83 _2690_/A1 _2706_/S1 VPWR VGND sg13cmos5l_buf_1
Xfanout50 _3620_/B _3505_/Y VPWR VGND sg13cmos5l_buf_1
XFILLER_11_942 VPWR VGND sg13cmos5l_decap_8
Xfanout61 _3881_/A hold1021/X VPWR VGND sg13cmos5l_buf_1
Xfanout72 _2500_/B hold966/X VPWR VGND sg13cmos5l_buf_1
XFILLER_7_935 VPWR VGND sg13cmos5l_decap_8
XFILLER_10_430 VPWR VGND sg13cmos5l_decap_8
XFILLER_10_441 VPWR VGND sg13cmos5l_fill_2
Xfanout94 _2701_/S _2706_/S0 VPWR VGND sg13cmos5l_buf_1
XFILLER_2_695 VPWR VGND sg13cmos5l_decap_8
X_4021__363 _4021_/RESET_B VPWR VGND sg13cmos5l_tiehi
XFILLER_49_154 VPWR VGND sg13cmos5l_decap_8
XFILLER_38_806 VPWR VGND sg13cmos5l_decap_8
XFILLER_37_327 VPWR VGND sg13cmos5l_decap_8
XFILLER_46_894 VPWR VGND sg13cmos5l_decap_8
X_3801_ _3852_/B _3804_/A _3801_/B VPWR VGND sg13cmos5l_nor2_1
XFILLER_14_791 VPWR VGND sg13cmos5l_decap_8
XFILLER_33_599 VPWR VGND sg13cmos5l_fill_2
X_3732_ _4340_/D _3879_/A _3859_/A VPWR VGND sg13cmos5l_nor2_1
Xclkload20 clkload20/X _4238_/CLK VPWR VGND sg13cmos5l_buf_8
X_3663_ _3679_/A _3625_/B _3631_/X _3662_/Y VPWR VGND sg13cmos5l_a21oi_1
XFILLER_9_283 VPWR VGND sg13cmos5l_fill_2
X_2614_ _2614_/Y _2647_/A _4017_/Q _2657_/A1 VPWR VGND sg13cmos5l_a21oi_1
X_3594_ _3596_/B _4317_/Q _3583_/Y _3595_/B _3605_/B _3592_/Y VPWR VGND sg13cmos5l_a221oi_1
X_2545_ _2546_/D _2441_/B _2544_/A hold844/X VPWR VGND sg13cmos5l_a21oi_1
X_2476_ _4120_/D _2480_/A _2481_/A _2475_/Y VPWR VGND sg13cmos5l_a21oi_1
X_4215_ _4215_/Q _4238_/CLK _4215_/D _4215_/RESET_B VPWR VGND sg13cmos5l_dfrbpq_1
X_4146_ _4146_/Q _4161_/CLK _4146_/D _4146_/RESET_B VPWR VGND sg13cmos5l_dfrbpq_1
XFILLER_18_38 VPWR VGND sg13cmos5l_decap_4
X_4077_ _4077_/Q _4128_/CLK _4077_/D _4077_/RESET_B VPWR VGND sg13cmos5l_dfrbpq_1
X_3028_ _3107_/A _3096_/C _3096_/D VPWR VGND sg13cmos5l_and2_1
XFILLER_37_894 VPWR VGND sg13cmos5l_decap_8
XFILLER_24_533 VPWR VGND sg13cmos5l_decap_4
Xclkload3 clkload3/Y clkload3/A VPWR VGND sg13cmos5l_inv_1
XFILLER_20_761 VPWR VGND sg13cmos5l_decap_8
XFILLER_4_949 VPWR VGND sg13cmos5l_decap_8
XFILLER_3_426 VPWR VGND sg13cmos5l_decap_8
XFILLER_47_603 VPWR VGND sg13cmos5l_fill_1
XFILLER_46_113 VPWR VGND sg13cmos5l_fill_2
XFILLER_35_809 VPWR VGND sg13cmos5l_fill_2
XFILLER_15_500 VPWR VGND sg13cmos5l_decap_8
XFILLER_28_894 VPWR VGND sg13cmos5l_decap_8
XFILLER_34_308 VPWR VGND sg13cmos5l_decap_8
XFILLER_34_319 VPWR VGND sg13cmos5l_fill_2
XFILLER_43_842 VPWR VGND sg13cmos5l_decap_8
XFILLER_42_374 VPWR VGND sg13cmos5l_decap_8
XFILLER_30_547 VPWR VGND sg13cmos5l_decap_4
XFILLER_24_81 VPWR VGND sg13cmos5l_decap_8
XFILLER_7_787 VPWR VGND sg13cmos5l_decap_4
XFILLER_6_286 VPWR VGND sg13cmos5l_decap_4
XFILLER_3_971 VPWR VGND sg13cmos5l_decap_8
X_2330_ _4019_/D _3952_/A hold749/X _2336_/B VPWR VGND sg13cmos5l_mux2_1
X_2261_ _2261_/Y _2707_/A VPWR VGND sg13cmos5l_inv_1
X_4000_ _4000_/Q clkload3/A _4000_/D _4000_/RESET_B VPWR VGND sg13cmos5l_dfrbpq_1
XFILLER_33_363 VPWR VGND sg13cmos5l_decap_8
X_3715_ _3716_/B _3715_/A _3715_/B VPWR VGND sg13cmos5l_nand2_1
X_3646_ _3647_/B _4330_/Q _3667_/B VPWR VGND sg13cmos5l_or2_1
X_3577_ _3577_/Y _4336_/Q _3429_/A _4286_/Q _3785_/A VPWR VGND sg13cmos5l_a22oi_1
XFILLER_1_908 VPWR VGND sg13cmos5l_decap_8
X_2528_ _2529_/B _4373_/Q _2528_/B VPWR VGND sg13cmos5l_nand2_1
X_2459_ _2462_/A hold829/X _2293_/A _2454_/Y VPWR VGND sg13cmos5l_a21oi_1
XFILLER_28_113 VPWR VGND sg13cmos5l_decap_8
XFILLER_44_606 VPWR VGND sg13cmos5l_fill_2
XFILLER_28_135 VPWR VGND sg13cmos5l_fill_1
X_4129_ _4129_/Q clkload4/A _4129_/D _4129_/RESET_B VPWR VGND sg13cmos5l_dfrbpq_1
XFILLER_43_149 VPWR VGND sg13cmos5l_fill_1
XFILLER_25_831 VPWR VGND sg13cmos5l_decap_8
XFILLER_25_864 VPWR VGND sg13cmos5l_fill_1
XFILLER_8_507 VPWR VGND sg13cmos5l_decap_4
XFILLER_3_223 VPWR VGND sg13cmos5l_fill_1
XFILLER_4_779 VPWR VGND sg13cmos5l_decap_4
XFILLER_10_61 VPWR VGND sg13cmos5l_fill_2
XFILLER_10_83 VPWR VGND sg13cmos5l_fill_1
XFILLER_48_901 VPWR VGND sg13cmos5l_decap_8
XFILLER_0_963 VPWR VGND sg13cmos5l_decap_8
X_4194__171 _4194_/D VPWR VGND sg13cmos5l_tielo
XFILLER_48_978 VPWR VGND sg13cmos5l_decap_8
XFILLER_35_606 VPWR VGND sg13cmos5l_fill_1
XFILLER_16_853 VPWR VGND sg13cmos5l_decap_8
XFILLER_28_691 VPWR VGND sg13cmos5l_decap_4
XFILLER_34_138 VPWR VGND sg13cmos5l_fill_1
XFILLER_34_149 VPWR VGND sg13cmos5l_fill_1
XFILLER_43_661 VPWR VGND sg13cmos5l_fill_2
XFILLER_43_650 VPWR VGND sg13cmos5l_decap_8
XFILLER_37_1003 VPWR VGND sg13cmos5l_decap_8
XFILLER_15_341 VPWR VGND sg13cmos5l_decap_8
XFILLER_15_385 VPWR VGND sg13cmos5l_fill_1
XFILLER_30_311 VPWR VGND sg13cmos5l_decap_4
XFILLER_30_366 VPWR VGND sg13cmos5l_decap_4
XFILLER_7_540 VPWR VGND sg13cmos5l_fill_2
X_3500_ _3502_/B _3500_/A _3481_/X VPWR VGND sg13cmos5l_nor2b_1
XFILLER_30_399 VPWR VGND sg13cmos5l_fill_1
XFILLER_7_584 VPWR VGND sg13cmos5l_decap_4
X_3431_ _4288_/D _3607_/A _3431_/B VPWR VGND sg13cmos5l_and2_1
X_3362_ _3451_/A _3357_/B _3340_/Y _3361_/A VPWR VGND sg13cmos5l_a21oi_1
X_2313_ _2315_/B _2473_/A _3882_/B VPWR VGND sg13cmos5l_nor2_1
XFILLER_39_912 VPWR VGND sg13cmos5l_fill_2
X_3293_ _3295_/C _3293_/A _3293_/B _3293_/C VPWR VGND sg13cmos5l_nand3_1
X_2244_ _3756_/A _4361_/Q VPWR VGND sg13cmos5l_inv_1
Xheichips26_dna_sequencer_145 uio_out[5] VPWR VGND sg13cmos5l_tielo
Xheichips26_dna_sequencer_134 uio_oe[2] VPWR VGND sg13cmos5l_tielo
XFILLER_39_956 VPWR VGND sg13cmos5l_decap_8
XFILLER_38_477 VPWR VGND sg13cmos5l_fill_1
XFILLER_25_138 VPWR VGND sg13cmos5l_fill_2
XFILLER_15_39 VPWR VGND sg13cmos5l_decap_8
XFILLER_34_661 VPWR VGND sg13cmos5l_fill_2
XFILLER_40_119 VPWR VGND sg13cmos5l_decap_8
XFILLER_22_823 VPWR VGND sg13cmos5l_fill_2
XFILLER_22_845 VPWR VGND sg13cmos5l_decap_8
XFILLER_22_856 VPWR VGND sg13cmos5l_fill_2
X_3629_ _3629_/Y _3625_/A _3625_/B _3628_/Y VPWR VGND sg13cmos5l_o21ai_1
Xoutput16 uo_out[2] _4116_/Q VPWR VGND sg13cmos5l_buf_1
XFILLER_0_259 VPWR VGND sg13cmos5l_decap_8
XFILLER_29_444 VPWR VGND sg13cmos5l_fill_2
XFILLER_45_959 VPWR VGND sg13cmos5l_decap_8
X_3991__472 _3991_/RESET_B VPWR VGND sg13cmos5l_tiehi
XFILLER_12_333 VPWR VGND sg13cmos5l_decap_8
XFILLER_13_845 VPWR VGND sg13cmos5l_decap_4
XFILLER_13_867 VPWR VGND sg13cmos5l_decap_8
XFILLER_24_182 VPWR VGND sg13cmos5l_fill_2
XFILLER_24_193 VPWR VGND sg13cmos5l_decap_4
X_3987__508 _3987_/RESET_B VPWR VGND sg13cmos5l_tiehi
XFILLER_9_838 VPWR VGND sg13cmos5l_decap_8
XFILLER_12_366 VPWR VGND sg13cmos5l_decap_8
XFILLER_36_904 VPWR VGND sg13cmos5l_decap_8
XFILLER_48_775 VPWR VGND sg13cmos5l_decap_8
XFILLER_35_403 VPWR VGND sg13cmos5l_fill_1
X_3980_ _3980_/Q _4161_/CLK _3980_/D _3980_/RESET_B VPWR VGND sg13cmos5l_dfrbpq_1
XFILLER_44_981 VPWR VGND sg13cmos5l_decap_8
X_2931_ _2938_/B _4202_/Q _2948_/B VPWR VGND sg13cmos5l_nand2_1
Xclkbuf_0_clk clkbuf_0_clk/X clk VPWR VGND sg13cmos5l_buf_8
X_2862_ _2862_/Y _4179_/Q _4161_/Q VPWR VGND sg13cmos5l_nor2_1
X_2793_ _2800_/B _2791_/Y _2792_/Y _2806_/A VPWR VGND sg13cmos5l_a21oi_1
XFILLER_11_1028 VPWR VGND sg13cmos5l_fill_1
XFILLER_7_381 VPWR VGND sg13cmos5l_decap_8
XFILLER_7_370 VPWR VGND sg13cmos5l_fill_2
X_3414_ _3414_/Y _4284_/Q _3410_/Y _3413_/Y _4283_/Q VPWR VGND sg13cmos5l_a22oi_1
X_3345_ _3345_/Y _3360_/A _3340_/Y _3360_/B VPWR VGND sg13cmos5l_a21oi_1
Xhold1004 _3385_/B1 _3384_/Y VPWR VGND sg13cmos5l_dlygate4sd3_1
Xhold1015 _2306_/B _4365_/Q VPWR VGND sg13cmos5l_dlygate4sd3_1
X_3276_ _3276_/Y _4258_/Q _4230_/Q VPWR VGND sg13cmos5l_xnor2_1
Xhold1026 hold1026/X _4349_/Q VPWR VGND sg13cmos5l_dlygate4sd3_1
X_2227_ _2227_/Y _2227_/A VPWR VGND sg13cmos5l_inv_1
XFILLER_27_915 VPWR VGND sg13cmos5l_fill_1
XFILLER_26_16 VPWR VGND sg13cmos5l_decap_8
XFILLER_26_27 VPWR VGND sg13cmos5l_fill_2
XFILLER_26_38 VPWR VGND sg13cmos5l_fill_1
XFILLER_22_620 VPWR VGND sg13cmos5l_fill_1
XFILLER_5_318 VPWR VGND sg13cmos5l_decap_8
Xhold882 _2565_/B _2564_/Y VPWR VGND sg13cmos5l_dlygate4sd3_1
XFILLER_1_513 VPWR VGND sg13cmos5l_decap_4
Xhold871 hold871/X _3064_/Y VPWR VGND sg13cmos5l_dlygate4sd3_1
Xhold860 _3256_/A _4236_/Q VPWR VGND sg13cmos5l_dlygate4sd3_1
Xhold893 hold893/X _3429_/Y VPWR VGND sg13cmos5l_dlygate4sd3_1
XFILLER_18_926 VPWR VGND sg13cmos5l_decap_4
XFILLER_45_723 VPWR VGND sg13cmos5l_fill_1
XFILLER_17_436 VPWR VGND sg13cmos5l_decap_8
XFILLER_29_285 VPWR VGND sg13cmos5l_fill_2
XFILLER_41_962 VPWR VGND sg13cmos5l_decap_8
XFILLER_13_620 VPWR VGND sg13cmos5l_decap_4
XFILLER_34_1006 VPWR VGND sg13cmos5l_decap_8
XFILLER_8_112 VPWR VGND sg13cmos5l_fill_2
XFILLER_4_373 VPWR VGND sg13cmos5l_fill_1
X_3130_ _3131_/B _4269_/Q _4270_/Q _4271_/Q VPWR VGND sg13cmos5l_nor3_1
X_4354__251 _4354_/RESET_B VPWR VGND sg13cmos5l_tiehi
X_3061_ _4221_/D _3079_/B _3061_/B VPWR VGND sg13cmos5l_nor2_1
XFILLER_48_594 VPWR VGND sg13cmos5l_fill_1
XFILLER_24_918 VPWR VGND sg13cmos5l_decap_8
XFILLER_17_970 VPWR VGND sg13cmos5l_decap_8
XFILLER_35_277 VPWR VGND sg13cmos5l_fill_2
XFILLER_35_288 VPWR VGND sg13cmos5l_decap_8
X_3963_ _3971_/S _3963_/A _3963_/B VPWR VGND sg13cmos5l_nand2_1
X_3894_ _3894_/Y _2306_/A _3892_/Y _3893_/Y VPWR VGND sg13cmos5l_a21oi_1
XFILLER_32_995 VPWR VGND sg13cmos5l_decap_8
X_2914_ _4201_/D _3255_/A _2914_/B VPWR VGND sg13cmos5l_and2_1
X_2845_ _2847_/A _2831_/B _2845_/B VPWR VGND sg13cmos5l_nand2b_1
XFILLER_12_18 VPWR VGND sg13cmos5l_fill_2
X_2776_ _2776_/Y _2776_/A _2776_/B VPWR VGND sg13cmos5l_nand2_1
X_4377_ _4377_/Q _4377_/CLK _4377_/D _4377_/RESET_B VPWR VGND sg13cmos5l_dfrbpq_1
X_3328_ _3357_/C _4274_/Q _4273_/Q _4275_/Q VPWR VGND sg13cmos5l_o21ai_1
XFILLER_27_701 VPWR VGND sg13cmos5l_fill_1
X_3259_ _4266_/D _3259_/A _3260_/B VPWR VGND sg13cmos5l_and2_1
XFILLER_26_200 VPWR VGND sg13cmos5l_fill_1
XFILLER_26_244 VPWR VGND sg13cmos5l_fill_2
XFILLER_27_789 VPWR VGND sg13cmos5l_decap_8
XFILLER_42_759 VPWR VGND sg13cmos5l_decap_4
XFILLER_23_940 VPWR VGND sg13cmos5l_fill_1
X_4229__505 _4229_/RESET_B VPWR VGND sg13cmos5l_tiehi
XFILLER_23_962 VPWR VGND sg13cmos5l_decap_8
XFILLER_22_494 VPWR VGND sg13cmos5l_decap_4
XFILLER_2_855 VPWR VGND sg13cmos5l_decap_8
Xhold690 hold690/X _4070_/Q VPWR VGND sg13cmos5l_dlygate4sd3_1
XFILLER_49_336 VPWR VGND sg13cmos5l_fill_1
XFILLER_49_369 VPWR VGND sg13cmos5l_decap_8
XFILLER_45_531 VPWR VGND sg13cmos5l_decap_8
XFILLER_18_778 VPWR VGND sg13cmos5l_fill_2
XFILLER_32_214 VPWR VGND sg13cmos5l_decap_4
XFILLER_33_715 VPWR VGND sg13cmos5l_fill_2
XFILLER_13_461 VPWR VGND sg13cmos5l_fill_2
XFILLER_14_973 VPWR VGND sg13cmos5l_decap_8
XFILLER_41_781 VPWR VGND sg13cmos5l_decap_8
XFILLER_40_291 VPWR VGND sg13cmos5l_decap_8
X_2630_ _2630_/Y _2629_/A _4055_/Q _2629_/Y VPWR VGND sg13cmos5l_a21oi_1
X_2561_ _2561_/Y _4141_/Q _2561_/B _2561_/C VPWR VGND sg13cmos5l_nor3_1
X_4300_ _4300_/Q _4303_/CLK _4300_/D _4300_/RESET_B VPWR VGND sg13cmos5l_dfrbpq_1
X_2492_ _2492_/Y hold829/X _2491_/Y _2449_/A VPWR VGND sg13cmos5l_o21ai_1
XFILLER_4_192 VPWR VGND sg13cmos5l_decap_8
X_4231_ _4231_/Q _4262_/CLK _4231_/D _4231_/RESET_B VPWR VGND sg13cmos5l_dfrbpq_1
XFILLER_4_85 VPWR VGND sg13cmos5l_fill_1
X_4162_ _4162_/Q _4209_/CLK _4162_/D _4162_/RESET_B VPWR VGND sg13cmos5l_dfrbpq_1
X_3113_ _3113_/Y _3113_/A _3113_/B VPWR VGND sg13cmos5l_nand2_1
X_4093_ _4093_/Q _4136_/CLK _4093_/D _4093_/RESET_B VPWR VGND sg13cmos5l_dfrbpq_1
X_3044_ _3046_/B hold898/X _3047_/C _3043_/Y VPWR VGND sg13cmos5l_o21ai_1
XFILLER_36_564 VPWR VGND sg13cmos5l_decap_8
XFILLER_24_748 VPWR VGND sg13cmos5l_fill_1
XFILLER_23_258 VPWR VGND sg13cmos5l_decap_8
XFILLER_23_269 VPWR VGND sg13cmos5l_fill_2
X_3946_ _3946_/Y _3946_/A _3946_/B VPWR VGND sg13cmos5l_nor2_1
X_3877_ _3879_/B _3877_/A _3877_/B _3877_/C VPWR VGND sg13cmos5l_and3_1
X_2828_ _2828_/X _2833_/A _2833_/B _3016_/A VPWR VGND sg13cmos5l_a21o_1
XFILLER_20_998 VPWR VGND sg13cmos5l_decap_8
X_2759_ _2760_/B _2234_/Y _2765_/B _4179_/Q VPWR VGND sg13cmos5l_o21ai_1
X_4107__277 _4107_/RESET_B VPWR VGND sg13cmos5l_tiehi
XFILLER_3_9 VPWR VGND sg13cmos5l_decap_8
XFILLER_48_14 VPWR VGND sg13cmos5l_decap_8
X_4194__556 _4194_/RESET_B VPWR VGND sg13cmos5l_tiehi
XFILLER_47_807 VPWR VGND sg13cmos5l_decap_8
XFILLER_19_509 VPWR VGND sg13cmos5l_decap_4
XFILLER_46_317 VPWR VGND sg13cmos5l_fill_1
XFILLER_27_531 VPWR VGND sg13cmos5l_decap_8
XFILLER_27_553 VPWR VGND sg13cmos5l_decap_8
XFILLER_42_512 VPWR VGND sg13cmos5l_decap_8
XFILLER_14_269 VPWR VGND sg13cmos5l_decap_8
Xfanout40 _3477_/B _3488_/B VPWR VGND sg13cmos5l_buf_1
Xfanout62 _3748_/B _4359_/Q VPWR VGND sg13cmos5l_buf_1
Xfanout51 _3442_/B _3502_/A VPWR VGND sg13cmos5l_buf_1
XFILLER_23_770 VPWR VGND sg13cmos5l_fill_2
Xfanout73 _2675_/A _2707_/A VPWR VGND sg13cmos5l_buf_1
XFILLER_7_914 VPWR VGND sg13cmos5l_decap_8
XFILLER_6_402 VPWR VGND sg13cmos5l_decap_4
Xfanout84 _2706_/S1 _4112_/Q VPWR VGND sg13cmos5l_buf_1
Xfanout95 _2706_/S0 _2670_/A1 VPWR VGND sg13cmos5l_buf_1
XFILLER_11_998 VPWR VGND sg13cmos5l_decap_8
XFILLER_6_468 VPWR VGND sg13cmos5l_decap_8
XFILLER_2_641 VPWR VGND sg13cmos5l_decap_8
XFILLER_46_873 VPWR VGND sg13cmos5l_decap_8
XFILLER_45_350 VPWR VGND sg13cmos5l_fill_1
XFILLER_18_597 VPWR VGND sg13cmos5l_decap_8
X_3800_ _3801_/B _4357_/Q _3802_/B _3798_/Y _3860_/B VPWR VGND sg13cmos5l_a22oi_1
XFILLER_21_707 VPWR VGND sg13cmos5l_fill_1
XFILLER_33_556 VPWR VGND sg13cmos5l_decap_8
XFILLER_33_567 VPWR VGND sg13cmos5l_fill_2
X_3731_ _3859_/A _3701_/X _3730_/Y _3731_/S VPWR VGND sg13cmos5l_mux2_1
Xclkload10 clkload10/Y _4161_/CLK VPWR VGND sg13cmos5l_inv_1
X_3662_ _3662_/Y _3654_/B _3654_/C _3625_/A VPWR VGND sg13cmos5l_a21oi_1
X_3593_ _3595_/B _4335_/Q _3786_/A _3429_/A _4286_/Q VPWR VGND sg13cmos5l_a22oi_1
X_2613_ _2613_/Y _2647_/A _3983_/Q _2612_/Y VPWR VGND sg13cmos5l_a21oi_1
Xclkload21 clkload21/Y _4272_/CLK VPWR VGND sg13cmos5l_inv_1
X_2544_ _2549_/A _2544_/A _2544_/B VPWR VGND sg13cmos5l_nor2_1
XFILLER_48_0 VPWR VGND sg13cmos5l_decap_8
XFILLER_5_490 VPWR VGND sg13cmos5l_decap_8
X_2475_ _2475_/Y _2480_/A _2481_/A _2449_/A VPWR VGND sg13cmos5l_o21ai_1
X_4214_ _4214_/Q _4238_/CLK _4214_/D _4214_/RESET_B VPWR VGND sg13cmos5l_dfrbpq_1
X_4145_ _4145_/Q _4181_/CLK _4145_/D _4145_/RESET_B VPWR VGND sg13cmos5l_dfrbpq_1
XFILLER_18_17 VPWR VGND sg13cmos5l_decap_8
X_4076_ _4076_/Q clkload2/A _4076_/D _4076_/RESET_B VPWR VGND sg13cmos5l_dfrbpq_1
X_3027_ _3096_/D _3077_/A _3027_/B _3027_/C _3027_/D VPWR VGND sg13cmos5l_nand4_1
X_4369__537 _4369_/RESET_B VPWR VGND sg13cmos5l_tiehi
XFILLER_34_38 VPWR VGND sg13cmos5l_decap_4
X_3929_ _3985_/D _3952_/A hold726/X _3935_/S VPWR VGND sg13cmos5l_mux2_1
XFILLER_20_740 VPWR VGND sg13cmos5l_decap_8
Xclkload4 clkload4/Y clkload4/A VPWR VGND sg13cmos5l_inv_1
XFILLER_4_928 VPWR VGND sg13cmos5l_decap_8
XFILLER_47_615 VPWR VGND sg13cmos5l_fill_1
XFILLER_19_317 VPWR VGND sg13cmos5l_fill_1
XFILLER_27_350 VPWR VGND sg13cmos5l_fill_1
XFILLER_42_364 VPWR VGND sg13cmos5l_fill_1
XFILLER_43_898 VPWR VGND sg13cmos5l_decap_8
XFILLER_15_589 VPWR VGND sg13cmos5l_decap_8
XFILLER_11_740 VPWR VGND sg13cmos5l_decap_8
XFILLER_3_950 VPWR VGND sg13cmos5l_decap_8
XFILLER_2_471 VPWR VGND sg13cmos5l_decap_8
XFILLER_2_482 VPWR VGND sg13cmos5l_fill_2
X_2260_ _2260_/Y _3255_/A VPWR VGND sg13cmos5l_inv_1
XFILLER_1_53 VPWR VGND sg13cmos5l_fill_2
XFILLER_1_42 VPWR VGND sg13cmos5l_decap_8
XFILLER_46_692 VPWR VGND sg13cmos5l_decap_4
XFILLER_18_394 VPWR VGND sg13cmos5l_fill_2
XFILLER_34_865 VPWR VGND sg13cmos5l_decap_8
XFILLER_34_876 VPWR VGND sg13cmos5l_fill_1
XFILLER_34_898 VPWR VGND sg13cmos5l_decap_8
XFILLER_14_1015 VPWR VGND sg13cmos5l_decap_8
XFILLER_21_559 VPWR VGND sg13cmos5l_fill_1
X_3714_ _3716_/A _4342_/Q _3715_/B VPWR VGND sg13cmos5l_or2_1
X_3645_ _3668_/A _4329_/Q _3638_/Y _3661_/A VPWR VGND sg13cmos5l_a21o_1
X_3576_ _3576_/Y _3785_/A _4286_/Q _3575_/Y VPWR VGND sg13cmos5l_o21ai_1
X_2527_ _2535_/C _4373_/Q _4377_/Q _2524_/X _2526_/Y _2315_/B VPWR VGND sg13cmos5l_a221oi_1
X_2458_ _2458_/Y _2456_/Y _2457_/Y _2516_/A VPWR VGND sg13cmos5l_a21oi_1
XFILLER_29_27 VPWR VGND sg13cmos5l_fill_1
X_2389_ _4066_/D _2438_/A0 hold685/X _2390_/S VPWR VGND sg13cmos5l_mux2_1
X_4128_ _4128_/Q _4128_/CLK _4128_/D _4128_/RESET_B VPWR VGND sg13cmos5l_dfrbpq_1
XFILLER_44_629 VPWR VGND sg13cmos5l_decap_8
X_4059_ _4059_/Q _4136_/CLK _4059_/D _4059_/RESET_B VPWR VGND sg13cmos5l_dfrbpq_1
XFILLER_28_158 VPWR VGND sg13cmos5l_fill_2
XFILLER_45_59 VPWR VGND sg13cmos5l_decap_8
XFILLER_45_48 VPWR VGND sg13cmos5l_fill_1
XFILLER_25_887 VPWR VGND sg13cmos5l_decap_8
XFILLER_24_375 VPWR VGND sg13cmos5l_fill_1
XFILLER_3_202 VPWR VGND sg13cmos5l_fill_2
XFILLER_4_758 VPWR VGND sg13cmos5l_decap_8
XFILLER_0_942 VPWR VGND sg13cmos5l_decap_8
XFILLER_48_957 VPWR VGND sg13cmos5l_decap_8
XFILLER_19_93 VPWR VGND sg13cmos5l_decap_8
XFILLER_27_180 VPWR VGND sg13cmos5l_decap_8
XFILLER_43_695 VPWR VGND sg13cmos5l_decap_8
XFILLER_16_898 VPWR VGND sg13cmos5l_decap_8
XFILLER_42_194 VPWR VGND sg13cmos5l_decap_8
XFILLER_30_334 VPWR VGND sg13cmos5l_fill_1
XFILLER_11_592 VPWR VGND sg13cmos5l_fill_1
X_3430_ _4286_/D _3416_/Y hold893/X _3442_/B VPWR VGND sg13cmos5l_a21oi_1
X_3361_ _3361_/Y _3361_/A VPWR VGND sg13cmos5l_inv_1
X_2312_ _3897_/A _2523_/B _3881_/A VPWR VGND sg13cmos5l_nand2b_1
X_3292_ _3295_/B _3270_/A _3270_/B _3162_/X VPWR VGND sg13cmos5l_o21ai_1
X_2243_ _2916_/A _2765_/B VPWR VGND sg13cmos5l_inv_1
Xheichips26_dna_sequencer_135 uio_oe[3] VPWR VGND sg13cmos5l_tielo
XFILLER_38_445 VPWR VGND sg13cmos5l_decap_4
Xheichips26_dna_sequencer_146 uio_out[6] VPWR VGND sg13cmos5l_tielo
XFILLER_15_18 VPWR VGND sg13cmos5l_decap_8
XFILLER_18_180 VPWR VGND sg13cmos5l_fill_1
X_4364__231 _4364_/RESET_B VPWR VGND sg13cmos5l_tiehi
XFILLER_21_323 VPWR VGND sg13cmos5l_decap_8
XFILLER_21_356 VPWR VGND sg13cmos5l_decap_4
XFILLER_21_389 VPWR VGND sg13cmos5l_fill_2
X_3628_ _3628_/Y _3628_/A _3666_/C VPWR VGND sg13cmos5l_nand2_1
Xoutput17 uo_out[3] _4117_/Q VPWR VGND sg13cmos5l_buf_1
X_3559_ _3565_/B _3554_/X _3557_/Y _3558_/Y VPWR VGND sg13cmos5l_o21ai_1
XFILLER_29_412 VPWR VGND sg13cmos5l_fill_1
XFILLER_5_1024 VPWR VGND sg13cmos5l_decap_4
XFILLER_45_938 VPWR VGND sg13cmos5l_decap_8
XFILLER_25_662 VPWR VGND sg13cmos5l_decap_8
XFILLER_12_312 VPWR VGND sg13cmos5l_decap_8
XFILLER_13_824 VPWR VGND sg13cmos5l_decap_8
XFILLER_24_161 VPWR VGND sg13cmos5l_decap_8
XFILLER_24_172 VPWR VGND sg13cmos5l_fill_2
XFILLER_25_684 VPWR VGND sg13cmos5l_decap_8
XFILLER_40_643 VPWR VGND sg13cmos5l_fill_1
XFILLER_12_345 VPWR VGND sg13cmos5l_decap_8
XFILLER_40_687 VPWR VGND sg13cmos5l_decap_8
XFILLER_40_676 VPWR VGND sg13cmos5l_fill_2
XFILLER_8_316 VPWR VGND sg13cmos5l_fill_1
XFILLER_4_566 VPWR VGND sg13cmos5l_decap_4
XFILLER_4_544 VPWR VGND sg13cmos5l_decap_8
XFILLER_21_94 VPWR VGND sg13cmos5l_fill_2
XFILLER_0_772 VPWR VGND sg13cmos5l_decap_8
XFILLER_0_783 VPWR VGND sg13cmos5l_fill_1
XFILLER_48_754 VPWR VGND sg13cmos5l_decap_8
XFILLER_47_264 VPWR VGND sg13cmos5l_fill_2
XFILLER_44_960 VPWR VGND sg13cmos5l_decap_8
X_2930_ _2938_/A _4204_/Q _2948_/B VPWR VGND sg13cmos5l_xnor2_1
XFILLER_15_172 VPWR VGND sg13cmos5l_decap_8
XFILLER_30_120 VPWR VGND sg13cmos5l_decap_4
XFILLER_31_654 VPWR VGND sg13cmos5l_fill_2
X_2861_ _2861_/Y _2765_/B _4162_/Q VPWR VGND sg13cmos5l_nand2b_1
XFILLER_31_676 VPWR VGND sg13cmos5l_decap_8
XFILLER_8_850 VPWR VGND sg13cmos5l_fill_1
XFILLER_12_890 VPWR VGND sg13cmos5l_decap_8
X_2792_ _2792_/Y _4171_/Q _4152_/Q VPWR VGND sg13cmos5l_xnor2_1
XFILLER_8_861 VPWR VGND sg13cmos5l_fill_2
X_3413_ _3413_/Y _3244_/A _3411_/X _3412_/Y _3405_/C VPWR VGND sg13cmos5l_a22oi_1
X_3344_ _3356_/B _4304_/Q _3344_/B VPWR VGND sg13cmos5l_xnor2_1
Xhold1005 _3149_/A _4241_/Q VPWR VGND sg13cmos5l_dlygate4sd3_1
X_3275_ _3275_/Y _4257_/Q _4229_/Q VPWR VGND sg13cmos5l_xnor2_1
XFILLER_39_743 VPWR VGND sg13cmos5l_fill_2
Xhold1016 _2307_/B _2523_/B VPWR VGND sg13cmos5l_dlygate4sd3_1
X_2226_ _2226_/Y _2226_/A VPWR VGND sg13cmos5l_inv_1
XFILLER_39_765 VPWR VGND sg13cmos5l_decap_8
XFILLER_38_231 VPWR VGND sg13cmos5l_fill_2
XFILLER_27_949 VPWR VGND sg13cmos5l_decap_4
XFILLER_42_919 VPWR VGND sg13cmos5l_decap_8
XFILLER_10_805 VPWR VGND sg13cmos5l_fill_1
XFILLER_22_676 VPWR VGND sg13cmos5l_decap_8
XFILLER_10_838 VPWR VGND sg13cmos5l_decap_8
XFILLER_10_849 VPWR VGND sg13cmos5l_fill_2
XFILLER_21_186 VPWR VGND sg13cmos5l_decap_8
Xhold861 _2570_/B _4145_/Q VPWR VGND sg13cmos5l_dlygate4sd3_1
Xhold872 _4223_/D _3065_/Y VPWR VGND sg13cmos5l_dlygate4sd3_1
Xhold850 _2285_/A _4220_/Q VPWR VGND sg13cmos5l_dlygate4sd3_1
Xhold883 _2484_/A _4122_/Q VPWR VGND sg13cmos5l_dlygate4sd3_1
Xhold894 _3775_/B _4320_/Q VPWR VGND sg13cmos5l_dlygate4sd3_1
XFILLER_49_518 VPWR VGND sg13cmos5l_decap_8
XFILLER_18_905 VPWR VGND sg13cmos5l_decap_8
XFILLER_44_223 VPWR VGND sg13cmos5l_fill_1
XFILLER_29_297 VPWR VGND sg13cmos5l_decap_8
XFILLER_41_941 VPWR VGND sg13cmos5l_decap_8
XFILLER_40_473 VPWR VGND sg13cmos5l_fill_1
XFILLER_8_157 VPWR VGND sg13cmos5l_fill_1
XFILLER_8_146 VPWR VGND sg13cmos5l_decap_8
XFILLER_12_197 VPWR VGND sg13cmos5l_fill_2
XFILLER_0_580 VPWR VGND sg13cmos5l_decap_8
X_3060_ _3060_/Y _2284_/A _3059_/B _3059_/Y VPWR VGND sg13cmos5l_o21ai_1
XFILLER_36_757 VPWR VGND sg13cmos5l_decap_8
XFILLER_23_407 VPWR VGND sg13cmos5l_fill_1
X_3962_ _4008_/D input5/X hold796/X _3962_/S VPWR VGND sg13cmos5l_mux2_1
XFILLER_32_941 VPWR VGND sg13cmos5l_fill_1
X_3893_ _3893_/Y _3897_/B _3896_/B VPWR VGND sg13cmos5l_nor2b_1
X_2913_ _4200_/D _2913_/A _2913_/B VPWR VGND sg13cmos5l_and2_1
XFILLER_32_974 VPWR VGND sg13cmos5l_decap_8
X_2844_ _2844_/Y _2821_/Y _2822_/X _2835_/X _2841_/Y _4183_/Q VPWR VGND sg13cmos5l_a221oi_1
XFILLER_31_484 VPWR VGND sg13cmos5l_decap_4
X_2775_ _2775_/Y _2890_/B _2771_/Y _2774_/Y VPWR VGND sg13cmos5l_a21oi_1
XFILLER_8_691 VPWR VGND sg13cmos5l_decap_4
X_4376_ _4376_/Q _4378_/CLK _4376_/D _4376_/RESET_B VPWR VGND sg13cmos5l_dfrbpq_1
X_3327_ _3357_/B _4277_/Q _3327_/B VPWR VGND sg13cmos5l_xnor2_1
X_3258_ _4265_/D _3258_/A _3258_/B VPWR VGND sg13cmos5l_nor2_1
XFILLER_2_1027 VPWR VGND sg13cmos5l_fill_2
XFILLER_2_1016 VPWR VGND sg13cmos5l_decap_8
X_2209_ _2209_/Y _3900_/A VPWR VGND sg13cmos5l_inv_1
X_3189_ _3189_/X _3189_/A _3189_/B VPWR VGND sg13cmos5l_and2_1
XFILLER_42_727 VPWR VGND sg13cmos5l_decap_8
XFILLER_22_440 VPWR VGND sg13cmos5l_decap_4
XFILLER_10_624 VPWR VGND sg13cmos5l_decap_8
XFILLER_6_617 VPWR VGND sg13cmos5l_decap_8
Xhold680 hold680/X _4065_/Q VPWR VGND sg13cmos5l_dlygate4sd3_1
Xhold691 hold691/X _4075_/Q VPWR VGND sg13cmos5l_dlygate4sd3_1
XFILLER_40_1022 VPWR VGND sg13cmos5l_decap_8
XFILLER_18_746 VPWR VGND sg13cmos5l_fill_1
XFILLER_17_256 VPWR VGND sg13cmos5l_fill_1
Xclkbuf_2_0__f_clk clkbuf_leaf_4_clk/A clkbuf_0_clk/X VPWR VGND sg13cmos5l_buf_8
XFILLER_27_82 VPWR VGND sg13cmos5l_decap_4
XFILLER_13_440 VPWR VGND sg13cmos5l_decap_8
XFILLER_14_952 VPWR VGND sg13cmos5l_decap_8
XFILLER_40_281 VPWR VGND sg13cmos5l_fill_1
X_2560_ _2560_/Y _4141_/Q _2566_/B VPWR VGND sg13cmos5l_nor2_1
XFILLER_5_683 VPWR VGND sg13cmos5l_decap_8
X_2491_ _2491_/Y _2294_/B _2484_/B _2488_/A _2490_/Y VPWR VGND sg13cmos5l_a22oi_1
XFILLER_4_31 VPWR VGND sg13cmos5l_fill_1
X_4230_ _4230_/Q _4262_/CLK _4230_/D _4230_/RESET_B VPWR VGND sg13cmos5l_dfrbpq_1
X_4161_ _4161_/Q _4161_/CLK _4161_/D _4161_/RESET_B VPWR VGND sg13cmos5l_dfrbpq_1
X_3112_ _3113_/B _3112_/A _3112_/B VPWR VGND sg13cmos5l_nand2_1
X_4092_ _4092_/Q clkload7/A _4092_/D _4092_/RESET_B VPWR VGND sg13cmos5l_dfrbpq_1
X_3043_ _3043_/Y _4240_/Q _3047_/C _3043_/C VPWR VGND sg13cmos5l_nand3b_1
X_3976__585 _3976_/RESET_B VPWR VGND sg13cmos5l_tiehi
X_3945_ _3945_/X _3958_/A hold758/X _3946_/B VPWR VGND sg13cmos5l_mux2_1
XFILLER_20_944 VPWR VGND sg13cmos5l_decap_8
XFILLER_32_782 VPWR VGND sg13cmos5l_fill_2
X_3876_ _4360_/D _3879_/A _3876_/B _3876_/C VPWR VGND sg13cmos5l_nor3_1
XFILLER_31_281 VPWR VGND sg13cmos5l_fill_1
X_2827_ _3016_/A _2851_/A _4208_/Q VPWR VGND sg13cmos5l_xnor2_1
X_2758_ _2758_/Y _4146_/Q _4181_/Q VPWR VGND sg13cmos5l_nand2_1
XFILLER_3_609 VPWR VGND sg13cmos5l_decap_8
X_2689_ _2689_/Y _2687_/S _3978_/Q _2688_/Y VPWR VGND sg13cmos5l_a21oi_1
X_4359_ _4359_/Q clkload6/A _4359_/D _4359_/RESET_B VPWR VGND sg13cmos5l_dfrbpq_1
XFILLER_24_1017 VPWR VGND sg13cmos5l_decap_8
XFILLER_24_1028 VPWR VGND sg13cmos5l_fill_1
XFILLER_15_716 VPWR VGND sg13cmos5l_decap_8
XFILLER_11_900 VPWR VGND sg13cmos5l_decap_8
XFILLER_14_259 VPWR VGND sg13cmos5l_decap_4
XFILLER_23_760 VPWR VGND sg13cmos5l_fill_2
Xfanout30 _2440_/S _2439_/S VPWR VGND sg13cmos5l_buf_1
Xfanout63 _2515_/B1 hold828/X VPWR VGND sg13cmos5l_buf_1
XFILLER_10_410 VPWR VGND sg13cmos5l_decap_8
Xfanout52 _3444_/B _3323_/Y VPWR VGND sg13cmos5l_buf_1
Xfanout41 _3296_/B _3306_/B VPWR VGND sg13cmos5l_buf_1
Xfanout74 _2707_/A _4113_/Q VPWR VGND sg13cmos5l_buf_1
XFILLER_7_904 VPWR VGND sg13cmos5l_decap_4
XFILLER_11_977 VPWR VGND sg13cmos5l_decap_8
Xfanout96 _2670_/A1 _2664_/A1 VPWR VGND sg13cmos5l_buf_1
Xfanout85 _2629_/A _2665_/A VPWR VGND sg13cmos5l_buf_1
XFILLER_13_84 VPWR VGND sg13cmos5l_fill_2
XFILLER_10_498 VPWR VGND sg13cmos5l_decap_4
XFILLER_13_95 VPWR VGND sg13cmos5l_decap_8
XFILLER_1_130 VPWR VGND sg13cmos5l_decap_8
XFILLER_49_134 VPWR VGND sg13cmos5l_decap_8
XFILLER_49_189 VPWR VGND sg13cmos5l_decap_8
XFILLER_18_510 VPWR VGND sg13cmos5l_decap_8
XFILLER_46_852 VPWR VGND sg13cmos5l_decap_8
X_3730_ _3730_/Y _3730_/A _3730_/B VPWR VGND sg13cmos5l_nand2_1
X_3661_ _3661_/X _3661_/A _3669_/A _3661_/C VPWR VGND sg13cmos5l_or3_1
Xclkload11 clkload11/Y _4181_/CLK VPWR VGND sg13cmos5l_inv_2
X_3592_ _3592_/Y _3602_/B _3583_/A _3587_/A _2221_/Y _3591_/Y VPWR VGND sg13cmos5l_a221oi_1
X_2612_ _2612_/Y _2647_/A _4000_/Q VPWR VGND sg13cmos5l_nor2b_1
Xclkload22 clkload22/Y _4262_/CLK VPWR VGND sg13cmos5l_inv_1
X_2543_ _2543_/Y _2441_/B _2544_/A _2542_/Y VPWR VGND sg13cmos5l_a21oi_1
XFILLER_47_1028 VPWR VGND sg13cmos5l_fill_1
XFILLER_47_1017 VPWR VGND sg13cmos5l_decap_8
X_2474_ _2481_/A _2474_/A _2474_/B VPWR VGND sg13cmos5l_xor2_1
X_4213_ _4213_/Q _4238_/CLK _4213_/D _4213_/RESET_B VPWR VGND sg13cmos5l_dfrbpq_1
X_4144_ _4144_/Q _4181_/CLK _4144_/D _4144_/RESET_B VPWR VGND sg13cmos5l_dfrbpq_1
XFILLER_28_329 VPWR VGND sg13cmos5l_decap_8
XFILLER_49_690 VPWR VGND sg13cmos5l_decap_4
X_4075_ _4075_/Q clkload7/A _4075_/D _4075_/RESET_B VPWR VGND sg13cmos5l_dfrbpq_1
X_3026_ _3096_/C _3026_/A _3026_/B _3026_/C VPWR VGND sg13cmos5l_nand3_1
XFILLER_36_340 VPWR VGND sg13cmos5l_decap_8
XFILLER_24_524 VPWR VGND sg13cmos5l_decap_4
XFILLER_34_28 VPWR VGND sg13cmos5l_decap_4
X_4113__271 _4113_/RESET_B VPWR VGND sg13cmos5l_tiehi
Xclkload5 clkload5/Y clkload5/A VPWR VGND sg13cmos5l_inv_4
X_3928_ _3984_/D _3951_/A0 hold736/X _3935_/S VPWR VGND sg13cmos5l_mux2_1
X_3859_ _3865_/A _3859_/A _3859_/B VPWR VGND sg13cmos5l_nand2_1
XFILLER_30_1010 VPWR VGND sg13cmos5l_decap_8
XFILLER_4_907 VPWR VGND sg13cmos5l_decap_8
XFILLER_1_7 VPWR VGND sg13cmos5l_decap_8
XFILLER_8_1011 VPWR VGND sg13cmos5l_decap_8
XFILLER_19_329 VPWR VGND sg13cmos5l_decap_8
XFILLER_46_159 VPWR VGND sg13cmos5l_fill_2
XFILLER_43_811 VPWR VGND sg13cmos5l_decap_8
XFILLER_43_877 VPWR VGND sg13cmos5l_decap_8
XFILLER_42_354 VPWR VGND sg13cmos5l_decap_4
XFILLER_15_568 VPWR VGND sg13cmos5l_decap_8
XFILLER_6_266 VPWR VGND sg13cmos5l_decap_8
XFILLER_41_8 VPWR VGND sg13cmos5l_fill_1
XFILLER_2_461 VPWR VGND sg13cmos5l_fill_2
XFILLER_34_7 VPWR VGND sg13cmos5l_decap_8
XFILLER_38_627 VPWR VGND sg13cmos5l_decap_8
XFILLER_1_21 VPWR VGND sg13cmos5l_decap_8
XFILLER_37_126 VPWR VGND sg13cmos5l_decap_8
XFILLER_18_340 VPWR VGND sg13cmos5l_fill_2
XFILLER_46_682 VPWR VGND sg13cmos5l_decap_4
XFILLER_19_896 VPWR VGND sg13cmos5l_fill_1
XFILLER_33_332 VPWR VGND sg13cmos5l_decap_8
XFILLER_21_516 VPWR VGND sg13cmos5l_fill_2
XFILLER_14_590 VPWR VGND sg13cmos5l_fill_1
X_3713_ _3713_/Y _3721_/B _3713_/B VPWR VGND sg13cmos5l_nor2_1
X_3644_ _3661_/A _3660_/A _3660_/B _3660_/C VPWR VGND sg13cmos5l_a21oi_1
X_3575_ _3575_/Y _4334_/Q _3580_/B VPWR VGND sg13cmos5l_nand2_1
X_3980__559 _3980_/RESET_B VPWR VGND sg13cmos5l_tiehi
X_2526_ _2526_/Y _2526_/A _2526_/B VPWR VGND sg13cmos5l_nand2_1
X_2457_ _2457_/Y _2461_/B _4114_/Q _2463_/B hold639/X VPWR VGND sg13cmos5l_a22oi_1
X_2388_ _4065_/D _2437_/A0 hold680/X _2390_/S VPWR VGND sg13cmos5l_mux2_1
XFILLER_21_1009 VPWR VGND sg13cmos5l_decap_8
X_4127_ _4127_/Q _4128_/CLK _4127_/D _4127_/RESET_B VPWR VGND sg13cmos5l_dfrbpq_1
X_4232__502 _4232_/RESET_B VPWR VGND sg13cmos5l_tiehi
XFILLER_37_660 VPWR VGND sg13cmos5l_decap_8
X_4058_ _4058_/Q clkload7/A _4058_/D _4058_/RESET_B VPWR VGND sg13cmos5l_dfrbpq_1
X_3009_ _3021_/A _3009_/A _3009_/B VPWR VGND sg13cmos5l_nor2_1
XFILLER_40_836 VPWR VGND sg13cmos5l_decap_8
XFILLER_10_63 VPWR VGND sg13cmos5l_fill_1
XFILLER_0_921 VPWR VGND sg13cmos5l_decap_8
XFILLER_10_74 VPWR VGND sg13cmos5l_decap_8
XFILLER_48_936 VPWR VGND sg13cmos5l_decap_8
XFILLER_0_998 VPWR VGND sg13cmos5l_decap_8
XFILLER_19_50 VPWR VGND sg13cmos5l_fill_2
XFILLER_16_833 VPWR VGND sg13cmos5l_fill_2
XFILLER_34_129 VPWR VGND sg13cmos5l_decap_8
XFILLER_15_321 VPWR VGND sg13cmos5l_decap_4
XFILLER_43_674 VPWR VGND sg13cmos5l_decap_8
XFILLER_42_184 VPWR VGND sg13cmos5l_fill_1
XFILLER_7_564 VPWR VGND sg13cmos5l_fill_2
X_3360_ _3361_/A _3360_/A _3360_/B VPWR VGND sg13cmos5l_nor2_1
XFILLER_44_1009 VPWR VGND sg13cmos5l_decap_8
X_2311_ _4375_/D _2311_/A VPWR VGND sg13cmos5l_inv_1
X_3291_ _3295_/A _3308_/A _3291_/B VPWR VGND sg13cmos5l_nor2_1
X_4103__281 _4103_/RESET_B VPWR VGND sg13cmos5l_tiehi
XFILLER_39_914 VPWR VGND sg13cmos5l_fill_1
X_2242_ _2918_/A _2242_/A VPWR VGND sg13cmos5l_inv_1
Xheichips26_dna_sequencer_136 uio_oe[4] VPWR VGND sg13cmos5l_tielo
Xheichips26_dna_sequencer_147 uio_out[7] VPWR VGND sg13cmos5l_tielo
XFILLER_19_682 VPWR VGND sg13cmos5l_decap_4
XFILLER_25_118 VPWR VGND sg13cmos5l_fill_1
XFILLER_33_151 VPWR VGND sg13cmos5l_fill_2
XFILLER_34_696 VPWR VGND sg13cmos5l_decap_8
XFILLER_33_184 VPWR VGND sg13cmos5l_fill_2
X_4110__274 _4110_/RESET_B VPWR VGND sg13cmos5l_tiehi
X_3627_ _3627_/Y _3624_/Y _3626_/Y _3623_/Y VPWR VGND sg13cmos5l_o21ai_1
X_3558_ _3558_/Y _3356_/B _3547_/X _3556_/X _3339_/X VPWR VGND sg13cmos5l_a22oi_1
Xoutput18 uo_out[4] _4118_/Q VPWR VGND sg13cmos5l_buf_1
XFILLER_0_228 VPWR VGND sg13cmos5l_decap_8
X_2509_ _2509_/Y _2515_/B1 hold664/X _2509_/B1 VPWR VGND sg13cmos5l_o21ai_1
X_3489_ _3490_/B _3489_/A _3489_/B VPWR VGND sg13cmos5l_xnor2_1
XFILLER_5_1003 VPWR VGND sg13cmos5l_decap_8
XFILLER_45_917 VPWR VGND sg13cmos5l_decap_8
XFILLER_29_457 VPWR VGND sg13cmos5l_decap_8
XFILLER_40_655 VPWR VGND sg13cmos5l_decap_8
XFILLER_4_523 VPWR VGND sg13cmos5l_fill_1
XFILLER_4_512 VPWR VGND sg13cmos5l_decap_8
XFILLER_47_221 VPWR VGND sg13cmos5l_decap_4
XFILLER_0_795 VPWR VGND sg13cmos5l_decap_8
XFILLER_46_70 VPWR VGND sg13cmos5l_fill_1
XFILLER_35_438 VPWR VGND sg13cmos5l_fill_2
XFILLER_16_685 VPWR VGND sg13cmos5l_decap_4
X_2860_ _2860_/X _2866_/B _2866_/C _2866_/A VPWR VGND sg13cmos5l_a21o_1
X_2791_ _2791_/Y _4170_/Q _4151_/Q VPWR VGND sg13cmos5l_xnor2_1
XFILLER_30_176 VPWR VGND sg13cmos5l_decap_8
XFILLER_31_688 VPWR VGND sg13cmos5l_fill_2
XFILLER_7_42 VPWR VGND sg13cmos5l_decap_8
XFILLER_11_1019 VPWR VGND sg13cmos5l_decap_8
X_3412_ _3412_/Y _4304_/Q _4300_/Q VPWR VGND sg13cmos5l_nor2b_1
X_3343_ _3360_/B _3621_/A _3344_/B VPWR VGND sg13cmos5l_xnor2_1
Xhold1006 _2823_/A _4186_/Q VPWR VGND sg13cmos5l_dlygate4sd3_1
X_3274_ _3274_/Y _4259_/Q _4231_/Q VPWR VGND sg13cmos5l_nand2_1
XFILLER_39_722 VPWR VGND sg13cmos5l_decap_4
X_3979__561 _3979_/RESET_B VPWR VGND sg13cmos5l_tiehi
Xhold1017 _3515_/A _4306_/Q VPWR VGND sg13cmos5l_dlygate4sd3_1
X_2225_ _2225_/Y _2225_/A VPWR VGND sg13cmos5l_inv_1
XFILLER_38_287 VPWR VGND sg13cmos5l_decap_8
XFILLER_27_939 VPWR VGND sg13cmos5l_decap_4
Xclkbuf_leaf_18_clk _4302_/CLK clkbuf_leaf_3_clk/A VPWR VGND sg13cmos5l_buf_8
XFILLER_35_961 VPWR VGND sg13cmos5l_decap_4
XFILLER_21_121 VPWR VGND sg13cmos5l_fill_2
XFILLER_34_482 VPWR VGND sg13cmos5l_decap_4
XFILLER_42_39 VPWR VGND sg13cmos5l_fill_2
XFILLER_10_817 VPWR VGND sg13cmos5l_decap_8
XFILLER_22_655 VPWR VGND sg13cmos5l_decap_8
X_3986__510 _3986_/RESET_B VPWR VGND sg13cmos5l_tiehi
XFILLER_21_165 VPWR VGND sg13cmos5l_decap_8
X_2989_ _3197_/A _3256_/A _2998_/A VPWR VGND sg13cmos5l_and2_1
XFILLER_5_309 VPWR VGND sg13cmos5l_fill_1
Xhold862 hold862/X _2570_/Y VPWR VGND sg13cmos5l_dlygate4sd3_1
Xhold840 hold840/X _4115_/Q VPWR VGND sg13cmos5l_dlygate4sd3_1
Xhold873 _3225_/B _4272_/Q VPWR VGND sg13cmos5l_dlygate4sd3_1
Xhold851 _4220_/D _3058_/Y VPWR VGND sg13cmos5l_dlygate4sd3_1
Xhold895 _2273_/A _4166_/Q VPWR VGND sg13cmos5l_dlygate4sd3_1
Xhold884 _4122_/D _2489_/Y VPWR VGND sg13cmos5l_dlygate4sd3_1
XFILLER_27_1015 VPWR VGND sg13cmos5l_decap_8
X_4336__153 _4336_/D VPWR VGND sg13cmos5l_tielo
XFILLER_29_221 VPWR VGND sg13cmos5l_fill_1
XFILLER_18_939 VPWR VGND sg13cmos5l_decap_8
XFILLER_29_287 VPWR VGND sg13cmos5l_fill_1
XFILLER_45_758 VPWR VGND sg13cmos5l_decap_8
XFILLER_44_246 VPWR VGND sg13cmos5l_fill_2
XFILLER_44_257 VPWR VGND sg13cmos5l_decap_8
XFILLER_26_983 VPWR VGND sg13cmos5l_decap_8
XFILLER_9_626 VPWR VGND sg13cmos5l_decap_8
XFILLER_41_997 VPWR VGND sg13cmos5l_decap_8
XFILLER_9_637 VPWR VGND sg13cmos5l_fill_1
XFILLER_12_165 VPWR VGND sg13cmos5l_fill_1
XFILLER_32_50 VPWR VGND sg13cmos5l_fill_2
XFILLER_4_331 VPWR VGND sg13cmos5l_fill_2
XFILLER_5_898 VPWR VGND sg13cmos5l_decap_8
XFILLER_4_353 VPWR VGND sg13cmos5l_decap_8
XFILLER_4_386 VPWR VGND sg13cmos5l_decap_8
XFILLER_48_563 VPWR VGND sg13cmos5l_decap_4
X_4100__284 _4100_/RESET_B VPWR VGND sg13cmos5l_tiehi
XFILLER_35_213 VPWR VGND sg13cmos5l_fill_2
X_3961_ _4007_/D _3971_/A0 hold681/X _3962_/S VPWR VGND sg13cmos5l_mux2_1
X_2912_ _4199_/D _3066_/A _2912_/B VPWR VGND sg13cmos5l_and2_1
X_3892_ _3892_/Y _3892_/A _3892_/B VPWR VGND sg13cmos5l_nand2_1
X_2843_ _2845_/B _2835_/X _2841_/Y _2823_/Y VPWR VGND sg13cmos5l_a21oi_1
X_2774_ _2774_/Y _2768_/B _2771_/Y _2789_/B VPWR VGND sg13cmos5l_o21ai_1
XFILLER_8_670 VPWR VGND sg13cmos5l_decap_8
Xclkbuf_leaf_7_clk clkload8/A clkload0/A VPWR VGND sg13cmos5l_buf_8
X_4375_ _4375_/Q clkload5/A _4375_/D _4375_/RESET_B VPWR VGND sg13cmos5l_dfrbpq_1
X_4296__432 _4296_/RESET_B VPWR VGND sg13cmos5l_tiehi
X_3326_ _3327_/B _4276_/Q _3357_/A VPWR VGND sg13cmos5l_nor2_1
X_4255__162 _4255_/D VPWR VGND sg13cmos5l_tielo
X_3257_ _4264_/D _3257_/A _3258_/B VPWR VGND sg13cmos5l_nor2_1
X_3188_ _3200_/B _4219_/Q _3188_/B VPWR VGND sg13cmos5l_xor2_1
XFILLER_15_909 VPWR VGND sg13cmos5l_decap_8
XFILLER_26_246 VPWR VGND sg13cmos5l_fill_1
XFILLER_41_227 VPWR VGND sg13cmos5l_fill_1
XFILLER_41_216 VPWR VGND sg13cmos5l_decap_8
XFILLER_34_290 VPWR VGND sg13cmos5l_fill_1
XFILLER_23_997 VPWR VGND sg13cmos5l_decap_8
XFILLER_10_669 VPWR VGND sg13cmos5l_fill_1
XFILLER_2_813 VPWR VGND sg13cmos5l_decap_8
Xhold670 hold670/X _4078_/Q VPWR VGND sg13cmos5l_dlygate4sd3_1
Xhold681 hold681/X _4007_/Q VPWR VGND sg13cmos5l_dlygate4sd3_1
Xhold692 _4075_/D _2399_/X VPWR VGND sg13cmos5l_dlygate4sd3_1
XFILLER_40_1001 VPWR VGND sg13cmos5l_decap_8
XFILLER_17_202 VPWR VGND sg13cmos5l_fill_2
XFILLER_45_555 VPWR VGND sg13cmos5l_decap_8
XFILLER_27_61 VPWR VGND sg13cmos5l_decap_8
XFILLER_45_588 VPWR VGND sg13cmos5l_decap_8
XFILLER_14_931 VPWR VGND sg13cmos5l_fill_1
XFILLER_25_290 VPWR VGND sg13cmos5l_fill_2
XFILLER_40_271 VPWR VGND sg13cmos5l_decap_4
XFILLER_9_434 VPWR VGND sg13cmos5l_decap_8
X_2490_ _2490_/Y _4122_/Q _2484_/B _2473_/Y VPWR VGND sg13cmos5l_a21oi_1
X_4160_ _4160_/Q _4161_/CLK _4160_/D _4160_/RESET_B VPWR VGND sg13cmos5l_dfrbpq_1
XFILLER_4_54 VPWR VGND sg13cmos5l_fill_1
X_3111_ _3111_/Y _3111_/A _3111_/B _3111_/C VPWR VGND sg13cmos5l_nand3_1
X_4091_ _4091_/Q clkload2/A _4091_/D _4091_/RESET_B VPWR VGND sg13cmos5l_dfrbpq_1
XFILLER_49_883 VPWR VGND sg13cmos5l_decap_8
X_3042_ _3042_/Y _3047_/C _3041_/Y _3040_/Y VPWR VGND sg13cmos5l_a21oi_1
XFILLER_23_238 VPWR VGND sg13cmos5l_fill_1
XFILLER_24_739 VPWR VGND sg13cmos5l_decap_8
X_3944_ _3996_/D _3956_/A hold735/X _3948_/S VPWR VGND sg13cmos5l_mux2_1
X_3875_ _3876_/C _3877_/A _3877_/C _3855_/Y VPWR VGND sg13cmos5l_a21oi_1
XFILLER_17_1025 VPWR VGND sg13cmos5l_decap_4
XFILLER_20_923 VPWR VGND sg13cmos5l_decap_8
X_2826_ _3023_/C _2841_/B VPWR VGND sg13cmos5l_inv_1
X_2757_ _4161_/D _2757_/A _2818_/A VPWR VGND sg13cmos5l_nor2_1
X_2688_ _2688_/Y _2687_/S _2267_/Y _2690_/A1 VPWR VGND sg13cmos5l_o21ai_1
XFILLER_48_49 VPWR VGND sg13cmos5l_decap_8
X_4358_ _4358_/Q clkload5/A _4358_/D _4358_/RESET_B VPWR VGND sg13cmos5l_dfrbpq_1
X_4289_ _4289_/Q _4323_/CLK _4289_/D _4289_/RESET_B VPWR VGND sg13cmos5l_dfrbpq_1
X_3309_ _3309_/Y _3311_/A _3311_/B VPWR VGND sg13cmos5l_nand2_1
XFILLER_46_308 VPWR VGND sg13cmos5l_decap_8
XFILLER_42_547 VPWR VGND sg13cmos5l_decap_8
Xfanout20 _3251_/A2 _3613_/A2 VPWR VGND sg13cmos5l_buf_1
Xfanout31 _2420_/S _2419_/S VPWR VGND sg13cmos5l_buf_1
Xfanout64 _3684_/A hold1026/X VPWR VGND sg13cmos5l_buf_1
Xfanout53 _3258_/B _3320_/A VPWR VGND sg13cmos5l_buf_1
Xfanout42 _3168_/A _3131_/Y VPWR VGND sg13cmos5l_buf_1
XFILLER_23_772 VPWR VGND sg13cmos5l_fill_1
XFILLER_23_794 VPWR VGND sg13cmos5l_decap_8
X_4010__259 _4010_/RESET_B VPWR VGND sg13cmos5l_tiehi
XFILLER_11_956 VPWR VGND sg13cmos5l_decap_8
Xfanout97 _2664_/A1 _4111_/Q VPWR VGND sg13cmos5l_buf_1
Xfanout75 _2300_/A _4113_/Q VPWR VGND sg13cmos5l_buf_1
Xfanout86 _2665_/A _2664_/A1 VPWR VGND sg13cmos5l_buf_1
XFILLER_7_949 VPWR VGND sg13cmos5l_decap_8
XFILLER_10_466 VPWR VGND sg13cmos5l_decap_8
XFILLER_13_63 VPWR VGND sg13cmos5l_decap_8
XFILLER_2_676 VPWR VGND sg13cmos5l_fill_2
XFILLER_49_113 VPWR VGND sg13cmos5l_decap_8
XFILLER_49_168 VPWR VGND sg13cmos5l_decap_8
XFILLER_46_831 VPWR VGND sg13cmos5l_decap_8
XFILLER_18_522 VPWR VGND sg13cmos5l_decap_8
XFILLER_18_533 VPWR VGND sg13cmos5l_fill_2
XFILLER_18_566 VPWR VGND sg13cmos5l_decap_8
XFILLER_33_503 VPWR VGND sg13cmos5l_fill_2
XFILLER_45_385 VPWR VGND sg13cmos5l_decap_8
X_3660_ _3661_/C _3660_/A _3660_/B _3660_/C VPWR VGND sg13cmos5l_and3_1
X_3591_ _3591_/Y _4316_/Q _3587_/Y _3590_/Y _4315_/Q VPWR VGND sg13cmos5l_a22oi_1
X_2611_ _2611_/Y _2647_/A _4034_/Q VPWR VGND sg13cmos5l_nand2b_1
Xclkload12 clkload12/X _4323_/CLK VPWR VGND sg13cmos5l_buf_8
X_2542_ _2542_/Y _2441_/B _2541_/Y _3775_/A VPWR VGND sg13cmos5l_o21ai_1
XFILLER_6_993 VPWR VGND sg13cmos5l_decap_8
X_4212_ _4212_/Q _4238_/CLK _4212_/D _4212_/RESET_B VPWR VGND sg13cmos5l_dfrbpq_1
X_2473_ _2473_/Y _2473_/A _2474_/A _2547_/B VPWR VGND sg13cmos5l_nor3_1
X_4293__435 _4293_/RESET_B VPWR VGND sg13cmos5l_tiehi
X_4143_ _4143_/Q _4161_/CLK _4143_/D _4143_/RESET_B VPWR VGND sg13cmos5l_dfrbpq_1
X_4074_ _4074_/Q clkload2/A _4074_/D _4074_/RESET_B VPWR VGND sg13cmos5l_dfrbpq_1
XFILLER_28_319 VPWR VGND sg13cmos5l_fill_1
X_3025_ _3025_/Y _3024_/A _3024_/B _3079_/B VPWR VGND sg13cmos5l_a21oi_1
XFILLER_37_853 VPWR VGND sg13cmos5l_decap_8
XFILLER_37_875 VPWR VGND sg13cmos5l_fill_2
XFILLER_37_864 VPWR VGND sg13cmos5l_decap_8
X_3927_ _3983_/D _3950_/A0 hold725/X _3935_/S VPWR VGND sg13cmos5l_mux2_1
X_3858_ _3859_/B _3858_/A _3858_/B VPWR VGND sg13cmos5l_nand2_1
Xclkload6 clkload6/Y clkload6/A VPWR VGND sg13cmos5l_inv_4
XFILLER_20_775 VPWR VGND sg13cmos5l_fill_2
X_3789_ _3789_/Y _4350_/Q _4324_/Q VPWR VGND sg13cmos5l_xnor2_1
X_2809_ _2809_/Y _2804_/C _2808_/Y _2801_/Y VPWR VGND sg13cmos5l_a21oi_1
XFILLER_28_831 VPWR VGND sg13cmos5l_decap_8
XFILLER_28_853 VPWR VGND sg13cmos5l_fill_2
XFILLER_42_300 VPWR VGND sg13cmos5l_decap_8
XFILLER_15_514 VPWR VGND sg13cmos5l_fill_2
XFILLER_15_525 VPWR VGND sg13cmos5l_fill_2
XFILLER_43_856 VPWR VGND sg13cmos5l_decap_8
XFILLER_42_388 VPWR VGND sg13cmos5l_decap_4
XFILLER_6_201 VPWR VGND sg13cmos5l_fill_1
XFILLER_10_230 VPWR VGND sg13cmos5l_decap_8
XFILLER_24_95 VPWR VGND sg13cmos5l_decap_4
XFILLER_3_985 VPWR VGND sg13cmos5l_decap_8
XFILLER_49_81 VPWR VGND sg13cmos5l_decap_8
XFILLER_1_66 VPWR VGND sg13cmos5l_decap_8
XFILLER_18_374 VPWR VGND sg13cmos5l_decap_8
XFILLER_33_311 VPWR VGND sg13cmos5l_fill_1
XFILLER_34_823 VPWR VGND sg13cmos5l_decap_8
XFILLER_18_396 VPWR VGND sg13cmos5l_fill_1
XFILLER_33_377 VPWR VGND sg13cmos5l_decap_8
X_3712_ _3713_/B _3712_/A _3733_/A VPWR VGND sg13cmos5l_nor2_1
X_3643_ _3660_/C _4329_/Q _3667_/B VPWR VGND sg13cmos5l_xnor2_1
X_3574_ _3574_/Y _3784_/A _4285_/Q _4284_/Q _3532_/A _3573_/Y VPWR VGND sg13cmos5l_a221oi_1
X_2525_ _2526_/B _3881_/A _2291_/Y _4377_/Q VPWR VGND sg13cmos5l_o21ai_1
X_2456_ _2456_/Y _2456_/A _2456_/B VPWR VGND sg13cmos5l_nand2_1
X_4375__543 _4375_/RESET_B VPWR VGND sg13cmos5l_tiehi
XFILLER_29_18 VPWR VGND sg13cmos5l_decap_8
X_2387_ _4064_/D _2436_/A0 hold722/X _2390_/S VPWR VGND sg13cmos5l_mux2_1
X_4126_ _4126_/Q _4136_/CLK _4126_/D _4126_/RESET_B VPWR VGND sg13cmos5l_dfrbpq_1
XFILLER_29_606 VPWR VGND sg13cmos5l_fill_2
XFILLER_45_17 VPWR VGND sg13cmos5l_decap_4
X_4057_ _4057_/Q clkload2/A _4057_/D _4057_/RESET_B VPWR VGND sg13cmos5l_dfrbpq_1
X_4150__203 _4150_/RESET_B VPWR VGND sg13cmos5l_tiehi
XFILLER_45_39 VPWR VGND sg13cmos5l_decap_8
X_3008_ _3009_/B _4190_/Q _3008_/B VPWR VGND sg13cmos5l_xnor2_1
XFILLER_37_694 VPWR VGND sg13cmos5l_fill_2
XFILLER_24_344 VPWR VGND sg13cmos5l_fill_2
XFILLER_25_845 VPWR VGND sg13cmos5l_decap_8
XFILLER_25_856 VPWR VGND sg13cmos5l_fill_1
XFILLER_24_355 VPWR VGND sg13cmos5l_decap_8
XFILLER_24_366 VPWR VGND sg13cmos5l_decap_8
XFILLER_20_550 VPWR VGND sg13cmos5l_fill_2
XFILLER_10_53 VPWR VGND sg13cmos5l_decap_4
XFILLER_0_900 VPWR VGND sg13cmos5l_decap_8
XFILLER_48_915 VPWR VGND sg13cmos5l_decap_8
XFILLER_0_977 VPWR VGND sg13cmos5l_decap_8
XFILLER_19_62 VPWR VGND sg13cmos5l_fill_1
XFILLER_19_127 VPWR VGND sg13cmos5l_decap_8
XFILLER_47_469 VPWR VGND sg13cmos5l_decap_8
XFILLER_19_84 VPWR VGND sg13cmos5l_decap_4
XFILLER_16_867 VPWR VGND sg13cmos5l_fill_2
XFILLER_37_1028 VPWR VGND sg13cmos5l_fill_1
XFILLER_37_1017 VPWR VGND sg13cmos5l_decap_8
XFILLER_15_355 VPWR VGND sg13cmos5l_decap_8
XFILLER_15_366 VPWR VGND sg13cmos5l_fill_2
XFILLER_31_804 VPWR VGND sg13cmos5l_decap_4
XFILLER_31_815 VPWR VGND sg13cmos5l_decap_8
XFILLER_30_347 VPWR VGND sg13cmos5l_fill_2
XFILLER_11_572 VPWR VGND sg13cmos5l_fill_2
XFILLER_3_782 VPWR VGND sg13cmos5l_decap_4
X_2310_ _2311_/A _2291_/Y _2309_/Y _3890_/B1 VPWR VGND sg13cmos5l_o21ai_1
X_3290_ _3291_/B _3290_/A _3290_/B VPWR VGND sg13cmos5l_xnor2_1
X_2241_ _2822_/A _4186_/Q VPWR VGND sg13cmos5l_inv_1
XFILLER_2_292 VPWR VGND sg13cmos5l_fill_2
XFILLER_25_4 VPWR VGND sg13cmos5l_decap_4
XFILLER_38_425 VPWR VGND sg13cmos5l_decap_8
Xheichips26_dna_sequencer_148 uo_out[6] VPWR VGND sg13cmos5l_tielo
Xheichips26_dna_sequencer_137 uio_oe[5] VPWR VGND sg13cmos5l_tielo
XFILLER_25_108 VPWR VGND sg13cmos5l_fill_1
XFILLER_46_480 VPWR VGND sg13cmos5l_fill_2
XFILLER_18_171 VPWR VGND sg13cmos5l_decap_8
XFILLER_34_620 VPWR VGND sg13cmos5l_decap_8
XFILLER_22_804 VPWR VGND sg13cmos5l_decap_8
XFILLER_34_675 VPWR VGND sg13cmos5l_decap_4
X_3626_ _3626_/Y _3626_/A _3626_/B _3626_/C VPWR VGND sg13cmos5l_nor3_1
Xoutput19 uo_out[5] _4119_/Q VPWR VGND sg13cmos5l_buf_1
X_3557_ _3557_/Y _3339_/X _3556_/X _3555_/X VPWR VGND sg13cmos5l_o21ai_1
X_2508_ _2508_/Y _2217_/Y _3684_/A _2507_/Y VPWR VGND sg13cmos5l_a21oi_1
XFILLER_0_207 VPWR VGND sg13cmos5l_decap_8
X_3488_ _3489_/B _3488_/A _3488_/B VPWR VGND sg13cmos5l_xor2_1
X_2439_ _2439_/X _2439_/A0 hold763/X _2439_/S VPWR VGND sg13cmos5l_mux2_1
XFILLER_29_425 VPWR VGND sg13cmos5l_fill_1
X_4109_ _4109_/Q clkload7/A _4109_/D _4109_/RESET_B VPWR VGND sg13cmos5l_dfrbpq_1
XFILLER_44_406 VPWR VGND sg13cmos5l_decap_4
XFILLER_16_108 VPWR VGND sg13cmos5l_decap_8
XFILLER_25_653 VPWR VGND sg13cmos5l_decap_4
XFILLER_40_612 VPWR VGND sg13cmos5l_fill_2
XFILLER_12_303 VPWR VGND sg13cmos5l_decap_4
XFILLER_13_804 VPWR VGND sg13cmos5l_decap_8
XFILLER_13_815 VPWR VGND sg13cmos5l_fill_1
XFILLER_24_130 VPWR VGND sg13cmos5l_decap_8
XFILLER_24_152 VPWR VGND sg13cmos5l_decap_4
XFILLER_40_634 VPWR VGND sg13cmos5l_decap_8
XFILLER_8_307 VPWR VGND sg13cmos5l_decap_8
XFILLER_21_892 VPWR VGND sg13cmos5l_decap_8
XFILLER_21_96 VPWR VGND sg13cmos5l_fill_1
XFILLER_43_1010 VPWR VGND sg13cmos5l_decap_8
XFILLER_48_789 VPWR VGND sg13cmos5l_decap_8
XFILLER_16_631 VPWR VGND sg13cmos5l_fill_1
XFILLER_44_995 VPWR VGND sg13cmos5l_decap_8
XFILLER_31_612 VPWR VGND sg13cmos5l_decap_8
XFILLER_8_841 VPWR VGND sg13cmos5l_decap_8
XFILLER_30_166 VPWR VGND sg13cmos5l_decap_4
X_2790_ _2806_/A _2797_/A _2797_/B VPWR VGND sg13cmos5l_nand2_1
XFILLER_8_863 VPWR VGND sg13cmos5l_fill_1
XFILLER_7_395 VPWR VGND sg13cmos5l_decap_8
X_3411_ _3411_/X _4251_/Q _3411_/B VPWR VGND sg13cmos5l_and2_1
X_3342_ _3342_/Y _3360_/A _3340_/Y _3341_/Y VPWR VGND sg13cmos5l_o21ai_1
X_3273_ _3273_/X _3298_/A _3298_/B VPWR VGND sg13cmos5l_or2_1
Xhold1007 _2856_/C1 _2834_/Y VPWR VGND sg13cmos5l_dlygate4sd3_1
XFILLER_39_734 VPWR VGND sg13cmos5l_fill_2
Xhold1018 _3808_/A _4354_/Q VPWR VGND sg13cmos5l_dlygate4sd3_1
X_2224_ _2224_/Y _2224_/A VPWR VGND sg13cmos5l_inv_1
XFILLER_19_480 VPWR VGND sg13cmos5l_fill_2
XFILLER_42_18 VPWR VGND sg13cmos5l_decap_4
X_2988_ _2999_/S _2995_/B _2988_/B VPWR VGND sg13cmos5l_nand2b_1
XFILLER_22_689 VPWR VGND sg13cmos5l_fill_2
Xhold830 _4123_/D _2493_/Y VPWR VGND sg13cmos5l_dlygate4sd3_1
X_3609_ _3609_/Y _2213_/Y _3613_/A2 _3608_/Y VPWR VGND sg13cmos5l_a21oi_1
Xhold863 _2242_/A _4182_/Q VPWR VGND sg13cmos5l_dlygate4sd3_1
Xhold852 hold852/X _4132_/Q VPWR VGND sg13cmos5l_dlygate4sd3_1
Xhold841 _4115_/D _2462_/Y VPWR VGND sg13cmos5l_dlygate4sd3_1
Xhold896 _4166_/D _2775_/Y VPWR VGND sg13cmos5l_dlygate4sd3_1
Xhold874 _3605_/B _4318_/Q VPWR VGND sg13cmos5l_dlygate4sd3_1
Xhold885 _2305_/A _4374_/Q VPWR VGND sg13cmos5l_dlygate4sd3_1
XFILLER_29_233 VPWR VGND sg13cmos5l_fill_1
XFILLER_16_41 VPWR VGND sg13cmos5l_fill_1
XFILLER_26_962 VPWR VGND sg13cmos5l_decap_8
XFILLER_16_63 VPWR VGND sg13cmos5l_fill_1
XFILLER_16_74 VPWR VGND sg13cmos5l_decap_4
XFILLER_25_494 VPWR VGND sg13cmos5l_decap_8
XFILLER_41_976 VPWR VGND sg13cmos5l_decap_8
XFILLER_9_605 VPWR VGND sg13cmos5l_decap_8
XFILLER_12_144 VPWR VGND sg13cmos5l_decap_8
XFILLER_40_464 VPWR VGND sg13cmos5l_decap_8
XFILLER_5_833 VPWR VGND sg13cmos5l_decap_8
X_3960_ _4006_/D _3946_/A hold776/X _3960_/S VPWR VGND sg13cmos5l_mux2_1
XFILLER_17_984 VPWR VGND sg13cmos5l_decap_4
XFILLER_44_792 VPWR VGND sg13cmos5l_decap_8
X_2911_ _4198_/D _2226_/Y _3251_/A2 _2910_/Y VPWR VGND sg13cmos5l_a21oi_1
XFILLER_32_932 VPWR VGND sg13cmos5l_decap_8
XFILLER_43_280 VPWR VGND sg13cmos5l_decap_4
X_3891_ _3891_/Y _3892_/A _3889_/Y _3890_/Y VPWR VGND sg13cmos5l_a21oi_1
XFILLER_32_954 VPWR VGND sg13cmos5l_decap_8
X_2842_ _2846_/B _2851_/B _3009_/A VPWR VGND sg13cmos5l_nor2_1
X_2773_ _2773_/Y _2888_/B _2771_/Y _2772_/Y VPWR VGND sg13cmos5l_a21oi_1
X_4374_ _4374_/Q _4378_/CLK _4374_/D _4374_/RESET_B VPWR VGND sg13cmos5l_dfrbpq_1
X_3325_ _3357_/A _4275_/Q _4274_/Q _4273_/Q VPWR VGND sg13cmos5l_or3_1
X_3256_ _4263_/D _3256_/A _3260_/B VPWR VGND sg13cmos5l_and2_1
X_3187_ _3187_/Y _3180_/B _3184_/Y _3180_/A VPWR VGND sg13cmos5l_o21ai_1
XFILLER_39_597 VPWR VGND sg13cmos5l_decap_8
XFILLER_26_258 VPWR VGND sg13cmos5l_decap_8
XFILLER_26_269 VPWR VGND sg13cmos5l_fill_2
XFILLER_23_921 VPWR VGND sg13cmos5l_decap_4
XFILLER_35_770 VPWR VGND sg13cmos5l_fill_2
XFILLER_23_976 VPWR VGND sg13cmos5l_fill_1
X_4147__208 _4147_/RESET_B VPWR VGND sg13cmos5l_tiehi
XFILLER_33_1020 VPWR VGND sg13cmos5l_decap_8
Xhold671 hold671/X _4033_/Q VPWR VGND sg13cmos5l_dlygate4sd3_1
XFILLER_1_313 VPWR VGND sg13cmos5l_fill_2
X_4123__252 _4123_/RESET_B VPWR VGND sg13cmos5l_tiehi
Xhold660 hold660/X _4171_/Q VPWR VGND sg13cmos5l_dlygate4sd3_1
Xhold693 hold693/X _4097_/Q VPWR VGND sg13cmos5l_dlygate4sd3_1
XFILLER_2_869 VPWR VGND sg13cmos5l_decap_8
Xhold682 hold682/X _4069_/Q VPWR VGND sg13cmos5l_dlygate4sd3_1
XFILLER_49_328 VPWR VGND sg13cmos5l_fill_2
XFILLER_45_512 VPWR VGND sg13cmos5l_fill_2
XFILLER_45_545 VPWR VGND sg13cmos5l_fill_1
XFILLER_41_795 VPWR VGND sg13cmos5l_decap_8
XFILLER_14_987 VPWR VGND sg13cmos5l_decap_8
XFILLER_4_173 VPWR VGND sg13cmos5l_decap_8
X_3110_ _3110_/Y _3094_/Y _3102_/X _3109_/Y VPWR VGND sg13cmos5l_a21oi_1
XFILLER_1_880 VPWR VGND sg13cmos5l_decap_8
X_4090_ _4090_/Q clkload7/A _4090_/D _4090_/RESET_B VPWR VGND sg13cmos5l_dfrbpq_1
XFILLER_49_862 VPWR VGND sg13cmos5l_decap_8
X_3041_ _3041_/Y _4240_/Q _4236_/Q VPWR VGND sg13cmos5l_nor2b_1
XFILLER_23_228 VPWR VGND sg13cmos5l_decap_4
X_3943_ _3995_/D _2267_/Y _3948_/S _3942_/Y VPWR VGND sg13cmos5l_a21oi_1
XFILLER_16_291 VPWR VGND sg13cmos5l_decap_4
XFILLER_17_1004 VPWR VGND sg13cmos5l_decap_8
X_4187__566 _4187_/RESET_B VPWR VGND sg13cmos5l_tiehi
X_3874_ _3876_/B _3877_/A _3874_/B _3877_/C VPWR VGND sg13cmos5l_and3_1
XFILLER_32_784 VPWR VGND sg13cmos5l_fill_1
X_2825_ _2841_/B _2851_/A _4208_/Q VPWR VGND sg13cmos5l_nor2_1
XFILLER_32_795 VPWR VGND sg13cmos5l_decap_4
XFILLER_20_979 VPWR VGND sg13cmos5l_decap_8
X_2756_ _4176_/D _2804_/A _2789_/B VPWR VGND sg13cmos5l_and2_1
X_2687_ _2687_/X _4029_/Q _4012_/Q _2687_/S VPWR VGND sg13cmos5l_mux2_1
XFILLER_48_28 VPWR VGND sg13cmos5l_decap_8
X_4357_ _4357_/Q clkload5/A _4357_/D _4357_/RESET_B VPWR VGND sg13cmos5l_dfrbpq_1
X_4288_ _4288_/Q _4323_/CLK _4288_/D _4288_/RESET_B VPWR VGND sg13cmos5l_dfrbpq_1
X_3308_ _3311_/B _3308_/A _3308_/B VPWR VGND sg13cmos5l_nor2_1
X_3239_ _3239_/Y hold922/X _3236_/Y _3260_/B VPWR VGND sg13cmos5l_o21ai_1
XFILLER_39_383 VPWR VGND sg13cmos5l_decap_8
XFILLER_27_567 VPWR VGND sg13cmos5l_fill_2
XFILLER_42_526 VPWR VGND sg13cmos5l_decap_8
Xfanout21 _3613_/A2 _2910_/A2 VPWR VGND sg13cmos5l_buf_1
Xfanout65 _3822_/A _3539_/A VPWR VGND sg13cmos5l_buf_1
Xfanout43 _3164_/A _3131_/Y VPWR VGND sg13cmos5l_buf_1
Xfanout54 _3260_/B _3154_/Y VPWR VGND sg13cmos5l_buf_1
Xfanout32 _2400_/S _2399_/S VPWR VGND sg13cmos5l_buf_1
Xfanout87 _2698_/A _2708_/S0 VPWR VGND sg13cmos5l_buf_1
XFILLER_10_423 VPWR VGND sg13cmos5l_decap_8
XFILLER_11_935 VPWR VGND sg13cmos5l_decap_8
Xfanout98 _2516_/A _4370_/D VPWR VGND sg13cmos5l_buf_1
XFILLER_13_31 VPWR VGND sg13cmos5l_fill_1
Xfanout76 _2658_/S1 _2700_/B2 VPWR VGND sg13cmos5l_buf_1
XFILLER_7_928 VPWR VGND sg13cmos5l_decap_8
XFILLER_2_688 VPWR VGND sg13cmos5l_decap_8
XFILLER_1_176 VPWR VGND sg13cmos5l_fill_2
XFILLER_46_810 VPWR VGND sg13cmos5l_decap_8
XFILLER_46_887 VPWR VGND sg13cmos5l_decap_8
XFILLER_18_545 VPWR VGND sg13cmos5l_decap_4
XFILLER_18_578 VPWR VGND sg13cmos5l_fill_1
X_3590_ _3590_/Y _3578_/Y _3588_/Y _3589_/Y _3586_/S VPWR VGND sg13cmos5l_a22oi_1
XFILLER_10_990 VPWR VGND sg13cmos5l_decap_8
Xclkload13 clkload13/Y _4302_/CLK VPWR VGND sg13cmos5l_inv_4
X_2610_ _2610_/Y _2610_/A _2610_/B _2610_/C VPWR VGND sg13cmos5l_nor3_1
XFILLER_6_972 VPWR VGND sg13cmos5l_decap_8
X_2541_ _2541_/Y _2544_/A _2544_/B VPWR VGND sg13cmos5l_nand2b_1
X_2472_ _2484_/B _2473_/A _2547_/B _2474_/A VPWR VGND sg13cmos5l_o21ai_1
X_4211_ _4211_/Q _4238_/CLK _4211_/D _4211_/RESET_B VPWR VGND sg13cmos5l_dfrbpq_1
X_4142_ _4142_/Q _4161_/CLK _4142_/D _4142_/RESET_B VPWR VGND sg13cmos5l_dfrbpq_1
X_4219__518 _4219_/RESET_B VPWR VGND sg13cmos5l_tiehi
X_4073_ _4073_/Q clkload7/A _4073_/D _4073_/RESET_B VPWR VGND sg13cmos5l_dfrbpq_1
XFILLER_28_309 VPWR VGND sg13cmos5l_decap_4
X_3024_ _3024_/Y _3024_/A _3024_/B VPWR VGND sg13cmos5l_nand2_1
XFILLER_37_832 VPWR VGND sg13cmos5l_decap_8
XFILLER_37_887 VPWR VGND sg13cmos5l_decap_8
XFILLER_24_537 VPWR VGND sg13cmos5l_fill_1
X_3926_ _3934_/S _4370_/D _3926_/B VPWR VGND sg13cmos5l_or2_1
X_3857_ _3857_/Y _3847_/Y _3850_/Y _3853_/A _3855_/A _3856_/Y VPWR VGND sg13cmos5l_a221oi_1
XFILLER_20_754 VPWR VGND sg13cmos5l_decap_8
Xclkload7 clkload7/Y clkload7/A VPWR VGND sg13cmos5l_inv_1
X_3788_ _3788_/Y _4351_/Q _4325_/Q VPWR VGND sg13cmos5l_xnor2_1
X_2808_ _2808_/Y _2808_/A _2808_/B VPWR VGND sg13cmos5l_nor2_1
X_2739_ _2739_/Y _2866_/A _2735_/A _2749_/A _2916_/A _2738_/Y VPWR VGND sg13cmos5l_a221oi_1
XFILLER_3_419 VPWR VGND sg13cmos5l_decap_8
XFILLER_30_507 VPWR VGND sg13cmos5l_decap_8
XFILLER_11_754 VPWR VGND sg13cmos5l_fill_2
XFILLER_6_224 VPWR VGND sg13cmos5l_fill_2
XFILLER_10_275 VPWR VGND sg13cmos5l_decap_8
XFILLER_3_964 VPWR VGND sg13cmos5l_decap_8
XFILLER_49_60 VPWR VGND sg13cmos5l_decap_8
X_4177__576 _4177_/RESET_B VPWR VGND sg13cmos5l_tiehi
XFILLER_19_810 VPWR VGND sg13cmos5l_decap_4
XFILLER_18_342 VPWR VGND sg13cmos5l_fill_1
XFILLER_33_356 VPWR VGND sg13cmos5l_decap_8
X_3711_ _3721_/B _3730_/B VPWR VGND sg13cmos5l_inv_1
X_4282__159 _4282_/D VPWR VGND sg13cmos5l_tielo
X_4184__569 _4184_/RESET_B VPWR VGND sg13cmos5l_tiehi
X_3642_ _3660_/B _4323_/Q _4294_/Q _4328_/Q VPWR VGND sg13cmos5l_nand3_1
X_3573_ _3573_/Y _3783_/A _2277_/Y _3588_/B _4332_/Q VPWR VGND sg13cmos5l_a22oi_1
X_2524_ _2524_/X _4377_/Q _2523_/Y _3911_/B VPWR VGND sg13cmos5l_a21o_1
X_2455_ _2456_/B _2461_/B input2/X VPWR VGND sg13cmos5l_nor2_1
X_2386_ _4063_/D _2435_/A0 hold718/X _2390_/S VPWR VGND sg13cmos5l_mux2_1
X_4125_ _4125_/Q _4136_/CLK _4125_/D _4125_/RESET_B VPWR VGND sg13cmos5l_dfrbpq_1
X_4056_ _4056_/Q clkload7/A _4056_/D _4056_/RESET_B VPWR VGND sg13cmos5l_dfrbpq_1
X_3007_ _3027_/C _3019_/A _3026_/A VPWR VGND sg13cmos5l_nand2b_1
XFILLER_24_301 VPWR VGND sg13cmos5l_fill_2
XFILLER_25_813 VPWR VGND sg13cmos5l_decap_8
XFILLER_25_824 VPWR VGND sg13cmos5l_decap_8
XFILLER_24_323 VPWR VGND sg13cmos5l_decap_8
XFILLER_12_518 VPWR VGND sg13cmos5l_decap_8
X_3909_ _3910_/C _3909_/A _3909_/B _3909_/C VPWR VGND sg13cmos5l_and3_1
XFILLER_20_584 VPWR VGND sg13cmos5l_fill_2
XFILLER_10_32 VPWR VGND sg13cmos5l_decap_8
XFILLER_0_956 VPWR VGND sg13cmos5l_decap_8
XFILLER_19_52 VPWR VGND sg13cmos5l_fill_1
XFILLER_19_139 VPWR VGND sg13cmos5l_decap_4
XFILLER_43_643 VPWR VGND sg13cmos5l_decap_8
XFILLER_43_632 VPWR VGND sg13cmos5l_decap_8
XFILLER_15_334 VPWR VGND sg13cmos5l_decap_8
XFILLER_27_194 VPWR VGND sg13cmos5l_fill_2
XFILLER_28_695 VPWR VGND sg13cmos5l_fill_2
XFILLER_30_304 VPWR VGND sg13cmos5l_decap_8
XFILLER_30_315 VPWR VGND sg13cmos5l_fill_1
X_4209__528 _4209_/RESET_B VPWR VGND sg13cmos5l_tiehi
XFILLER_30_359 VPWR VGND sg13cmos5l_decap_8
XFILLER_7_522 VPWR VGND sg13cmos5l_decap_8
XFILLER_7_566 VPWR VGND sg13cmos5l_fill_1
XFILLER_7_599 VPWR VGND sg13cmos5l_fill_2
XFILLER_7_577 VPWR VGND sg13cmos5l_decap_8
XFILLER_3_750 VPWR VGND sg13cmos5l_decap_8
X_2240_ _3079_/A _2240_/A VPWR VGND sg13cmos5l_inv_1
XFILLER_39_949 VPWR VGND sg13cmos5l_decap_8
Xheichips26_dna_sequencer_149 uo_out[7] VPWR VGND sg13cmos5l_tielo
XFILLER_18_4 VPWR VGND sg13cmos5l_decap_8
Xheichips26_dna_sequencer_138 uio_oe[6] VPWR VGND sg13cmos5l_tielo
XFILLER_47_982 VPWR VGND sg13cmos5l_decap_8
XFILLER_34_610 VPWR VGND sg13cmos5l_fill_1
XFILLER_22_816 VPWR VGND sg13cmos5l_decap_8
XFILLER_33_131 VPWR VGND sg13cmos5l_fill_2
XFILLER_33_153 VPWR VGND sg13cmos5l_fill_1
XFILLER_22_838 VPWR VGND sg13cmos5l_decap_8
XFILLER_33_197 VPWR VGND sg13cmos5l_fill_2
X_3625_ _3625_/Y _3625_/A _3625_/B VPWR VGND sg13cmos5l_nand2_1
X_3556_ _3556_/X _4281_/Q _3556_/B VPWR VGND sg13cmos5l_xor2_1
X_2507_ _2507_/Y _3684_/A _4132_/Q _2509_/B1 VPWR VGND sg13cmos5l_o21ai_1
X_3487_ _3493_/A _3487_/A _3487_/B VPWR VGND sg13cmos5l_nor2_1
X_2438_ _4108_/D _2438_/A0 hold813/X _2440_/S VPWR VGND sg13cmos5l_mux2_1
X_2369_ _4049_/D _2438_/A0 hold810/X _2370_/S VPWR VGND sg13cmos5l_mux2_1
XFILLER_29_437 VPWR VGND sg13cmos5l_decap_8
X_4219__167 _4219_/D VPWR VGND sg13cmos5l_tielo
X_4108_ _4108_/Q clkload2/A _4108_/D _4108_/RESET_B VPWR VGND sg13cmos5l_dfrbpq_1
XFILLER_38_993 VPWR VGND sg13cmos5l_decap_8
X_4039_ _4039_/Q clkload4/A _4039_/D _4039_/RESET_B VPWR VGND sg13cmos5l_dfrbpq_1
XFILLER_37_492 VPWR VGND sg13cmos5l_decap_8
XFILLER_12_326 VPWR VGND sg13cmos5l_decap_8
XFILLER_13_838 VPWR VGND sg13cmos5l_decap_8
XFILLER_13_849 VPWR VGND sg13cmos5l_fill_1
XFILLER_25_698 VPWR VGND sg13cmos5l_decap_4
XFILLER_12_359 VPWR VGND sg13cmos5l_decap_8
XFILLER_4_558 VPWR VGND sg13cmos5l_fill_2
XFILLER_48_768 VPWR VGND sg13cmos5l_decap_8
X_4174__579 _4174_/RESET_B VPWR VGND sg13cmos5l_tiehi
XFILLER_29_982 VPWR VGND sg13cmos5l_decap_8
X_4133__232 _4133_/RESET_B VPWR VGND sg13cmos5l_tiehi
XFILLER_44_974 VPWR VGND sg13cmos5l_decap_8
XFILLER_30_156 VPWR VGND sg13cmos5l_decap_4
X_3410_ _3410_/Y _3244_/A _3408_/X _3409_/Y _3405_/C VPWR VGND sg13cmos5l_a22oi_1
X_3341_ _3341_/Y _3357_/A _3357_/C _3549_/A VPWR VGND sg13cmos5l_nand3_1
X_3272_ _3298_/B _3272_/A _3272_/B _3293_/B _3293_/C VPWR VGND sg13cmos5l_and4_1
Xhold1008 _2857_/B _2941_/A VPWR VGND sg13cmos5l_dlygate4sd3_1
XFILLER_39_713 VPWR VGND sg13cmos5l_decap_4
Xhold1019 _3560_/C1 _4278_/Q VPWR VGND sg13cmos5l_dlygate4sd3_1
X_2223_ _2223_/Y _2223_/A VPWR VGND sg13cmos5l_inv_1
XFILLER_26_418 VPWR VGND sg13cmos5l_fill_1
XFILLER_35_930 VPWR VGND sg13cmos5l_fill_1
XFILLER_35_996 VPWR VGND sg13cmos5l_decap_8
XFILLER_21_123 VPWR VGND sg13cmos5l_fill_1
X_2987_ _2988_/B _2987_/A _2987_/B VPWR VGND sg13cmos5l_xnor2_1
Xhold820 _4132_/D _2508_/Y VPWR VGND sg13cmos5l_dlygate4sd3_1
X_3608_ _3608_/Y _4289_/Q _3613_/A2 _3615_/A VPWR VGND sg13cmos5l_o21ai_1
Xhold853 hold853/X _2464_/Y VPWR VGND sg13cmos5l_dlygate4sd3_1
XFILLER_1_506 VPWR VGND sg13cmos5l_decap_8
XFILLER_1_517 VPWR VGND sg13cmos5l_fill_1
Xhold831 _2216_/A _4346_/Q VPWR VGND sg13cmos5l_dlygate4sd3_1
Xhold842 _3911_/A _4369_/Q VPWR VGND sg13cmos5l_dlygate4sd3_1
Xhold864 _3043_/C _4238_/Q VPWR VGND sg13cmos5l_dlygate4sd3_1
X_3539_ _3839_/A _3539_/A _3539_/B VPWR VGND sg13cmos5l_nor2_1
Xhold875 hold875/X _3757_/A VPWR VGND sg13cmos5l_dlygate4sd3_1
Xhold886 hold886/X _2518_/A VPWR VGND sg13cmos5l_dlygate4sd3_1
Xhold897 _2903_/B _4193_/Q VPWR VGND sg13cmos5l_dlygate4sd3_1
XFILLER_45_716 VPWR VGND sg13cmos5l_decap_8
XFILLER_18_919 VPWR VGND sg13cmos5l_fill_2
X_4013__225 _4013_/RESET_B VPWR VGND sg13cmos5l_tiehi
XFILLER_13_635 VPWR VGND sg13cmos5l_decap_4
XFILLER_41_955 VPWR VGND sg13cmos5l_decap_8
XFILLER_40_454 VPWR VGND sg13cmos5l_decap_4
XFILLER_8_105 VPWR VGND sg13cmos5l_decap_8
XFILLER_5_812 VPWR VGND sg13cmos5l_fill_2
X_4321__402 _4321_/RESET_B VPWR VGND sg13cmos5l_tiehi
XFILLER_4_322 VPWR VGND sg13cmos5l_decap_4
XFILLER_0_561 VPWR VGND sg13cmos5l_decap_8
XFILLER_0_594 VPWR VGND sg13cmos5l_fill_1
XFILLER_29_790 VPWR VGND sg13cmos5l_decap_8
XFILLER_35_215 VPWR VGND sg13cmos5l_fill_1
XFILLER_17_963 VPWR VGND sg13cmos5l_decap_8
X_2910_ _2910_/Y _2797_/A _2910_/A2 _2905_/A VPWR VGND sg13cmos5l_o21ai_1
X_3890_ _3890_/Y _3887_/A _3892_/A _3890_/B1 VPWR VGND sg13cmos5l_o21ai_1
X_2841_ _2841_/Y _4209_/Q _2841_/B VPWR VGND sg13cmos5l_xnor2_1
XFILLER_32_988 VPWR VGND sg13cmos5l_decap_8
X_2772_ _2772_/Y _2764_/X _2771_/Y _2789_/B VPWR VGND sg13cmos5l_o21ai_1
X_4361__237 _4361_/RESET_B VPWR VGND sg13cmos5l_tiehi
X_4373_ _4373_/Q _4377_/CLK _4373_/D _4373_/RESET_B VPWR VGND sg13cmos5l_dfrbpq_1
X_3324_ _3502_/A _3607_/B _3607_/A VPWR VGND sg13cmos5l_nand2b_1
X_3255_ _4262_/D _3255_/A _3255_/B VPWR VGND sg13cmos5l_and2_1
X_3975__202 _3975_/RESET_B VPWR VGND sg13cmos5l_tiehi
XFILLER_39_565 VPWR VGND sg13cmos5l_decap_4
X_3186_ _3186_/Y _3189_/A _3189_/B _3185_/X VPWR VGND sg13cmos5l_o21ai_1
XFILLER_26_237 VPWR VGND sg13cmos5l_decap_8
XFILLER_35_782 VPWR VGND sg13cmos5l_decap_4
XFILLER_34_281 VPWR VGND sg13cmos5l_fill_1
XFILLER_10_638 VPWR VGND sg13cmos5l_decap_4
XFILLER_22_487 VPWR VGND sg13cmos5l_decap_8
XFILLER_22_498 VPWR VGND sg13cmos5l_fill_1
XFILLER_2_848 VPWR VGND sg13cmos5l_decap_8
Xhold661 _2219_/A _4343_/Q VPWR VGND sg13cmos5l_dlygate4sd3_1
Xhold672 hold672/X _4085_/Q VPWR VGND sg13cmos5l_dlygate4sd3_1
Xhold650 _2679_/A _4139_/Q VPWR VGND sg13cmos5l_dlygate4sd3_1
Xhold694 hold694/X _4067_/Q VPWR VGND sg13cmos5l_dlygate4sd3_1
Xhold683 hold683/X _4048_/Q VPWR VGND sg13cmos5l_dlygate4sd3_1
XFILLER_18_716 VPWR VGND sg13cmos5l_fill_2
XFILLER_17_204 VPWR VGND sg13cmos5l_fill_1
XFILLER_17_248 VPWR VGND sg13cmos5l_fill_2
XFILLER_26_771 VPWR VGND sg13cmos5l_fill_2
XFILLER_32_207 VPWR VGND sg13cmos5l_decap_8
XFILLER_32_218 VPWR VGND sg13cmos5l_fill_2
XFILLER_43_40 VPWR VGND sg13cmos5l_fill_2
XFILLER_14_966 VPWR VGND sg13cmos5l_decap_8
XFILLER_25_292 VPWR VGND sg13cmos5l_fill_1
XFILLER_9_403 VPWR VGND sg13cmos5l_fill_1
XFILLER_13_454 VPWR VGND sg13cmos5l_decap_8
XFILLER_9_458 VPWR VGND sg13cmos5l_fill_2
XFILLER_13_498 VPWR VGND sg13cmos5l_decap_8
XFILLER_9_469 VPWR VGND sg13cmos5l_fill_1
XFILLER_5_697 VPWR VGND sg13cmos5l_fill_2
XFILLER_4_185 VPWR VGND sg13cmos5l_decap_8
XFILLER_49_841 VPWR VGND sg13cmos5l_decap_8
X_3040_ _3040_/Y _4194_/Q _3040_/B _3047_/C VPWR VGND sg13cmos5l_nor3_1
XFILLER_36_557 VPWR VGND sg13cmos5l_decap_8
X_3942_ _3942_/Y _3954_/A _3948_/S VPWR VGND sg13cmos5l_nor2_1
XFILLER_16_270 VPWR VGND sg13cmos5l_fill_2
X_3873_ _4359_/D _3879_/A _3873_/B _3873_/C VPWR VGND sg13cmos5l_nor3_1
X_2824_ _2833_/B _4184_/Q _4183_/Q _4185_/Q VPWR VGND sg13cmos5l_o21ai_1
XFILLER_20_958 VPWR VGND sg13cmos5l_fill_2
X_2755_ _4159_/D _2818_/A _2804_/D VPWR VGND sg13cmos5l_nor2_1
X_2686_ _2686_/Y _2709_/A _2685_/X _2684_/Y VPWR VGND sg13cmos5l_a21oi_1
X_4356_ _4356_/Q clkload5/A _4356_/D _4356_/RESET_B VPWR VGND sg13cmos5l_dfrbpq_1
X_3307_ _3308_/B _3307_/A _3307_/B VPWR VGND sg13cmos5l_xnor2_1
X_4287_ _4287_/Q _4353_/CLK _4287_/D _4287_/RESET_B VPWR VGND sg13cmos5l_dfrbpq_1
XFILLER_39_362 VPWR VGND sg13cmos5l_fill_1
X_3238_ _3238_/Y _3220_/Y _3236_/Y hold907/X VPWR VGND sg13cmos5l_a21oi_1
X_3169_ _3169_/Y _3169_/A _3169_/B VPWR VGND sg13cmos5l_nor2_1
XFILLER_27_524 VPWR VGND sg13cmos5l_decap_8
XFILLER_27_546 VPWR VGND sg13cmos5l_decap_8
XFILLER_42_505 VPWR VGND sg13cmos5l_decap_8
Xfanout22 _2910_/A2 _2576_/Y VPWR VGND sg13cmos5l_buf_1
Xfanout55 _3079_/B _3029_/A VPWR VGND sg13cmos5l_buf_1
Xfanout33 _2380_/S _2379_/S VPWR VGND sg13cmos5l_buf_1
Xfanout44 _2998_/A _3193_/A VPWR VGND sg13cmos5l_buf_1
Xfanout88 _2708_/S0 _2664_/A1 VPWR VGND sg13cmos5l_buf_1
Xfanout66 _3783_/A hold994/X VPWR VGND sg13cmos5l_buf_1
Xfanout99 _4370_/D _2260_/Y VPWR VGND sg13cmos5l_buf_1
Xfanout77 _2667_/B2 _2700_/B2 VPWR VGND sg13cmos5l_buf_1
XFILLER_13_43 VPWR VGND sg13cmos5l_fill_2
XFILLER_6_428 VPWR VGND sg13cmos5l_decap_4
XFILLER_2_678 VPWR VGND sg13cmos5l_fill_1
XFILLER_1_144 VPWR VGND sg13cmos5l_decap_4
XFILLER_49_148 VPWR VGND sg13cmos5l_fill_2
XFILLER_46_866 VPWR VGND sg13cmos5l_decap_8
XFILLER_33_549 VPWR VGND sg13cmos5l_decap_8
XFILLER_14_763 VPWR VGND sg13cmos5l_fill_1
Xclkload14 clkload14/Y _4303_/CLK VPWR VGND sg13cmos5l_inv_4
XFILLER_6_951 VPWR VGND sg13cmos5l_decap_8
X_2540_ _2544_/B _3911_/B _2517_/Y _2535_/Y _2539_/Y VPWR VGND sg13cmos5l_a22oi_1
XFILLER_5_483 VPWR VGND sg13cmos5l_decap_8
XFILLER_5_472 VPWR VGND sg13cmos5l_fill_1
XFILLER_5_461 VPWR VGND sg13cmos5l_decap_8
X_2471_ _4119_/D _2516_/A _2471_/B VPWR VGND sg13cmos5l_nor2_1
X_4210_ _4210_/Q _4238_/CLK _4210_/D _4210_/RESET_B VPWR VGND sg13cmos5l_dfrbpq_1
X_4141_ _4141_/Q _4161_/CLK _4141_/D _4141_/RESET_B VPWR VGND sg13cmos5l_dfrbpq_1
XFILLER_49_660 VPWR VGND sg13cmos5l_decap_4
X_4072_ _4072_/Q clkload7/A _4072_/D _4072_/RESET_B VPWR VGND sg13cmos5l_dfrbpq_1
X_3023_ _3024_/B _3079_/A _3023_/B _3023_/C _3027_/D VPWR VGND sg13cmos5l_nand4_1
XFILLER_36_398 VPWR VGND sg13cmos5l_fill_2
X_3925_ _3982_/D _3971_/A0 hold803/X _3925_/S VPWR VGND sg13cmos5l_mux2_1
XFILLER_20_733 VPWR VGND sg13cmos5l_decap_8
Xclkload8 clkload8/Y clkload8/A VPWR VGND sg13cmos5l_inv_1
X_3856_ _3856_/Y _3872_/B _3856_/B _3856_/C VPWR VGND sg13cmos5l_nor3_1
XFILLER_20_777 VPWR VGND sg13cmos5l_fill_1
X_3787_ _3787_/Y _4352_/Q _4326_/Q VPWR VGND sg13cmos5l_nand2_1
XFILLER_30_1024 VPWR VGND sg13cmos5l_decap_4
X_2807_ _2808_/B _2807_/A _2807_/B VPWR VGND sg13cmos5l_xnor2_1
X_2738_ _2738_/Y _2765_/B _4158_/Q _2736_/Y VPWR VGND sg13cmos5l_a21oi_1
X_2669_ _2669_/Y _2670_/A1 _2270_/Y _2669_/B1 VPWR VGND sg13cmos5l_o21ai_1
XFILLER_8_1025 VPWR VGND sg13cmos5l_decap_4
X_4339_ _4339_/Q clkload5/A _4339_/D _4339_/RESET_B VPWR VGND sg13cmos5l_dfrbpq_1
XFILLER_28_855 VPWR VGND sg13cmos5l_fill_1
XFILLER_43_825 VPWR VGND sg13cmos5l_fill_1
XFILLER_15_527 VPWR VGND sg13cmos5l_fill_1
XFILLER_15_538 VPWR VGND sg13cmos5l_fill_2
XFILLER_11_700 VPWR VGND sg13cmos5l_fill_2
XFILLER_11_733 VPWR VGND sg13cmos5l_decap_8
XFILLER_11_799 VPWR VGND sg13cmos5l_decap_4
XFILLER_6_0 VPWR VGND sg13cmos5l_fill_2
XFILLER_3_943 VPWR VGND sg13cmos5l_decap_8
XFILLER_46_1020 VPWR VGND sg13cmos5l_decap_8
X_4318__407 _4318_/RESET_B VPWR VGND sg13cmos5l_tiehi
XFILLER_38_608 VPWR VGND sg13cmos5l_decap_4
XFILLER_1_35 VPWR VGND sg13cmos5l_decap_8
XFILLER_18_310 VPWR VGND sg13cmos5l_decap_4
XFILLER_34_803 VPWR VGND sg13cmos5l_decap_4
XFILLER_46_696 VPWR VGND sg13cmos5l_fill_2
XFILLER_33_346 VPWR VGND sg13cmos5l_decap_4
XFILLER_34_858 VPWR VGND sg13cmos5l_decap_8
X_3710_ _3730_/B _4363_/Q _3710_/B VPWR VGND sg13cmos5l_xnor2_1
XFILLER_14_1008 VPWR VGND sg13cmos5l_decap_8
X_3641_ _3660_/A _4327_/Q _3667_/B VPWR VGND sg13cmos5l_nand2_1
X_4225__512 _4225_/RESET_B VPWR VGND sg13cmos5l_tiehi
X_3572_ _4313_/D _3620_/B _3666_/C VPWR VGND sg13cmos5l_and2_1
X_2523_ _2523_/Y _2291_/Y _2523_/B VPWR VGND sg13cmos5l_nand2b_1
X_2454_ _2454_/Y input4/X input2/X VPWR VGND sg13cmos5l_nand2_1
X_4004__374 _4004_/RESET_B VPWR VGND sg13cmos5l_tiehi
X_2385_ _4062_/D _2434_/A0 hold723/X _2390_/S VPWR VGND sg13cmos5l_mux2_1
X_4124_ _4124_/Q _4136_/CLK _4124_/D _4124_/RESET_B VPWR VGND sg13cmos5l_dfrbpq_1
XFILLER_29_608 VPWR VGND sg13cmos5l_fill_1
Xinput1 input1/X rst_n VPWR VGND sg13cmos5l_buf_1
X_4055_ _4055_/Q clkload2/A _4055_/D _4055_/RESET_B VPWR VGND sg13cmos5l_dfrbpq_1
X_3006_ _3026_/A _4190_/Q _3008_/B VPWR VGND sg13cmos5l_nor2_1
XFILLER_37_674 VPWR VGND sg13cmos5l_decap_4
XFILLER_37_696 VPWR VGND sg13cmos5l_fill_1
XFILLER_36_173 VPWR VGND sg13cmos5l_fill_1
XFILLER_33_880 VPWR VGND sg13cmos5l_decap_8
X_3908_ _3908_/Y _3909_/A _3907_/Y _2288_/B VPWR VGND sg13cmos5l_a21oi_1
X_3839_ _3858_/B _3839_/A _3839_/B VPWR VGND sg13cmos5l_or2_1
X_4009__263 _4009_/RESET_B VPWR VGND sg13cmos5l_tiehi
XFILLER_10_11 VPWR VGND sg13cmos5l_decap_8
XFILLER_0_935 VPWR VGND sg13cmos5l_decap_8
XFILLER_27_162 VPWR VGND sg13cmos5l_decap_8
XFILLER_43_688 VPWR VGND sg13cmos5l_decap_8
XFILLER_42_165 VPWR VGND sg13cmos5l_fill_1
XFILLER_30_349 VPWR VGND sg13cmos5l_fill_1
X_4183__570 _4183_/RESET_B VPWR VGND sg13cmos5l_tiehi
XFILLER_38_438 VPWR VGND sg13cmos5l_decap_8
Xheichips26_dna_sequencer_139 uio_oe[7] VPWR VGND sg13cmos5l_tielo
XFILLER_38_449 VPWR VGND sg13cmos5l_fill_1
XFILLER_20_1012 VPWR VGND sg13cmos5l_decap_8
XFILLER_47_961 VPWR VGND sg13cmos5l_decap_8
X_4190__563 _4190_/RESET_B VPWR VGND sg13cmos5l_tiehi
XFILLER_21_316 VPWR VGND sg13cmos5l_decap_8
XFILLER_21_349 VPWR VGND sg13cmos5l_decap_8
X_3624_ _3624_/Y _3562_/A _3562_/B _3531_/B VPWR VGND sg13cmos5l_o21ai_1
X_3555_ _3555_/X _3556_/B _3549_/C _3549_/A VPWR VGND sg13cmos5l_a21o_1
X_2506_ _2506_/Y _2218_/Y _3684_/A _2505_/Y VPWR VGND sg13cmos5l_a21oi_1
X_3486_ _3486_/Y _3476_/Y _3479_/Y _3481_/X _3501_/A _3485_/Y VPWR VGND sg13cmos5l_a221oi_1
X_2437_ _4107_/D _2437_/A0 hold751/X _2440_/S VPWR VGND sg13cmos5l_mux2_1
X_2368_ _4048_/D _2437_/A0 hold683/X _2370_/S VPWR VGND sg13cmos5l_mux2_1
XFILLER_5_1028 VPWR VGND sg13cmos5l_fill_1
XFILLER_5_1017 VPWR VGND sg13cmos5l_decap_8
XFILLER_29_405 VPWR VGND sg13cmos5l_decap_8
X_2299_ _2300_/B _4110_/Q _4093_/Q _4076_/Q _4059_/Q _2665_/A _2658_/S1 VPWR VGND
+ sg13cmos5l_mux4_1
X_4107_ _4107_/Q clkload7/A _4107_/D _4107_/RESET_B VPWR VGND sg13cmos5l_dfrbpq_1
XFILLER_38_972 VPWR VGND sg13cmos5l_decap_8
X_4038_ _4038_/Q _4378_/CLK _4038_/D _4038_/RESET_B VPWR VGND sg13cmos5l_dfrbpq_1
XFILLER_37_471 VPWR VGND sg13cmos5l_decap_8
XFILLER_25_622 VPWR VGND sg13cmos5l_decap_4
XFILLER_25_677 VPWR VGND sg13cmos5l_decap_8
XFILLER_40_669 VPWR VGND sg13cmos5l_decap_8
XFILLER_21_861 VPWR VGND sg13cmos5l_decap_8
XFILLER_20_371 VPWR VGND sg13cmos5l_decap_4
XFILLER_21_32 VPWR VGND sg13cmos5l_decap_8
XFILLER_21_43 VPWR VGND sg13cmos5l_fill_1
XFILLER_21_65 VPWR VGND sg13cmos5l_fill_2
XFILLER_0_732 VPWR VGND sg13cmos5l_decap_8
XFILLER_0_765 VPWR VGND sg13cmos5l_decap_8
XFILLER_48_747 VPWR VGND sg13cmos5l_decap_8
XFILLER_47_257 VPWR VGND sg13cmos5l_decap_8
X_4215__522 _4215_/RESET_B VPWR VGND sg13cmos5l_tiehi
XFILLER_29_961 VPWR VGND sg13cmos5l_decap_8
XFILLER_16_622 VPWR VGND sg13cmos5l_decap_8
XFILLER_44_953 VPWR VGND sg13cmos5l_decap_8
XFILLER_43_452 VPWR VGND sg13cmos5l_fill_2
XFILLER_16_644 VPWR VGND sg13cmos5l_fill_2
XFILLER_16_666 VPWR VGND sg13cmos5l_decap_8
XFILLER_15_165 VPWR VGND sg13cmos5l_fill_2
XFILLER_31_603 VPWR VGND sg13cmos5l_fill_1
XFILLER_30_113 VPWR VGND sg13cmos5l_decap_8
XFILLER_30_124 VPWR VGND sg13cmos5l_fill_1
XFILLER_31_647 VPWR VGND sg13cmos5l_decap_8
XFILLER_31_669 VPWR VGND sg13cmos5l_decap_8
XFILLER_7_12 VPWR VGND sg13cmos5l_decap_8
XFILLER_12_883 VPWR VGND sg13cmos5l_decap_8
XFILLER_7_342 VPWR VGND sg13cmos5l_fill_1
XFILLER_7_331 VPWR VGND sg13cmos5l_decap_8
X_4222__515 _4222_/RESET_B VPWR VGND sg13cmos5l_tiehi
X_3340_ _3340_/Y _3340_/A _3357_/A VPWR VGND sg13cmos5l_xnor2_1
X_3271_ _3298_/A _3293_/B _3293_/C _3153_/Y VPWR VGND sg13cmos5l_a21oi_1
XFILLER_30_4 VPWR VGND sg13cmos5l_fill_2
X_2222_ _3745_/B _2222_/A VPWR VGND sg13cmos5l_inv_1
Xhold1009 _3539_/A _4336_/Q VPWR VGND sg13cmos5l_dlygate4sd3_1
XFILLER_39_758 VPWR VGND sg13cmos5l_decap_8
X_4001__399 _4001_/RESET_B VPWR VGND sg13cmos5l_tiehi
XFILLER_34_441 VPWR VGND sg13cmos5l_fill_1
XFILLER_22_669 VPWR VGND sg13cmos5l_decap_8
X_2986_ _2995_/C _4214_/Q _2987_/B VPWR VGND sg13cmos5l_xor2_1
XFILLER_21_179 VPWR VGND sg13cmos5l_decap_8
Xhold810 hold810/X _4049_/Q VPWR VGND sg13cmos5l_dlygate4sd3_1
X_3607_ _4320_/D _3607_/A _3607_/B VPWR VGND sg13cmos5l_and2_1
Xhold821 _2722_/A _4149_/Q VPWR VGND sg13cmos5l_dlygate4sd3_1
X_3538_ _4307_/D _3620_/B _3625_/A VPWR VGND sg13cmos5l_and2_1
Xhold854 _3441_/A _4268_/Q VPWR VGND sg13cmos5l_dlygate4sd3_1
Xhold843 _3916_/B _3915_/Y VPWR VGND sg13cmos5l_dlygate4sd3_1
Xhold832 _3259_/A _4239_/Q VPWR VGND sg13cmos5l_dlygate4sd3_1
Xhold876 _4318_/D _3606_/Y VPWR VGND sg13cmos5l_dlygate4sd3_1
Xhold887 hold887/X _4253_/Q VPWR VGND sg13cmos5l_dlygate4sd3_1
Xhold898 hold898/X _2903_/Y VPWR VGND sg13cmos5l_dlygate4sd3_1
Xhold865 _2500_/A _4129_/Q VPWR VGND sg13cmos5l_dlygate4sd3_1
X_3469_ _3490_/A _3467_/X _3468_/X _3460_/Y VPWR VGND sg13cmos5l_o21ai_1
X_4173__580 _4173_/RESET_B VPWR VGND sg13cmos5l_tiehi
XFILLER_16_32 VPWR VGND sg13cmos5l_fill_1
XFILLER_26_953 VPWR VGND sg13cmos5l_decap_4
XFILLER_41_934 VPWR VGND sg13cmos5l_decap_8
XFILLER_25_474 VPWR VGND sg13cmos5l_decap_8
XFILLER_26_997 VPWR VGND sg13cmos5l_decap_8
XFILLER_12_113 VPWR VGND sg13cmos5l_decap_4
XFILLER_5_824 VPWR VGND sg13cmos5l_decap_4
XFILLER_4_301 VPWR VGND sg13cmos5l_decap_8
XFILLER_10_1011 VPWR VGND sg13cmos5l_decap_8
X_4180__573 _4180_/RESET_B VPWR VGND sg13cmos5l_tiehi
XFILLER_4_367 VPWR VGND sg13cmos5l_fill_2
X_3998__406 _3998_/RESET_B VPWR VGND sg13cmos5l_tiehi
XFILLER_17_931 VPWR VGND sg13cmos5l_fill_2
XFILLER_17_942 VPWR VGND sg13cmos5l_decap_8
XFILLER_17_953 VPWR VGND sg13cmos5l_fill_1
X_4289__442 _4289_/RESET_B VPWR VGND sg13cmos5l_tiehi
X_2840_ _3009_/A _3079_/A _2841_/B VPWR VGND sg13cmos5l_xnor2_1
X_2771_ _2771_/Y _2771_/A _2771_/B VPWR VGND sg13cmos5l_nor2_1
XFILLER_12_680 VPWR VGND sg13cmos5l_decap_8
XFILLER_8_684 VPWR VGND sg13cmos5l_decap_8
X_4372_ _4372_/Q _4377_/CLK _4372_/D _4372_/RESET_B VPWR VGND sg13cmos5l_dfrbpq_1
X_3323_ _3323_/Y _3323_/A _3607_/B VPWR VGND sg13cmos5l_nor2_1
XFILLER_39_511 VPWR VGND sg13cmos5l_decap_8
X_3254_ _4261_/D _3254_/A _3254_/B VPWR VGND sg13cmos5l_and2_1
XFILLER_39_555 VPWR VGND sg13cmos5l_fill_1
XFILLER_2_1009 VPWR VGND sg13cmos5l_decap_8
XFILLER_27_706 VPWR VGND sg13cmos5l_fill_2
X_3185_ _3185_/X _3182_/B _3175_/C _3175_/A VPWR VGND sg13cmos5l_a21o_1
XFILLER_35_761 VPWR VGND sg13cmos5l_fill_2
XFILLER_22_433 VPWR VGND sg13cmos5l_decap_8
XFILLER_22_444 VPWR VGND sg13cmos5l_fill_2
X_2969_ _2969_/Y _2998_/A _3189_/A VPWR VGND sg13cmos5l_nand2_1
X_4205__532 _4205_/RESET_B VPWR VGND sg13cmos5l_tiehi
Xhold640 _2516_/B _2515_/Y VPWR VGND sg13cmos5l_dlygate4sd3_1
Xhold662 _4130_/D _2504_/Y VPWR VGND sg13cmos5l_dlygate4sd3_1
XFILLER_1_315 VPWR VGND sg13cmos5l_fill_1
Xhold651 _2213_/A _4321_/Q VPWR VGND sg13cmos5l_dlygate4sd3_1
Xhold684 hold684/X _4095_/Q VPWR VGND sg13cmos5l_dlygate4sd3_1
Xhold673 hold673/X _4071_/Q VPWR VGND sg13cmos5l_dlygate4sd3_1
Xhold695 _2288_/B _4368_/Q VPWR VGND sg13cmos5l_dlygate4sd3_1
XFILLER_49_308 VPWR VGND sg13cmos5l_decap_4
XFILLER_40_1015 VPWR VGND sg13cmos5l_decap_8
X_4212__525 _4212_/RESET_B VPWR VGND sg13cmos5l_tiehi
XFILLER_27_75 VPWR VGND sg13cmos5l_decap_8
XFILLER_27_86 VPWR VGND sg13cmos5l_fill_2
XFILLER_41_742 VPWR VGND sg13cmos5l_decap_8
XFILLER_13_411 VPWR VGND sg13cmos5l_decap_8
XFILLER_13_433 VPWR VGND sg13cmos5l_decap_8
XFILLER_14_945 VPWR VGND sg13cmos5l_decap_8
XFILLER_41_753 VPWR VGND sg13cmos5l_fill_1
XFILLER_9_448 VPWR VGND sg13cmos5l_fill_1
XFILLER_5_676 VPWR VGND sg13cmos5l_decap_8
XFILLER_49_820 VPWR VGND sg13cmos5l_decap_8
X_4098__286 _4098_/RESET_B VPWR VGND sg13cmos5l_tiehi
XFILLER_0_370 VPWR VGND sg13cmos5l_decap_4
XFILLER_0_381 VPWR VGND sg13cmos5l_decap_8
XFILLER_49_897 VPWR VGND sg13cmos5l_decap_8
XFILLER_36_514 VPWR VGND sg13cmos5l_decap_8
XFILLER_1_1020 VPWR VGND sg13cmos5l_decap_8
X_3941_ _3994_/D _2262_/Y _3948_/S _3940_/Y VPWR VGND sg13cmos5l_a21oi_1
X_3872_ _3873_/C _3877_/A _3872_/B _3877_/C VPWR VGND sg13cmos5l_and3_1
XFILLER_32_764 VPWR VGND sg13cmos5l_fill_2
XFILLER_32_775 VPWR VGND sg13cmos5l_decap_8
X_2823_ _2823_/Y _2823_/A _2833_/A VPWR VGND sg13cmos5l_xnor2_1
XFILLER_20_937 VPWR VGND sg13cmos5l_decap_8
X_4146__210 _4146_/RESET_B VPWR VGND sg13cmos5l_tiehi
X_2754_ _2804_/D _2735_/Y _2744_/Y _2879_/A VPWR VGND sg13cmos5l_a21oi_1
XFILLER_9_993 VPWR VGND sg13cmos5l_decap_8
X_2685_ _2685_/X _4095_/Q _4078_/Q _4061_/Q _4044_/Q _2698_/A _2700_/B2 VPWR VGND
+ sg13cmos5l_mux4_1
X_4355_ _4355_/Q clkload5/A _4355_/D _4355_/RESET_B VPWR VGND sg13cmos5l_dfrbpq_1
X_3306_ _3307_/B _3306_/A _3306_/B VPWR VGND sg13cmos5l_xor2_1
X_4286_ _4286_/Q _4353_/CLK _4286_/D _4286_/RESET_B VPWR VGND sg13cmos5l_dfrbpq_1
X_3237_ _3237_/Y hold906/X _3236_/Y _3260_/B VPWR VGND sg13cmos5l_o21ai_1
X_3168_ _3168_/Y _3168_/A _3380_/A VPWR VGND sg13cmos5l_nand2_1
XFILLER_27_503 VPWR VGND sg13cmos5l_fill_2
XFILLER_15_709 VPWR VGND sg13cmos5l_decap_8
X_3099_ _3107_/B _3113_/A _3112_/B _3096_/Y _3097_/Y _3098_/Y VPWR VGND sg13cmos5l_a221oi_1
XFILLER_23_731 VPWR VGND sg13cmos5l_decap_8
Xfanout45 _3879_/A _3772_/A VPWR VGND sg13cmos5l_buf_1
Xfanout34 _2359_/S _2357_/S VPWR VGND sg13cmos5l_buf_1
Xfanout23 _2784_/A2 _3072_/A2 VPWR VGND sg13cmos5l_buf_1
Xfanout56 _3123_/A _2963_/Y VPWR VGND sg13cmos5l_buf_1
Xfanout67 _2851_/A hold1000/X VPWR VGND sg13cmos5l_buf_1
Xfanout78 _2708_/S1 _2700_/B2 VPWR VGND sg13cmos5l_buf_1
XFILLER_7_908 VPWR VGND sg13cmos5l_fill_1
XFILLER_10_403 VPWR VGND sg13cmos5l_fill_1
XFILLER_13_11 VPWR VGND sg13cmos5l_fill_2
Xfanout89 _2647_/A _2632_/S VPWR VGND sg13cmos5l_buf_1
XFILLER_22_296 VPWR VGND sg13cmos5l_fill_2
XFILLER_13_77 VPWR VGND sg13cmos5l_decap_8
XFILLER_8_4 VPWR VGND sg13cmos5l_fill_2
X_4279__452 _4279_/RESET_B VPWR VGND sg13cmos5l_tiehi
XFILLER_1_123 VPWR VGND sg13cmos5l_decap_8
XFILLER_49_127 VPWR VGND sg13cmos5l_decap_8
XFILLER_38_52 VPWR VGND sg13cmos5l_decap_8
XFILLER_46_845 VPWR VGND sg13cmos5l_decap_8
XFILLER_45_399 VPWR VGND sg13cmos5l_decap_8
XFILLER_14_742 VPWR VGND sg13cmos5l_decap_4
X_4286__445 _4286_/RESET_B VPWR VGND sg13cmos5l_tiehi
XFILLER_9_201 VPWR VGND sg13cmos5l_fill_1
XFILLER_6_930 VPWR VGND sg13cmos5l_decap_8
Xclkload15 clkload15/Y _4333_/CLK VPWR VGND sg13cmos5l_inv_4
X_4245__164 _4245_/D VPWR VGND sg13cmos5l_tielo
XFILLER_5_440 VPWR VGND sg13cmos5l_decap_8
X_2470_ _2470_/Y _4119_/Q _2461_/B _2456_/B hold648/X VPWR VGND sg13cmos5l_a22oi_1
X_4140_ _4140_/Q _4378_/CLK _4140_/D _4140_/RESET_B VPWR VGND sg13cmos5l_dfrbpq_1
X_4071_ _4071_/Q clkload7/A _4071_/D _4071_/RESET_B VPWR VGND sg13cmos5l_dfrbpq_1
XFILLER_49_683 VPWR VGND sg13cmos5l_decap_8
X_3022_ _3024_/A _4187_/Q _3026_/A _3026_/C VPWR VGND sg13cmos5l_nand3b_1
XFILLER_48_193 VPWR VGND sg13cmos5l_decap_4
XFILLER_36_322 VPWR VGND sg13cmos5l_decap_4
XFILLER_24_517 VPWR VGND sg13cmos5l_decap_8
XFILLER_24_528 VPWR VGND sg13cmos5l_fill_1
X_3924_ _3981_/D _3946_/A hold727/X _3925_/S VPWR VGND sg13cmos5l_mux2_1
XFILLER_32_561 VPWR VGND sg13cmos5l_fill_2
Xclkload9 clkload9/Y clkload9/A VPWR VGND sg13cmos5l_inv_1
X_3855_ _3855_/Y _3855_/A VPWR VGND sg13cmos5l_inv_1
X_3786_ _4357_/D _3786_/A _3786_/B VPWR VGND sg13cmos5l_nor2_1
XFILLER_30_1003 VPWR VGND sg13cmos5l_decap_8
X_2806_ _2807_/B _2806_/A _2806_/B VPWR VGND sg13cmos5l_nor2_1
X_2737_ _2749_/A _4157_/Q _2737_/B VPWR VGND sg13cmos5l_xor2_1
X_2668_ _2668_/X _4039_/Q _4022_/Q _2701_/S VPWR VGND sg13cmos5l_mux2_1
X_4202__535 _4202_/RESET_B VPWR VGND sg13cmos5l_tiehi
XFILLER_8_1004 VPWR VGND sg13cmos5l_decap_8
X_2599_ _2599_/Y _2701_/S _2263_/Y _2704_/A1 VPWR VGND sg13cmos5l_o21ai_1
X_4338_ _4338_/Q clkload6/A _4338_/D _4338_/RESET_B VPWR VGND sg13cmos5l_dfrbpq_1
X_4269_ _4269_/Q _4272_/CLK _4269_/D _4269_/RESET_B VPWR VGND sg13cmos5l_dfrbpq_1
XFILLER_43_804 VPWR VGND sg13cmos5l_decap_8
XFILLER_43_837 VPWR VGND sg13cmos5l_fill_1
XFILLER_42_358 VPWR VGND sg13cmos5l_fill_2
XFILLER_42_347 VPWR VGND sg13cmos5l_decap_8
XFILLER_24_32 VPWR VGND sg13cmos5l_decap_8
XFILLER_10_200 VPWR VGND sg13cmos5l_fill_2
XFILLER_11_723 VPWR VGND sg13cmos5l_decap_4
XFILLER_24_43 VPWR VGND sg13cmos5l_fill_1
XFILLER_10_244 VPWR VGND sg13cmos5l_decap_4
X_4088__296 _4088_/RESET_B VPWR VGND sg13cmos5l_tiehi
XFILLER_40_20 VPWR VGND sg13cmos5l_fill_2
XFILLER_10_266 VPWR VGND sg13cmos5l_decap_4
XFILLER_6_259 VPWR VGND sg13cmos5l_decap_8
XFILLER_6_237 VPWR VGND sg13cmos5l_decap_8
XFILLER_3_922 VPWR VGND sg13cmos5l_decap_8
XFILLER_2_421 VPWR VGND sg13cmos5l_fill_2
XFILLER_3_999 VPWR VGND sg13cmos5l_decap_8
XFILLER_2_454 VPWR VGND sg13cmos5l_decap_8
XFILLER_49_95 VPWR VGND sg13cmos5l_decap_8
XFILLER_1_14 VPWR VGND sg13cmos5l_decap_8
X_4095__289 _4095_/RESET_B VPWR VGND sg13cmos5l_tiehi
XFILLER_37_119 VPWR VGND sg13cmos5l_decap_8
XFILLER_46_686 VPWR VGND sg13cmos5l_fill_1
XFILLER_46_675 VPWR VGND sg13cmos5l_decap_8
XFILLER_18_388 VPWR VGND sg13cmos5l_fill_2
XFILLER_33_325 VPWR VGND sg13cmos5l_decap_8
XFILLER_34_837 VPWR VGND sg13cmos5l_fill_2
XFILLER_34_848 VPWR VGND sg13cmos5l_decap_4
X_3640_ _3640_/Y _4331_/Q _3667_/B VPWR VGND sg13cmos5l_nand2_1
X_3571_ _3666_/C _3547_/X _3556_/X _3361_/Y VPWR VGND sg13cmos5l_o21ai_1
X_2522_ _2576_/A _2522_/A _3901_/B _2522_/C _2522_/D VPWR VGND sg13cmos5l_nor4_1
X_2453_ _2463_/B input4/X input2/X VPWR VGND sg13cmos5l_and2_1
X_2384_ _4061_/D _3965_/A0 hold771/X _2390_/S VPWR VGND sg13cmos5l_mux2_1
X_4123_ _4123_/Q _4136_/CLK _4123_/D _4123_/RESET_B VPWR VGND sg13cmos5l_dfrbpq_1
X_4054_ _4054_/Q clkload2/A _4054_/D _4054_/RESET_B VPWR VGND sg13cmos5l_dfrbpq_1
Xinput2 input2/X ui_in[0] VPWR VGND sg13cmos5l_buf_1
XFILLER_49_491 VPWR VGND sg13cmos5l_decap_8
X_3005_ _3016_/B _4189_/Q _4187_/Q _4188_/Q VPWR VGND sg13cmos5l_or3_1
XFILLER_37_653 VPWR VGND sg13cmos5l_decap_8
XFILLER_36_152 VPWR VGND sg13cmos5l_fill_2
XFILLER_40_807 VPWR VGND sg13cmos5l_fill_1
XFILLER_40_829 VPWR VGND sg13cmos5l_decap_8
X_4269__462 _4269_/RESET_B VPWR VGND sg13cmos5l_tiehi
X_3907_ _3907_/Y _3907_/A _3909_/C VPWR VGND sg13cmos5l_nand2_1
XFILLER_32_380 VPWR VGND sg13cmos5l_fill_1
X_3838_ _3838_/X _3724_/X _3828_/A _3837_/Y VPWR VGND sg13cmos5l_a21o_1
X_3769_ _3769_/Y _3754_/A _3771_/S _3783_/B VPWR VGND sg13cmos5l_o21ai_1
XFILLER_0_914 VPWR VGND sg13cmos5l_decap_8
XFILLER_10_67 VPWR VGND sg13cmos5l_decap_8
X_4276__455 _4276_/RESET_B VPWR VGND sg13cmos5l_tiehi
XFILLER_48_929 VPWR VGND sg13cmos5l_decap_8
XFILLER_16_826 VPWR VGND sg13cmos5l_decap_8
XFILLER_27_141 VPWR VGND sg13cmos5l_decap_8
XFILLER_15_314 VPWR VGND sg13cmos5l_decap_8
X_4283__448 _4283_/RESET_B VPWR VGND sg13cmos5l_tiehi
XFILLER_11_553 VPWR VGND sg13cmos5l_fill_2
XFILLER_11_564 VPWR VGND sg13cmos5l_fill_2
XFILLER_7_557 VPWR VGND sg13cmos5l_decap_8
XFILLER_47_940 VPWR VGND sg13cmos5l_decap_8
XFILLER_19_631 VPWR VGND sg13cmos5l_decap_8
XFILLER_19_642 VPWR VGND sg13cmos5l_fill_1
XFILLER_18_185 VPWR VGND sg13cmos5l_fill_1
XFILLER_19_686 VPWR VGND sg13cmos5l_fill_1
XFILLER_33_122 VPWR VGND sg13cmos5l_fill_1
XFILLER_15_892 VPWR VGND sg13cmos5l_fill_2
XFILLER_33_199 VPWR VGND sg13cmos5l_fill_1
X_3623_ _3623_/Y _3626_/B _3626_/C _3626_/A VPWR VGND sg13cmos5l_o21ai_1
X_3554_ _3554_/X _3554_/A _3554_/B _3554_/C VPWR VGND sg13cmos5l_and3_1
X_2505_ _2505_/Y _3684_/A _4131_/Q _2509_/B1 VPWR VGND sg13cmos5l_o21ai_1
X_3485_ _3485_/Y _3476_/B _3476_/C _3476_/A VPWR VGND sg13cmos5l_a21oi_1
X_2436_ _4106_/D _2436_/A0 hold766/X _2440_/S VPWR VGND sg13cmos5l_mux2_1
X_2367_ _4047_/D _2436_/A0 hold794/X _2370_/S VPWR VGND sg13cmos5l_mux2_1
XFILLER_38_951 VPWR VGND sg13cmos5l_decap_8
X_2298_ _2298_/Y _2658_/S1 _2297_/X _2659_/A VPWR VGND sg13cmos5l_a21oi_1
X_4106_ _4106_/Q clkload7/A _4106_/D _4106_/RESET_B VPWR VGND sg13cmos5l_dfrbpq_1
X_4037_ _4037_/Q clkload3/A _4037_/D _4037_/RESET_B VPWR VGND sg13cmos5l_dfrbpq_1
XFILLER_40_648 VPWR VGND sg13cmos5l_decap_8
XFILLER_21_11 VPWR VGND sg13cmos5l_decap_8
X_4085__299 _4085_/RESET_B VPWR VGND sg13cmos5l_tiehi
XFILLER_0_700 VPWR VGND sg13cmos5l_fill_1
XFILLER_43_1024 VPWR VGND sg13cmos5l_decap_4
XFILLER_0_788 VPWR VGND sg13cmos5l_decap_8
XFILLER_29_940 VPWR VGND sg13cmos5l_decap_8
XFILLER_47_269 VPWR VGND sg13cmos5l_decap_4
XFILLER_44_932 VPWR VGND sg13cmos5l_decap_8
XFILLER_43_431 VPWR VGND sg13cmos5l_decap_8
XFILLER_43_475 VPWR VGND sg13cmos5l_fill_2
XFILLER_16_678 VPWR VGND sg13cmos5l_decap_8
XFILLER_30_136 VPWR VGND sg13cmos5l_decap_4
XFILLER_12_862 VPWR VGND sg13cmos5l_decap_8
XFILLER_30_147 VPWR VGND sg13cmos5l_decap_4
XFILLER_7_310 VPWR VGND sg13cmos5l_decap_8
XFILLER_7_24 VPWR VGND sg13cmos5l_decap_8
X_3270_ _3270_/Y _3270_/A _3270_/B VPWR VGND sg13cmos5l_nor2_1
X_2221_ _2221_/Y _4316_/Q VPWR VGND sg13cmos5l_inv_1
XFILLER_23_4 VPWR VGND sg13cmos5l_decap_4
XFILLER_35_910 VPWR VGND sg13cmos5l_decap_8
XFILLER_22_626 VPWR VGND sg13cmos5l_fill_2
XFILLER_34_475 VPWR VGND sg13cmos5l_decap_8
XFILLER_34_486 VPWR VGND sg13cmos5l_fill_1
XFILLER_21_114 VPWR VGND sg13cmos5l_decap_8
X_2985_ _2995_/B _2969_/Y _2974_/Y _2983_/Y _2984_/Y VPWR VGND sg13cmos5l_a22oi_1
XFILLER_21_158 VPWR VGND sg13cmos5l_fill_2
X_4266__465 _4266_/RESET_B VPWR VGND sg13cmos5l_tiehi
XFILLER_30_692 VPWR VGND sg13cmos5l_fill_2
Xhold800 hold800/X _4081_/Q VPWR VGND sg13cmos5l_dlygate4sd3_1
X_3606_ _3606_/Y _3595_/B hold875/X _3681_/A VPWR VGND sg13cmos5l_a21oi_1
Xhold811 hold811/X _4170_/Q VPWR VGND sg13cmos5l_dlygate4sd3_1
X_3537_ _3625_/A _3535_/Y _3537_/B VPWR VGND sg13cmos5l_nand2b_1
Xhold833 _3635_/A _4323_/Q VPWR VGND sg13cmos5l_dlygate4sd3_1
Xhold855 _3900_/A _4367_/Q VPWR VGND sg13cmos5l_dlygate4sd3_1
Xhold822 _3431_/B _4256_/Q VPWR VGND sg13cmos5l_dlygate4sd3_1
Xhold844 hold844/X _4138_/Q VPWR VGND sg13cmos5l_dlygate4sd3_1
Xhold888 _3243_/B _3242_/Y VPWR VGND sg13cmos5l_dlygate4sd3_1
XFILLER_27_1008 VPWR VGND sg13cmos5l_decap_8
Xhold877 _3260_/A _4240_/Q VPWR VGND sg13cmos5l_dlygate4sd3_1
Xhold866 _2502_/A _2498_/Y VPWR VGND sg13cmos5l_dlygate4sd3_1
X_3468_ _3468_/X _4298_/Q _3488_/B _3459_/Y VPWR VGND sg13cmos5l_a21o_1
Xhold899 _4193_/D _2904_/Y VPWR VGND sg13cmos5l_dlygate4sd3_1
X_3399_ _3399_/Y _3619_/A _4253_/Q _3396_/Y _3398_/Y _3397_/Y VPWR VGND sg13cmos5l_a221oi_1
X_2419_ _4092_/D _2439_/A0 hold675/X _2419_/S VPWR VGND sg13cmos5l_mux2_1
X_4273__458 _4273_/RESET_B VPWR VGND sg13cmos5l_tiehi
XFILLER_17_409 VPWR VGND sg13cmos5l_fill_1
XFILLER_38_792 VPWR VGND sg13cmos5l_decap_8
XFILLER_26_921 VPWR VGND sg13cmos5l_decap_8
XFILLER_25_431 VPWR VGND sg13cmos5l_decap_8
XFILLER_25_442 VPWR VGND sg13cmos5l_fill_1
XFILLER_26_976 VPWR VGND sg13cmos5l_decap_8
XFILLER_9_619 VPWR VGND sg13cmos5l_decap_8
XFILLER_12_158 VPWR VGND sg13cmos5l_fill_2
XFILLER_0_541 VPWR VGND sg13cmos5l_decap_4
XFILLER_48_567 VPWR VGND sg13cmos5l_fill_1
XFILLER_43_261 VPWR VGND sg13cmos5l_fill_2
XFILLER_32_968 VPWR VGND sg13cmos5l_fill_2
X_2770_ _2771_/B _4167_/Q _2740_/Y _2776_/A VPWR VGND sg13cmos5l_o21ai_1
XFILLER_8_663 VPWR VGND sg13cmos5l_decap_8
XFILLER_7_140 VPWR VGND sg13cmos5l_decap_8
XFILLER_7_184 VPWR VGND sg13cmos5l_fill_1
X_4371_ _4371_/Q _4378_/CLK _4371_/D _4371_/RESET_B VPWR VGND sg13cmos5l_dfrbpq_1
X_3322_ _4271_/D _3311_/A _3318_/A _3321_/Y VPWR VGND sg13cmos5l_a21oi_1
X_3253_ _4260_/D _3607_/A _3253_/B VPWR VGND sg13cmos5l_and2_1
X_3184_ _3184_/Y _3182_/B _3175_/C _3175_/A VPWR VGND sg13cmos5l_a21oi_1
XFILLER_27_729 VPWR VGND sg13cmos5l_decap_4
XFILLER_35_740 VPWR VGND sg13cmos5l_fill_2
XFILLER_34_261 VPWR VGND sg13cmos5l_decap_8
XFILLER_23_946 VPWR VGND sg13cmos5l_decap_8
XFILLER_10_618 VPWR VGND sg13cmos5l_fill_1
XFILLER_22_467 VPWR VGND sg13cmos5l_fill_2
X_2968_ _3189_/A _2966_/B _2968_/B VPWR VGND sg13cmos5l_nand2b_1
X_2899_ _2899_/X _2893_/B _3040_/B _2901_/S VPWR VGND sg13cmos5l_mux2_1
XFILLER_2_806 VPWR VGND sg13cmos5l_decap_8
Xhold630 _4226_/D _3068_/Y VPWR VGND sg13cmos5l_dlygate4sd3_1
Xhold663 hold663/X _3993_/Q VPWR VGND sg13cmos5l_dlygate4sd3_1
Xhold652 _4321_/D _3609_/Y VPWR VGND sg13cmos5l_dlygate4sd3_1
Xhold641 _2227_/A _4197_/Q VPWR VGND sg13cmos5l_dlygate4sd3_1
Xhold685 hold685/X _4066_/Q VPWR VGND sg13cmos5l_dlygate4sd3_1
Xhold674 hold674/X _4076_/Q VPWR VGND sg13cmos5l_dlygate4sd3_1
Xhold696 _3910_/B _3908_/Y VPWR VGND sg13cmos5l_dlygate4sd3_1
XFILLER_25_283 VPWR VGND sg13cmos5l_decap_8
XFILLER_43_97 VPWR VGND sg13cmos5l_decap_8
XFILLER_40_275 VPWR VGND sg13cmos5l_fill_2
XFILLER_40_264 VPWR VGND sg13cmos5l_decap_8
XFILLER_9_427 VPWR VGND sg13cmos5l_decap_8
XFILLER_13_489 VPWR VGND sg13cmos5l_decap_4
XFILLER_5_699 VPWR VGND sg13cmos5l_fill_1
XFILLER_1_894 VPWR VGND sg13cmos5l_decap_8
XFILLER_49_876 VPWR VGND sg13cmos5l_decap_8
XFILLER_48_386 VPWR VGND sg13cmos5l_decap_4
X_3940_ _3940_/Y _3952_/A _3948_/S VPWR VGND sg13cmos5l_nor2_1
XFILLER_32_743 VPWR VGND sg13cmos5l_fill_2
X_3871_ _3873_/B _3845_/A _3854_/S _3877_/C _3877_/A _3856_/C VPWR VGND sg13cmos5l_a221oi_1
XFILLER_17_1018 VPWR VGND sg13cmos5l_decap_8
X_2822_ _2822_/X _2822_/A _2833_/A VPWR VGND sg13cmos5l_or2_1
X_2753_ _4158_/D _2818_/A _2804_/C VPWR VGND sg13cmos5l_nor2_1
XFILLER_9_972 VPWR VGND sg13cmos5l_decap_8
X_4263__468 _4263_/RESET_B VPWR VGND sg13cmos5l_tiehi
X_2684_ _2684_/Y _2690_/A1 _2681_/Y _2682_/Y _2683_/Y _2709_/A VPWR VGND sg13cmos5l_a221oi_1
X_4354_ _4354_/Q _4377_/CLK _4354_/D _4354_/RESET_B VPWR VGND sg13cmos5l_dfrbpq_1
X_3305_ _3311_/A _3305_/A _3305_/B VPWR VGND sg13cmos5l_nor2_1
X_4285_ _4285_/Q _4353_/CLK _4285_/D _4285_/RESET_B VPWR VGND sg13cmos5l_dfrbpq_1
X_3236_ _3236_/Y _3230_/Y _3233_/Y _3235_/Y VPWR VGND sg13cmos5l_o21ai_1
X_3167_ _4243_/D _3260_/B _3167_/B VPWR VGND sg13cmos5l_and2_1
X_3098_ _3098_/Y _3096_/A _3096_/B _3096_/C _3096_/D VPWR VGND sg13cmos5l_a22oi_1
XFILLER_23_721 VPWR VGND sg13cmos5l_fill_1
XFILLER_35_570 VPWR VGND sg13cmos5l_decap_8
Xfanout46 _3786_/B _3772_/A VPWR VGND sg13cmos5l_buf_1
XFILLER_22_220 VPWR VGND sg13cmos5l_decap_8
Xfanout24 _3779_/A2 _3072_/A2 VPWR VGND sg13cmos5l_buf_1
Xfanout35 _2336_/B _2334_/S VPWR VGND sg13cmos5l_buf_1
Xfanout57 _2918_/B _2960_/A VPWR VGND sg13cmos5l_buf_1
XFILLER_11_949 VPWR VGND sg13cmos5l_decap_8
Xfanout79 _2700_/B2 _4112_/Q VPWR VGND sg13cmos5l_buf_1
Xfanout68 _3076_/A _3023_/B VPWR VGND sg13cmos5l_buf_1
XFILLER_10_437 VPWR VGND sg13cmos5l_decap_4
XFILLER_13_45 VPWR VGND sg13cmos5l_fill_1
XFILLER_13_56 VPWR VGND sg13cmos5l_decap_8
XFILLER_2_669 VPWR VGND sg13cmos5l_decap_8
XFILLER_49_106 VPWR VGND sg13cmos5l_decap_8
XFILLER_38_20 VPWR VGND sg13cmos5l_decap_4
XFILLER_46_824 VPWR VGND sg13cmos5l_decap_8
XFILLER_38_75 VPWR VGND sg13cmos5l_decap_8
XFILLER_45_378 VPWR VGND sg13cmos5l_decap_8
XFILLER_14_798 VPWR VGND sg13cmos5l_decap_4
XFILLER_9_279 VPWR VGND sg13cmos5l_decap_4
Xclkload16 clkload16/Y _4353_/CLK VPWR VGND sg13cmos5l_inv_2
XFILLER_6_986 VPWR VGND sg13cmos5l_decap_8
X_4070_ _4070_/Q clkload2/A _4070_/D _4070_/RESET_B VPWR VGND sg13cmos5l_dfrbpq_1
XFILLER_23_1011 VPWR VGND sg13cmos5l_decap_8
X_3021_ _3026_/C _3021_/A _3021_/B _3021_/C VPWR VGND sg13cmos5l_or3_1
XFILLER_37_824 VPWR VGND sg13cmos5l_fill_2
XFILLER_48_172 VPWR VGND sg13cmos5l_decap_8
XFILLER_37_846 VPWR VGND sg13cmos5l_decap_8
X_3923_ _3980_/D _3958_/A hold779/X _3925_/S VPWR VGND sg13cmos5l_mux2_1
X_3854_ _3855_/A _3729_/B _3836_/Y _3854_/S VPWR VGND sg13cmos5l_mux2_1
X_2805_ _2805_/Y _2805_/A _2805_/B VPWR VGND sg13cmos5l_nand2_1
XFILLER_20_768 VPWR VGND sg13cmos5l_decap_8
X_3785_ _4356_/D _3785_/A _3786_/B VPWR VGND sg13cmos5l_nor2_1
X_2736_ _2736_/Y _4179_/Q _4157_/Q VPWR VGND sg13cmos5l_nand2_1
X_2667_ _2673_/A _2663_/Y _2664_/Y _2666_/Y _2667_/B2 _2300_/A VPWR VGND sg13cmos5l_a221oi_1
X_2598_ _2598_/X _4032_/Q _4015_/Q _2701_/S VPWR VGND sg13cmos5l_mux2_1
X_4120__258 _4120_/RESET_B VPWR VGND sg13cmos5l_tiehi
X_4337_ _4337_/Q clkload6/A _4337_/D _4337_/RESET_B VPWR VGND sg13cmos5l_dfrbpq_1
X_4268_ _4268_/Q _4272_/CLK _4268_/D _4268_/RESET_B VPWR VGND sg13cmos5l_dfrbpq_1
X_3219_ _3219_/Y _3225_/B _3441_/A VPWR VGND sg13cmos5l_nor2b_1
XFILLER_28_824 VPWR VGND sg13cmos5l_decap_8
X_4199_ _4199_/Q _4225_/CLK _4199_/D _4199_/RESET_B VPWR VGND sg13cmos5l_dfrbpq_1
XFILLER_28_846 VPWR VGND sg13cmos5l_decap_8
XFILLER_15_507 VPWR VGND sg13cmos5l_decap_8
XFILLER_43_849 VPWR VGND sg13cmos5l_decap_8
XFILLER_23_551 VPWR VGND sg13cmos5l_fill_1
XFILLER_24_11 VPWR VGND sg13cmos5l_fill_2
XFILLER_11_702 VPWR VGND sg13cmos5l_fill_1
XFILLER_10_223 VPWR VGND sg13cmos5l_decap_8
XFILLER_24_88 VPWR VGND sg13cmos5l_decap_8
XFILLER_7_717 VPWR VGND sg13cmos5l_fill_2
XFILLER_3_901 VPWR VGND sg13cmos5l_decap_8
XFILLER_6_2 VPWR VGND sg13cmos5l_fill_1
XFILLER_3_978 VPWR VGND sg13cmos5l_decap_8
XFILLER_2_488 VPWR VGND sg13cmos5l_decap_4
XFILLER_49_74 VPWR VGND sg13cmos5l_decap_8
XFILLER_1_59 VPWR VGND sg13cmos5l_decap_8
XFILLER_19_835 VPWR VGND sg13cmos5l_fill_2
XFILLER_19_846 VPWR VGND sg13cmos5l_fill_2
XFILLER_45_153 VPWR VGND sg13cmos5l_decap_4
XFILLER_18_367 VPWR VGND sg13cmos5l_decap_8
XFILLER_34_816 VPWR VGND sg13cmos5l_decap_8
XFILLER_33_304 VPWR VGND sg13cmos5l_decap_8
XFILLER_14_540 VPWR VGND sg13cmos5l_decap_8
X_3570_ _4312_/D _3619_/B _3625_/B VPWR VGND sg13cmos5l_nor2_1
XFILLER_6_761 VPWR VGND sg13cmos5l_fill_2
XFILLER_6_750 VPWR VGND sg13cmos5l_decap_8
X_2521_ _2522_/D _2518_/Y _2519_/Y _2520_/Y _2528_/B VPWR VGND sg13cmos5l_a22oi_1
XFILLER_6_783 VPWR VGND sg13cmos5l_fill_1
XFILLER_5_282 VPWR VGND sg13cmos5l_fill_2
X_2452_ _4113_/D _2235_/Y _2449_/B _2451_/Y VPWR VGND sg13cmos5l_a21oi_1
X_2383_ _4060_/D _3964_/A0 hold701/X _2390_/S VPWR VGND sg13cmos5l_mux2_1
X_4122_ _4122_/Q _4136_/CLK _4122_/D _4122_/RESET_B VPWR VGND sg13cmos5l_dfrbpq_1
X_4053_ _4053_/Q clkload2/A _4053_/D _4053_/RESET_B VPWR VGND sg13cmos5l_dfrbpq_1
X_3004_ _3008_/B _4189_/Q _4187_/Q _4188_/Q VPWR VGND sg13cmos5l_nor3_1
Xinput3 input3/X ui_in[1] VPWR VGND sg13cmos5l_buf_1
XFILLER_37_687 VPWR VGND sg13cmos5l_decap_8
XFILLER_25_838 VPWR VGND sg13cmos5l_decap_8
XFILLER_36_186 VPWR VGND sg13cmos5l_decap_8
X_3906_ _3909_/C _3912_/A _3905_/X _4375_/Q VPWR VGND sg13cmos5l_o21ai_1
XFILLER_20_532 VPWR VGND sg13cmos5l_decap_8
X_4345__373 _4345_/RESET_B VPWR VGND sg13cmos5l_tiehi
X_3837_ _3837_/Y _3731_/S _3726_/Y _3836_/A _3836_/B _3727_/Y VPWR VGND sg13cmos5l_a221oi_1
X_3768_ _4344_/D _3772_/A _3768_/B VPWR VGND sg13cmos5l_nor2_1
XFILLER_3_208 VPWR VGND sg13cmos5l_fill_2
X_2719_ _4153_/D _2721_/A VPWR VGND sg13cmos5l_inv_1
X_3699_ _3730_/A _3705_/B _3699_/B VPWR VGND sg13cmos5l_nand2b_1
XFILLER_10_46 VPWR VGND sg13cmos5l_decap_8
XFILLER_48_908 VPWR VGND sg13cmos5l_decap_8
XFILLER_19_88 VPWR VGND sg13cmos5l_fill_2
XFILLER_27_120 VPWR VGND sg13cmos5l_decap_8
X_4094__290 _4094_/RESET_B VPWR VGND sg13cmos5l_tiehi
XFILLER_43_668 VPWR VGND sg13cmos5l_fill_1
XFILLER_43_657 VPWR VGND sg13cmos5l_decap_4
XFILLER_15_348 VPWR VGND sg13cmos5l_decap_8
XFILLER_31_808 VPWR VGND sg13cmos5l_fill_2
XFILLER_35_65 VPWR VGND sg13cmos5l_decap_8
XFILLER_11_532 VPWR VGND sg13cmos5l_decap_8
XFILLER_24_893 VPWR VGND sg13cmos5l_fill_2
XFILLER_7_503 VPWR VGND sg13cmos5l_fill_2
XFILLER_11_543 VPWR VGND sg13cmos5l_fill_2
XFILLER_7_536 VPWR VGND sg13cmos5l_decap_4
XFILLER_3_786 VPWR VGND sg13cmos5l_fill_1
XFILLER_3_775 VPWR VGND sg13cmos5l_decap_8
XFILLER_2_274 VPWR VGND sg13cmos5l_fill_2
XFILLER_2_285 VPWR VGND sg13cmos5l_decap_8
XFILLER_25_8 VPWR VGND sg13cmos5l_fill_1
XFILLER_19_610 VPWR VGND sg13cmos5l_decap_4
XFILLER_47_996 VPWR VGND sg13cmos5l_decap_8
XFILLER_18_164 VPWR VGND sg13cmos5l_decap_8
XFILLER_34_657 VPWR VGND sg13cmos5l_decap_4
XFILLER_34_668 VPWR VGND sg13cmos5l_decap_8
XFILLER_15_871 VPWR VGND sg13cmos5l_fill_2
XFILLER_34_679 VPWR VGND sg13cmos5l_fill_1
XFILLER_30_830 VPWR VGND sg13cmos5l_fill_2
XFILLER_30_874 VPWR VGND sg13cmos5l_fill_2
X_3622_ _3654_/B _3628_/A _3666_/C VPWR VGND sg13cmos5l_or2_1
X_3553_ _3554_/C _3552_/A _3552_/B _3618_/A VPWR VGND sg13cmos5l_o21ai_1
X_2504_ _2504_/Y _3751_/A _3684_/A _2503_/Y VPWR VGND sg13cmos5l_a21oi_1
X_3484_ _3501_/A _3482_/Y _3484_/B VPWR VGND sg13cmos5l_nand2b_1
X_2435_ _4105_/D _2435_/A0 hold818/X _2440_/S VPWR VGND sg13cmos5l_mux2_1
X_2366_ _4046_/D _2435_/A0 hold703/X _2370_/S VPWR VGND sg13cmos5l_mux2_1
X_4105_ _4105_/Q clkload2/A _4105_/D _4105_/RESET_B VPWR VGND sg13cmos5l_dfrbpq_1
X_2297_ _2297_/X _4008_/Q _3991_/Q _2647_/A VPWR VGND sg13cmos5l_mux2_1
X_4119__260 _4119_/RESET_B VPWR VGND sg13cmos5l_tiehi
X_4036_ _4036_/Q clkload3/A _4036_/D _4036_/RESET_B VPWR VGND sg13cmos5l_dfrbpq_1
XFILLER_25_602 VPWR VGND sg13cmos5l_decap_8
XFILLER_25_657 VPWR VGND sg13cmos5l_fill_2
XFILLER_40_627 VPWR VGND sg13cmos5l_decap_8
XFILLER_40_605 VPWR VGND sg13cmos5l_decap_8
XFILLER_36_1010 VPWR VGND sg13cmos5l_decap_8
XFILLER_24_178 VPWR VGND sg13cmos5l_decap_4
XFILLER_0_723 VPWR VGND sg13cmos5l_decap_4
XFILLER_43_1003 VPWR VGND sg13cmos5l_decap_8
XFILLER_29_930 VPWR VGND sg13cmos5l_decap_8
XFILLER_44_911 VPWR VGND sg13cmos5l_decap_8
XFILLER_29_996 VPWR VGND sg13cmos5l_decap_8
XFILLER_15_112 VPWR VGND sg13cmos5l_decap_8
XFILLER_44_988 VPWR VGND sg13cmos5l_decap_8
XFILLER_43_454 VPWR VGND sg13cmos5l_fill_1
XFILLER_15_167 VPWR VGND sg13cmos5l_fill_1
XFILLER_8_823 VPWR VGND sg13cmos5l_decap_4
XFILLER_7_36 VPWR VGND sg13cmos5l_fill_2
XFILLER_7_388 VPWR VGND sg13cmos5l_decap_8
X_2220_ _3602_/B _2220_/A VPWR VGND sg13cmos5l_inv_1
XFILLER_3_583 VPWR VGND sg13cmos5l_decap_8
X_4259__473 _4259_/RESET_B VPWR VGND sg13cmos5l_tiehi
XFILLER_38_204 VPWR VGND sg13cmos5l_decap_4
XFILLER_16_4 VPWR VGND sg13cmos5l_fill_2
XFILLER_47_793 VPWR VGND sg13cmos5l_decap_8
XFILLER_19_462 VPWR VGND sg13cmos5l_fill_1
XFILLER_19_473 VPWR VGND sg13cmos5l_decap_8
XFILLER_34_410 VPWR VGND sg13cmos5l_fill_2
XFILLER_19_495 VPWR VGND sg13cmos5l_decap_8
X_2984_ _2984_/Y _3189_/A _2974_/B _3175_/A _2977_/X VPWR VGND sg13cmos5l_a22oi_1
X_3605_ _3757_/A _4319_/Q _3605_/B VPWR VGND sg13cmos5l_nand2b_1
Xhold801 _2226_/A _4198_/Q VPWR VGND sg13cmos5l_dlygate4sd3_1
Xhold812 _2797_/A _4172_/Q VPWR VGND sg13cmos5l_dlygate4sd3_1
Xhold845 _2274_/A _4165_/Q VPWR VGND sg13cmos5l_dlygate4sd3_1
X_3536_ _3537_/B _3834_/A _3536_/B _3536_/C VPWR VGND sg13cmos5l_nand3_1
Xhold823 _3773_/B _4347_/Q VPWR VGND sg13cmos5l_dlygate4sd3_1
Xhold834 _4352_/D _3781_/Y VPWR VGND sg13cmos5l_dlygate4sd3_1
Xhold889 _4253_/D _3243_/Y VPWR VGND sg13cmos5l_dlygate4sd3_1
Xhold856 _4367_/D _3904_/Y VPWR VGND sg13cmos5l_dlygate4sd3_1
Xhold878 _3222_/A _4270_/Q VPWR VGND sg13cmos5l_dlygate4sd3_1
Xhold867 _4129_/D _2502_/Y VPWR VGND sg13cmos5l_dlygate4sd3_1
X_3467_ _3467_/X _3489_/A _3467_/B VPWR VGND sg13cmos5l_and2_1
X_3398_ _3398_/Y _4251_/Q _4300_/Q VPWR VGND sg13cmos5l_nand2b_1
X_2418_ _4091_/D _2438_/A0 hold715/X _2420_/S VPWR VGND sg13cmos5l_mux2_1
X_2349_ _4033_/D _3971_/A0 hold671/X _2349_/S VPWR VGND sg13cmos5l_mux2_1
XFILLER_29_226 VPWR VGND sg13cmos5l_decap_8
XFILLER_38_771 VPWR VGND sg13cmos5l_decap_8
X_4019_ _4019_/Q clkload3/A _4019_/D _4019_/RESET_B VPWR VGND sg13cmos5l_dfrbpq_1
XFILLER_37_281 VPWR VGND sg13cmos5l_fill_2
X_4091__293 _4091_/RESET_B VPWR VGND sg13cmos5l_tiehi
XFILLER_13_605 VPWR VGND sg13cmos5l_decap_4
XFILLER_16_78 VPWR VGND sg13cmos5l_fill_1
XFILLER_41_969 VPWR VGND sg13cmos5l_decap_8
XFILLER_48_502 VPWR VGND sg13cmos5l_decap_8
XFILLER_0_575 VPWR VGND sg13cmos5l_fill_1
XFILLER_44_785 VPWR VGND sg13cmos5l_decap_8
XFILLER_44_752 VPWR VGND sg13cmos5l_decap_8
XFILLER_17_977 VPWR VGND sg13cmos5l_decap_8
XFILLER_17_988 VPWR VGND sg13cmos5l_fill_1
XFILLER_32_925 VPWR VGND sg13cmos5l_decap_8
XFILLER_43_284 VPWR VGND sg13cmos5l_fill_2
XFILLER_43_273 VPWR VGND sg13cmos5l_decap_8
XFILLER_31_413 VPWR VGND sg13cmos5l_decap_4
XFILLER_31_435 VPWR VGND sg13cmos5l_fill_1
XFILLER_32_947 VPWR VGND sg13cmos5l_decap_8
XFILLER_40_980 VPWR VGND sg13cmos5l_decap_8
XFILLER_7_130 VPWR VGND sg13cmos5l_fill_1
X_4370_ _4370_/Q _4378_/CLK _4370_/D _4370_/RESET_B VPWR VGND sg13cmos5l_dfrbpq_1
X_3321_ _3321_/Y _3311_/B _3318_/A _3154_/Y VPWR VGND sg13cmos5l_o21ai_1
X_3252_ _4259_/D _2223_/Y _3613_/A2 _3251_/Y VPWR VGND sg13cmos5l_a21oi_1
X_3183_ _3183_/X _3189_/A _3189_/B VPWR VGND sg13cmos5l_or2_1
XFILLER_22_402 VPWR VGND sg13cmos5l_fill_2
XFILLER_23_969 VPWR VGND sg13cmos5l_decap_8
X_2967_ _2968_/B _4237_/Q _4238_/Q _4239_/Q VPWR VGND sg13cmos5l_o21ai_1
XFILLER_33_1013 VPWR VGND sg13cmos5l_decap_8
X_2898_ _2901_/S _4194_/Q _2898_/B VPWR VGND sg13cmos5l_nor2_1
Xhold620 _2905_/B _4169_/Q VPWR VGND sg13cmos5l_dlygate4sd3_1
Xhold631 _2212_/A _4322_/Q VPWR VGND sg13cmos5l_dlygate4sd3_1
Xhold642 _4227_/D _3070_/Y VPWR VGND sg13cmos5l_dlygate4sd3_1
Xhold653 hold653/X _4227_/Q VPWR VGND sg13cmos5l_dlygate4sd3_1
X_3519_ _3519_/X _3523_/B _3834_/A _3519_/C VPWR VGND sg13cmos5l_and3_1
Xhold664 hold664/X _4133_/Q VPWR VGND sg13cmos5l_dlygate4sd3_1
Xhold697 _4368_/D _3910_/Y VPWR VGND sg13cmos5l_dlygate4sd3_1
Xhold675 hold675/X _4092_/Q VPWR VGND sg13cmos5l_dlygate4sd3_1
Xhold686 hold686/X _4024_/Q VPWR VGND sg13cmos5l_dlygate4sd3_1
XFILLER_45_538 VPWR VGND sg13cmos5l_decap_8
XFILLER_14_903 VPWR VGND sg13cmos5l_fill_2
XFILLER_41_722 VPWR VGND sg13cmos5l_decap_4
X_4130__238 _4130_/RESET_B VPWR VGND sg13cmos5l_tiehi
XFILLER_41_788 VPWR VGND sg13cmos5l_decap_8
XFILLER_40_298 VPWR VGND sg13cmos5l_fill_2
Xclkbuf_leaf_20_clk _4333_/CLK clkbuf_leaf_3_clk/A VPWR VGND sg13cmos5l_buf_8
XFILLER_22_991 VPWR VGND sg13cmos5l_decap_8
XFILLER_4_199 VPWR VGND sg13cmos5l_decap_8
XFILLER_1_873 VPWR VGND sg13cmos5l_decap_8
XFILLER_49_855 VPWR VGND sg13cmos5l_decap_8
XFILLER_36_505 VPWR VGND sg13cmos5l_decap_4
XFILLER_17_752 VPWR VGND sg13cmos5l_decap_8
XFILLER_16_284 VPWR VGND sg13cmos5l_decap_8
XFILLER_32_733 VPWR VGND sg13cmos5l_decap_8
X_3870_ _4358_/D _3879_/A _3870_/B _3870_/C VPWR VGND sg13cmos5l_nor3_1
XFILLER_16_295 VPWR VGND sg13cmos5l_fill_2
XFILLER_31_243 VPWR VGND sg13cmos5l_decap_4
XFILLER_32_766 VPWR VGND sg13cmos5l_fill_1
X_2821_ _2821_/Y _2822_/A _2833_/A VPWR VGND sg13cmos5l_nand2_1
XFILLER_32_788 VPWR VGND sg13cmos5l_decap_8
XFILLER_32_799 VPWR VGND sg13cmos5l_fill_2
X_2752_ _2804_/C _2749_/B _2751_/A _2749_/Y VPWR VGND sg13cmos5l_a21oi_1
XFILLER_9_951 VPWR VGND sg13cmos5l_decap_8
Xclkbuf_leaf_11_clk _4225_/CLK clkload1/A VPWR VGND sg13cmos5l_buf_8
XFILLER_8_472 VPWR VGND sg13cmos5l_fill_2
XFILLER_8_450 VPWR VGND sg13cmos5l_decap_4
X_2683_ _2683_/Y _2687_/S _4010_/Q _2690_/A1 VPWR VGND sg13cmos5l_a21oi_1
X_4353_ _4353_/Q _4353_/CLK _4353_/D _4353_/RESET_B VPWR VGND sg13cmos5l_dfrbpq_1
X_4284_ _4284_/Q _4353_/CLK _4284_/D _4284_/RESET_B VPWR VGND sg13cmos5l_dfrbpq_1
X_3304_ _3304_/Y _3295_/Y _3298_/Y _3300_/X _3319_/A _3303_/Y VPWR VGND sg13cmos5l_a221oi_1
X_3235_ _3235_/Y _4255_/Q _3235_/B VPWR VGND sg13cmos5l_nor2_1
XFILLER_39_376 VPWR VGND sg13cmos5l_decap_8
X_3166_ _3167_/B _3148_/Y _3164_/X _3165_/Y VPWR VGND sg13cmos5l_a21o_1
X_3097_ _3097_/Y _2999_/S _3197_/A _3024_/A _3024_/B _2990_/Y VPWR VGND sg13cmos5l_a221oi_1
XFILLER_42_519 VPWR VGND sg13cmos5l_fill_2
XFILLER_23_711 VPWR VGND sg13cmos5l_decap_4
Xfanout47 _3772_/A _3685_/Y VPWR VGND sg13cmos5l_buf_1
Xfanout25 _3781_/A2 _3072_/A2 VPWR VGND sg13cmos5l_buf_1
Xfanout36 _3948_/S _3946_/B VPWR VGND sg13cmos5l_buf_1
X_3999_ _3999_/Q clkload9/A _3999_/D _3999_/RESET_B VPWR VGND sg13cmos5l_dfrbpq_1
Xfanout69 _2765_/B hold986/X VPWR VGND sg13cmos5l_buf_1
Xfanout58 _2659_/A _2261_/Y VPWR VGND sg13cmos5l_buf_1
XFILLER_22_298 VPWR VGND sg13cmos5l_fill_1
XFILLER_6_409 VPWR VGND sg13cmos5l_fill_2
XFILLER_2_648 VPWR VGND sg13cmos5l_fill_2
XFILLER_46_803 VPWR VGND sg13cmos5l_decap_8
XFILLER_38_65 VPWR VGND sg13cmos5l_fill_1
XFILLER_45_335 VPWR VGND sg13cmos5l_decap_4
XFILLER_18_549 VPWR VGND sg13cmos5l_fill_2
XFILLER_14_711 VPWR VGND sg13cmos5l_decap_8
XFILLER_14_722 VPWR VGND sg13cmos5l_decap_8
XFILLER_14_733 VPWR VGND sg13cmos5l_fill_1
XFILLER_13_254 VPWR VGND sg13cmos5l_decap_4
Xclkload17 clkload17/X _4377_/CLK VPWR VGND sg13cmos5l_buf_8
XFILLER_10_983 VPWR VGND sg13cmos5l_decap_8
XFILLER_6_965 VPWR VGND sg13cmos5l_decap_8
XFILLER_48_7 VPWR VGND sg13cmos5l_decap_8
XFILLER_1_681 VPWR VGND sg13cmos5l_fill_1
X_3020_ _3027_/D _3021_/A _3021_/B _3018_/Y VPWR VGND sg13cmos5l_o21ai_1
XFILLER_37_814 VPWR VGND sg13cmos5l_fill_2
Xclkbuf_leaf_0_clk _4136_/CLK clkbuf_leaf_4_clk/A VPWR VGND sg13cmos5l_buf_8
XFILLER_36_357 VPWR VGND sg13cmos5l_decap_8
X_3922_ _3979_/D _3956_/A hold676/X _3925_/S VPWR VGND sg13cmos5l_mux2_1
X_3853_ _3874_/B _3853_/A VPWR VGND sg13cmos5l_inv_1
XFILLER_32_563 VPWR VGND sg13cmos5l_fill_1
X_2804_ _2805_/B _2804_/A _2804_/B _2804_/C _2804_/D VPWR VGND sg13cmos5l_nand4_1
XFILLER_20_747 VPWR VGND sg13cmos5l_decap_8
X_3784_ _4355_/D _3784_/A _3786_/B VPWR VGND sg13cmos5l_nor2_1
X_2735_ _2735_/Y _2735_/A VPWR VGND sg13cmos5l_inv_1
XFILLER_8_291 VPWR VGND sg13cmos5l_fill_1
X_2666_ _2666_/Y _2665_/A _4056_/Q _2665_/Y VPWR VGND sg13cmos5l_a21oi_1
X_2597_ _2603_/A _2593_/Y _2594_/Y _2596_/Y _2708_/S1 _2707_/A VPWR VGND sg13cmos5l_a221oi_1
X_4336_ _4336_/Q clkload5/A _4336_/D _4336_/RESET_B VPWR VGND sg13cmos5l_dfrbpq_1
X_4267_ _4267_/Q _4272_/CLK _4267_/D _4267_/RESET_B VPWR VGND sg13cmos5l_dfrbpq_1
X_3218_ _3222_/C _4272_/Q _3064_/A _3221_/B VPWR VGND sg13cmos5l_o21ai_1
X_4198_ _4198_/Q _4234_/CLK _4198_/D _4198_/RESET_B VPWR VGND sg13cmos5l_dfrbpq_1
XFILLER_39_173 VPWR VGND sg13cmos5l_decap_4
X_3149_ _3149_/X _3149_/A _3169_/A VPWR VGND sg13cmos5l_or2_1
XFILLER_27_346 VPWR VGND sg13cmos5l_decap_4
XFILLER_23_563 VPWR VGND sg13cmos5l_fill_2
XFILLER_11_747 VPWR VGND sg13cmos5l_decap_8
XFILLER_6_217 VPWR VGND sg13cmos5l_decap_8
X_4129__240 _4129_/RESET_B VPWR VGND sg13cmos5l_tiehi
XFILLER_2_423 VPWR VGND sg13cmos5l_fill_1
XFILLER_3_957 VPWR VGND sg13cmos5l_decap_8
XFILLER_49_53 VPWR VGND sg13cmos5l_decap_8
XFILLER_2_478 VPWR VGND sg13cmos5l_decap_4
XFILLER_19_814 VPWR VGND sg13cmos5l_fill_2
XFILLER_46_644 VPWR VGND sg13cmos5l_decap_4
XFILLER_46_622 VPWR VGND sg13cmos5l_decap_8
XFILLER_1_49 VPWR VGND sg13cmos5l_decap_4
XFILLER_19_858 VPWR VGND sg13cmos5l_decap_8
XFILLER_41_382 VPWR VGND sg13cmos5l_decap_4
X_4143__215 _4143_/RESET_B VPWR VGND sg13cmos5l_tiehi
X_2520_ _2520_/Y _4374_/Q _4376_/Q VPWR VGND sg13cmos5l_nor2_1
X_2451_ _2451_/Y _2235_/Y _2449_/B _3775_/A VPWR VGND sg13cmos5l_o21ai_1
XFILLER_46_4 VPWR VGND sg13cmos5l_fill_2
X_2382_ _2390_/S _3937_/A _2391_/B VPWR VGND sg13cmos5l_nand2_1
X_4121_ _4121_/Q _4136_/CLK _4121_/D _4121_/RESET_B VPWR VGND sg13cmos5l_dfrbpq_1
X_4052_ _4052_/Q clkload7/A _4052_/D _4052_/RESET_B VPWR VGND sg13cmos5l_dfrbpq_1
X_3003_ _4213_/D _3079_/B _3112_/A VPWR VGND sg13cmos5l_nor2_1
XFILLER_37_633 VPWR VGND sg13cmos5l_fill_2
Xinput4 input4/X ui_in[2] VPWR VGND sg13cmos5l_buf_1
XFILLER_25_806 VPWR VGND sg13cmos5l_decap_8
XFILLER_24_316 VPWR VGND sg13cmos5l_decap_8
Xclkbuf_2_1__f_clk clkload0/A clkbuf_0_clk/X VPWR VGND sg13cmos5l_buf_8
XFILLER_36_154 VPWR VGND sg13cmos5l_fill_1
XFILLER_18_891 VPWR VGND sg13cmos5l_decap_8
X_3905_ _3905_/X _4368_/Q _4367_/Q VPWR VGND sg13cmos5l_and2_1
X_3836_ _3836_/Y _3836_/A _3836_/B VPWR VGND sg13cmos5l_nand2_1
X_3767_ _3767_/X _3749_/X _2218_/Y _3771_/S VPWR VGND sg13cmos5l_mux2_1
X_2718_ _2721_/A _2718_/A _2724_/B VPWR VGND sg13cmos5l_nand2_1
X_3698_ _3699_/B _4360_/Q _3748_/B _4361_/Q VPWR VGND sg13cmos5l_o21ai_1
XFILLER_10_25 VPWR VGND sg13cmos5l_decap_8
X_2649_ _2649_/Y _2654_/S _4035_/Q VPWR VGND sg13cmos5l_nand2b_1
X_4319_ _4319_/Q _4363_/CLK _4319_/D _4319_/RESET_B VPWR VGND sg13cmos5l_dfrbpq_1
XFILLER_0_949 VPWR VGND sg13cmos5l_decap_8
XFILLER_28_655 VPWR VGND sg13cmos5l_decap_4
XFILLER_43_625 VPWR VGND sg13cmos5l_decap_8
XFILLER_27_187 VPWR VGND sg13cmos5l_decap_8
XFILLER_42_179 VPWR VGND sg13cmos5l_fill_1
XFILLER_7_515 VPWR VGND sg13cmos5l_decap_8
XFILLER_11_566 VPWR VGND sg13cmos5l_fill_1
XFILLER_3_721 VPWR VGND sg13cmos5l_decap_8
XFILLER_3_743 VPWR VGND sg13cmos5l_decap_8
XFILLER_2_242 VPWR VGND sg13cmos5l_decap_8
X_4357__245 _4357_/RESET_B VPWR VGND sg13cmos5l_tiehi
XFILLER_47_975 VPWR VGND sg13cmos5l_decap_8
XFILLER_18_110 VPWR VGND sg13cmos5l_fill_1
XFILLER_20_1026 VPWR VGND sg13cmos5l_fill_2
XFILLER_15_850 VPWR VGND sg13cmos5l_decap_8
XFILLER_30_864 VPWR VGND sg13cmos5l_decap_4
X_3621_ _4331_/D _3621_/A _3681_/A VPWR VGND sg13cmos5l_nor2_1
X_3552_ _3554_/B _3552_/A _3552_/B VPWR VGND sg13cmos5l_nand2_1
XFILLER_6_581 VPWR VGND sg13cmos5l_fill_2
X_2503_ _2503_/Y _2515_/B1 _2456_/A _2509_/B1 VPWR VGND sg13cmos5l_o21ai_1
X_3483_ _3484_/B _3483_/A _3483_/B _3483_/C VPWR VGND sg13cmos5l_nand3_1
X_2434_ _4104_/D _2434_/A0 hold783/X _2440_/S VPWR VGND sg13cmos5l_mux2_1
X_2365_ _4045_/D _2434_/A0 hold702/X _2370_/S VPWR VGND sg13cmos5l_mux2_1
XFILLER_37_0 VPWR VGND sg13cmos5l_decap_8
X_4104_ _4104_/Q clkload2/A _4104_/D _4104_/RESET_B VPWR VGND sg13cmos5l_dfrbpq_1
X_2296_ _2296_/Y _2629_/A _4042_/Q _2295_/Y VPWR VGND sg13cmos5l_o21ai_1
XFILLER_37_441 VPWR VGND sg13cmos5l_decap_4
X_4035_ _4035_/Q clkload7/A _4035_/D _4035_/RESET_B VPWR VGND sg13cmos5l_dfrbpq_1
XFILLER_38_986 VPWR VGND sg13cmos5l_decap_8
XFILLER_37_485 VPWR VGND sg13cmos5l_decap_8
XFILLER_24_113 VPWR VGND sg13cmos5l_fill_1
XFILLER_24_168 VPWR VGND sg13cmos5l_decap_4
XFILLER_25_669 VPWR VGND sg13cmos5l_decap_4
XFILLER_12_319 VPWR VGND sg13cmos5l_decap_8
X_3819_ _3839_/B _3819_/A _3819_/B VPWR VGND sg13cmos5l_nor2_1
XFILLER_4_529 VPWR VGND sg13cmos5l_fill_1
XFILLER_0_746 VPWR VGND sg13cmos5l_decap_4
XFILLER_0_779 VPWR VGND sg13cmos5l_decap_4
XFILLER_29_975 VPWR VGND sg13cmos5l_decap_8
XFILLER_46_98 VPWR VGND sg13cmos5l_fill_2
XFILLER_44_967 VPWR VGND sg13cmos5l_decap_8
XFILLER_43_477 VPWR VGND sg13cmos5l_fill_1
XFILLER_8_802 VPWR VGND sg13cmos5l_decap_8
XFILLER_11_363 VPWR VGND sg13cmos5l_fill_1
XFILLER_12_897 VPWR VGND sg13cmos5l_decap_8
XFILLER_7_59 VPWR VGND sg13cmos5l_decap_4
X_4140__218 _4140_/RESET_B VPWR VGND sg13cmos5l_tiehi
XFILLER_3_540 VPWR VGND sg13cmos5l_decap_8
XFILLER_39_717 VPWR VGND sg13cmos5l_fill_1
XFILLER_39_739 VPWR VGND sg13cmos5l_decap_4
XFILLER_47_772 VPWR VGND sg13cmos5l_decap_8
XFILLER_46_282 VPWR VGND sg13cmos5l_decap_8
XFILLER_46_271 VPWR VGND sg13cmos5l_fill_2
XFILLER_22_628 VPWR VGND sg13cmos5l_fill_1
X_2983_ _2983_/Y _2983_/A _2983_/B _2983_/C VPWR VGND sg13cmos5l_nand3_1
XFILLER_14_190 VPWR VGND sg13cmos5l_decap_8
X_3604_ _3604_/Y _3583_/Y _3600_/S _3603_/Y VPWR VGND sg13cmos5l_a21oi_1
Xhold802 _4228_/D _3072_/Y VPWR VGND sg13cmos5l_dlygate4sd3_1
Xhold846 _4165_/D _2773_/Y VPWR VGND sg13cmos5l_dlygate4sd3_1
XFILLER_7_890 VPWR VGND sg13cmos5l_decap_8
Xhold824 hold824/X _3771_/S VPWR VGND sg13cmos5l_dlygate4sd3_1
X_3535_ _3535_/Y _3523_/B _3519_/C _3536_/C VPWR VGND sg13cmos5l_a21oi_1
Xhold813 hold813/X _4108_/Q VPWR VGND sg13cmos5l_dlygate4sd3_1
Xhold835 hold835/X _4291_/Q VPWR VGND sg13cmos5l_dlygate4sd3_1
Xhold868 _2248_/A _4302_/Q VPWR VGND sg13cmos5l_dlygate4sd3_1
Xhold857 _3244_/B _4254_/Q VPWR VGND sg13cmos5l_dlygate4sd3_1
X_3466_ _3467_/B _4298_/Q _3477_/B VPWR VGND sg13cmos5l_or2_1
Xhold879 hold879/X _4137_/Q VPWR VGND sg13cmos5l_dlygate4sd3_1
X_2417_ _4090_/D _2437_/A0 hold781/X _2420_/S VPWR VGND sg13cmos5l_mux2_1
X_3397_ _3397_/Y _4301_/Q _4252_/Q VPWR VGND sg13cmos5l_nor2b_1
X_2348_ _4032_/D _3946_/A hold728/X _2349_/S VPWR VGND sg13cmos5l_mux2_1
X_2279_ _3258_/A _3043_/C VPWR VGND sg13cmos5l_inv_1
X_4018_ _4018_/Q clkload4/A _4018_/D _4018_/RESET_B VPWR VGND sg13cmos5l_dfrbpq_1
XFILLER_37_271 VPWR VGND sg13cmos5l_fill_1
XFILLER_25_411 VPWR VGND sg13cmos5l_fill_2
XFILLER_41_948 VPWR VGND sg13cmos5l_decap_8
XFILLER_40_414 VPWR VGND sg13cmos5l_fill_1
XFILLER_13_628 VPWR VGND sg13cmos5l_decap_8
XFILLER_13_639 VPWR VGND sg13cmos5l_fill_2
XFILLER_40_458 VPWR VGND sg13cmos5l_fill_1
XFILLER_40_447 VPWR VGND sg13cmos5l_fill_2
XFILLER_5_805 VPWR VGND sg13cmos5l_decap_8
XFILLER_4_315 VPWR VGND sg13cmos5l_decap_8
XFILLER_10_1025 VPWR VGND sg13cmos5l_decap_4
XFILLER_0_510 VPWR VGND sg13cmos5l_decap_8
XFILLER_0_521 VPWR VGND sg13cmos5l_fill_2
XFILLER_0_554 VPWR VGND sg13cmos5l_decap_8
XFILLER_0_587 VPWR VGND sg13cmos5l_decap_8
XFILLER_29_783 VPWR VGND sg13cmos5l_fill_2
XFILLER_32_915 VPWR VGND sg13cmos5l_decap_4
XFILLER_43_296 VPWR VGND sg13cmos5l_decap_4
XFILLER_11_182 VPWR VGND sg13cmos5l_decap_8
XFILLER_11_193 VPWR VGND sg13cmos5l_fill_1
XFILLER_4_860 VPWR VGND sg13cmos5l_decap_8
X_3320_ _4270_/D _3320_/A _3320_/B _3320_/C VPWR VGND sg13cmos5l_nor3_1
XFILLER_4_893 VPWR VGND sg13cmos5l_decap_8
X_3251_ _3251_/Y _3087_/A _3251_/A2 _3255_/A VPWR VGND sg13cmos5l_o21ai_1
X_3182_ _3189_/B _4218_/Q _3182_/B VPWR VGND sg13cmos5l_xor2_1
XFILLER_39_569 VPWR VGND sg13cmos5l_fill_1
XFILLER_19_271 VPWR VGND sg13cmos5l_decap_8
XFILLER_19_282 VPWR VGND sg13cmos5l_fill_1
XFILLER_35_786 VPWR VGND sg13cmos5l_fill_2
X_2966_ _3193_/A _4240_/Q _2966_/B VPWR VGND sg13cmos5l_xnor2_1
XFILLER_31_992 VPWR VGND sg13cmos5l_decap_8
X_2897_ _2898_/B _2903_/B _2894_/Y _2896_/Y VPWR VGND sg13cmos5l_o21ai_1
X_4342__152 _4342_/D VPWR VGND sg13cmos5l_tielo
X_4377__204 _4377_/RESET_B VPWR VGND sg13cmos5l_tiehi
Xhold610 _3615_/B _4293_/Q VPWR VGND sg13cmos5l_dlygate4sd3_1
Xhold621 _3607_/B _4288_/Q VPWR VGND sg13cmos5l_dlygate4sd3_1
Xhold643 _2917_/A _4181_/Q VPWR VGND sg13cmos5l_dlygate4sd3_1
Xhold654 _2456_/A _4130_/Q VPWR VGND sg13cmos5l_dlygate4sd3_1
Xhold632 _4351_/D _3779_/Y VPWR VGND sg13cmos5l_dlygate4sd3_1
Xhold676 hold676/X _3979_/Q VPWR VGND sg13cmos5l_dlygate4sd3_1
Xhold665 _2467_/B _2466_/Y VPWR VGND sg13cmos5l_dlygate4sd3_1
X_3518_ _3518_/Y _3514_/Y _3516_/Y _3517_/Y _4333_/Q VPWR VGND sg13cmos5l_a22oi_1
Xhold687 _2544_/A _4140_/Q VPWR VGND sg13cmos5l_dlygate4sd3_1
X_3449_ _3449_/Y _3359_/B _3483_/A _3487_/B _3451_/A VPWR VGND sg13cmos5l_a22oi_1
Xhold698 hold698/X _4073_/Q VPWR VGND sg13cmos5l_dlygate4sd3_1
XFILLER_38_580 VPWR VGND sg13cmos5l_decap_8
XFILLER_14_915 VPWR VGND sg13cmos5l_decap_4
XFILLER_26_742 VPWR VGND sg13cmos5l_fill_2
XFILLER_26_764 VPWR VGND sg13cmos5l_decap_8
XFILLER_40_200 VPWR VGND sg13cmos5l_decap_8
XFILLER_13_425 VPWR VGND sg13cmos5l_decap_4
XFILLER_13_447 VPWR VGND sg13cmos5l_decap_8
XFILLER_14_959 VPWR VGND sg13cmos5l_decap_8
XFILLER_22_970 VPWR VGND sg13cmos5l_decap_8
XFILLER_4_112 VPWR VGND sg13cmos5l_fill_1
XFILLER_1_852 VPWR VGND sg13cmos5l_decap_8
XFILLER_49_834 VPWR VGND sg13cmos5l_decap_8
X_4319__154 _4319_/D VPWR VGND sg13cmos5l_tielo
X_4139__220 _4139_/RESET_B VPWR VGND sg13cmos5l_tiehi
XFILLER_0_395 VPWR VGND sg13cmos5l_decap_8
XFILLER_29_591 VPWR VGND sg13cmos5l_fill_2
XFILLER_17_764 VPWR VGND sg13cmos5l_fill_2
XFILLER_44_572 VPWR VGND sg13cmos5l_fill_2
XFILLER_16_263 VPWR VGND sg13cmos5l_decap_8
XFILLER_31_233 VPWR VGND sg13cmos5l_fill_1
XFILLER_32_745 VPWR VGND sg13cmos5l_fill_1
X_2820_ _2833_/A _4184_/Q _4183_/Q _4185_/Q VPWR VGND sg13cmos5l_or3_1
XFILLER_9_930 VPWR VGND sg13cmos5l_decap_8
XFILLER_13_981 VPWR VGND sg13cmos5l_decap_8
X_2751_ _2751_/Y _2751_/A VPWR VGND sg13cmos5l_inv_1
XFILLER_12_480 VPWR VGND sg13cmos5l_fill_2
X_2682_ _2682_/Y _2680_/A _4027_/Q VPWR VGND sg13cmos5l_nand2b_1
X_4352_ _4352_/Q _4377_/CLK _4352_/D _4352_/RESET_B VPWR VGND sg13cmos5l_dfrbpq_1
X_4283_ _4283_/Q _4353_/CLK _4283_/D _4283_/RESET_B VPWR VGND sg13cmos5l_dfrbpq_1
X_3303_ _3303_/Y _3295_/B _3295_/C _3295_/A VPWR VGND sg13cmos5l_a21oi_1
X_4077__307 _4077_/RESET_B VPWR VGND sg13cmos5l_tiehi
X_3234_ _3235_/B _3244_/B _3234_/B VPWR VGND sg13cmos5l_nor2_1
XFILLER_39_355 VPWR VGND sg13cmos5l_decap_8
X_3165_ _3165_/Y _3144_/B _3135_/B _3148_/Y _3164_/A _3169_/A VPWR VGND sg13cmos5l_a221oi_1
XFILLER_27_517 VPWR VGND sg13cmos5l_decap_8
X_3096_ _3096_/Y _3096_/A _3096_/B _3096_/C _3096_/D VPWR VGND sg13cmos5l_nand4_1
X_4170__586 _4170_/RESET_B VPWR VGND sg13cmos5l_tiehi
XFILLER_11_907 VPWR VGND sg13cmos5l_fill_1
Xfanout37 _2473_/A _2528_/B VPWR VGND sg13cmos5l_buf_1
XFILLER_23_756 VPWR VGND sg13cmos5l_decap_4
Xfanout26 _3072_/A2 _2575_/X VPWR VGND sg13cmos5l_buf_1
Xfanout59 _2709_/A _2261_/Y VPWR VGND sg13cmos5l_buf_1
Xfanout48 _3619_/B _3681_/A VPWR VGND sg13cmos5l_buf_1
XFILLER_10_417 VPWR VGND sg13cmos5l_fill_1
X_3998_ _3998_/Q _4181_/CLK _3998_/D _3998_/RESET_B VPWR VGND sg13cmos5l_dfrbpq_1
X_2949_ _2949_/Y _2949_/A _2949_/B VPWR VGND sg13cmos5l_nor2_1
XFILLER_1_137 VPWR VGND sg13cmos5l_decap_8
XFILLER_1_148 VPWR VGND sg13cmos5l_fill_1
XFILLER_18_517 VPWR VGND sg13cmos5l_fill_1
XFILLER_46_859 VPWR VGND sg13cmos5l_decap_8
XFILLER_14_756 VPWR VGND sg13cmos5l_decap_8
XFILLER_26_594 VPWR VGND sg13cmos5l_fill_1
XFILLER_41_575 VPWR VGND sg13cmos5l_fill_1
XFILLER_16_1020 VPWR VGND sg13cmos5l_decap_8
XFILLER_10_962 VPWR VGND sg13cmos5l_decap_8
XFILLER_6_944 VPWR VGND sg13cmos5l_decap_8
Xclkload18 clkload18/Y _4234_/CLK VPWR VGND sg13cmos5l_inv_1
XFILLER_5_454 VPWR VGND sg13cmos5l_decap_8
XFILLER_5_432 VPWR VGND sg13cmos5l_fill_2
XFILLER_49_664 VPWR VGND sg13cmos5l_fill_1
XFILLER_49_653 VPWR VGND sg13cmos5l_decap_8
XFILLER_37_826 VPWR VGND sg13cmos5l_fill_1
X_3921_ _3978_/D _3954_/A hold705/X _3925_/S VPWR VGND sg13cmos5l_mux2_1
X_3852_ _3853_/A _3852_/A _3852_/B _3852_/C VPWR VGND sg13cmos5l_nor3_1
X_2803_ _2803_/X _2804_/D _2803_/B VPWR VGND sg13cmos5l_or2_1
X_3783_ _3783_/X _3783_/A _3783_/B VPWR VGND sg13cmos5l_and2_1
XFILLER_30_1017 VPWR VGND sg13cmos5l_decap_8
X_2734_ _2735_/A _2744_/B _2733_/Y VPWR VGND sg13cmos5l_nor2b_1
XFILLER_8_270 VPWR VGND sg13cmos5l_decap_4
XFILLER_30_1028 VPWR VGND sg13cmos5l_fill_1
X_2665_ _2665_/Y _2665_/A _4073_/Q VPWR VGND sg13cmos5l_nor2b_1
X_2596_ _2596_/Y _2698_/A _4049_/Q _2595_/Y VPWR VGND sg13cmos5l_a21oi_1
X_4335_ _4335_/Q _4353_/CLK _4335_/D _4335_/RESET_B VPWR VGND sg13cmos5l_dfrbpq_1
XFILLER_8_1018 VPWR VGND sg13cmos5l_decap_8
X_4266_ _4266_/Q _4272_/CLK _4266_/D _4266_/RESET_B VPWR VGND sg13cmos5l_dfrbpq_1
X_3217_ _3217_/Y _4224_/Q _3217_/B VPWR VGND sg13cmos5l_nor2_1
X_4197_ _4197_/Q _4234_/CLK _4197_/D _4197_/RESET_B VPWR VGND sg13cmos5l_dfrbpq_1
X_3148_ _3148_/Y _3141_/Y _3146_/Y _3147_/Y VPWR VGND sg13cmos5l_o21ai_1
XFILLER_43_818 VPWR VGND sg13cmos5l_decap_8
X_3079_ _4235_/D _3079_/A _3079_/B VPWR VGND sg13cmos5l_nor2_1
XFILLER_36_870 VPWR VGND sg13cmos5l_fill_1
XFILLER_11_715 VPWR VGND sg13cmos5l_fill_2
X_4164__176 _4164_/D VPWR VGND sg13cmos5l_tielo
XFILLER_3_936 VPWR VGND sg13cmos5l_decap_8
XFILLER_46_1013 VPWR VGND sg13cmos5l_decap_8
XFILLER_49_32 VPWR VGND sg13cmos5l_decap_8
XFILLER_46_601 VPWR VGND sg13cmos5l_decap_8
XFILLER_1_28 VPWR VGND sg13cmos5l_decap_8
XFILLER_18_314 VPWR VGND sg13cmos5l_fill_2
XFILLER_18_325 VPWR VGND sg13cmos5l_decap_4
XFILLER_19_848 VPWR VGND sg13cmos5l_fill_1
XFILLER_45_144 VPWR VGND sg13cmos5l_fill_1
XFILLER_18_347 VPWR VGND sg13cmos5l_fill_2
XFILLER_18_358 VPWR VGND sg13cmos5l_fill_2
XFILLER_26_391 VPWR VGND sg13cmos5l_fill_1
XFILLER_27_892 VPWR VGND sg13cmos5l_decap_8
XFILLER_33_339 VPWR VGND sg13cmos5l_decap_8
X_4067__317 _4067_/RESET_B VPWR VGND sg13cmos5l_tiehi
XFILLER_14_586 VPWR VGND sg13cmos5l_decap_4
XFILLER_14_90 VPWR VGND sg13cmos5l_decap_8
XFILLER_10_770 VPWR VGND sg13cmos5l_decap_8
X_2450_ _4112_/D _3973_/A _3973_/B VPWR VGND sg13cmos5l_nor2_1
XFILLER_5_284 VPWR VGND sg13cmos5l_fill_1
XFILLER_39_4 VPWR VGND sg13cmos5l_decap_4
X_2381_ _2391_/B _4127_/Q _2371_/C VPWR VGND sg13cmos5l_nor2b_1
X_4120_ _4120_/Q _4136_/CLK _4120_/D _4120_/RESET_B VPWR VGND sg13cmos5l_dfrbpq_1
X_4338__382 _4338_/RESET_B VPWR VGND sg13cmos5l_tiehi
X_4051_ _4051_/Q clkload3/A _4051_/D _4051_/RESET_B VPWR VGND sg13cmos5l_dfrbpq_1
XFILLER_49_461 VPWR VGND sg13cmos5l_decap_8
X_3002_ _3002_/Y _2974_/B _2995_/C _2969_/Y VPWR VGND sg13cmos5l_o21ai_1
Xinput5 input5/X ui_in[3] VPWR VGND sg13cmos5l_buf_1
XFILLER_37_667 VPWR VGND sg13cmos5l_decap_8
XFILLER_36_166 VPWR VGND sg13cmos5l_decap_8
XFILLER_17_391 VPWR VGND sg13cmos5l_decap_4
X_3904_ _3904_/Y _2209_/Y _3899_/Y _3903_/Y _3909_/A _3916_/A VPWR VGND sg13cmos5l_a221oi_1
XFILLER_33_851 VPWR VGND sg13cmos5l_decap_8
XFILLER_33_873 VPWR VGND sg13cmos5l_decap_8
XFILLER_20_512 VPWR VGND sg13cmos5l_decap_8
X_3835_ _3835_/X _3836_/A _3836_/B VPWR VGND sg13cmos5l_and2_1
X_3766_ _4343_/D _3772_/A _3766_/B VPWR VGND sg13cmos5l_nor2_1
X_2717_ _4150_/D _2717_/A VPWR VGND sg13cmos5l_inv_1
X_3697_ _3705_/B _4361_/Q _4360_/Q _3748_/B VPWR VGND sg13cmos5l_nor3_1
X_2648_ _2648_/Y _2647_/A _3984_/Q _2647_/Y VPWR VGND sg13cmos5l_a21oi_1
XFILLER_0_928 VPWR VGND sg13cmos5l_decap_8
X_2579_ _2579_/Y _2680_/A _3975_/Q _2578_/Y VPWR VGND sg13cmos5l_a21oi_1
X_4318_ _4318_/Q clkload6/A _4318_/D _4318_/RESET_B VPWR VGND sg13cmos5l_dfrbpq_1
X_4249_ _4249_/Q _4302_/CLK _4249_/D _4249_/RESET_B VPWR VGND sg13cmos5l_dfrbpq_1
XFILLER_27_155 VPWR VGND sg13cmos5l_decap_8
XFILLER_42_136 VPWR VGND sg13cmos5l_fill_2
XFILLER_24_884 VPWR VGND sg13cmos5l_fill_2
XFILLER_13_1023 VPWR VGND sg13cmos5l_decap_4
XFILLER_3_700 VPWR VGND sg13cmos5l_fill_1
XFILLER_47_954 VPWR VGND sg13cmos5l_decap_8
XFILLER_20_1005 VPWR VGND sg13cmos5l_decap_8
XFILLER_33_103 VPWR VGND sg13cmos5l_fill_1
XFILLER_21_309 VPWR VGND sg13cmos5l_decap_8
X_3620_ _4330_/D _3620_/A _3620_/B VPWR VGND sg13cmos5l_and2_1
XFILLER_30_876 VPWR VGND sg13cmos5l_fill_1
X_3551_ _3552_/B _4300_/Q _4278_/Q VPWR VGND sg13cmos5l_or2_1
X_2502_ _2502_/Y _2502_/A _2502_/B VPWR VGND sg13cmos5l_nor2_1
X_3482_ _3482_/Y _3483_/B _3483_/C _3359_/B VPWR VGND sg13cmos5l_a21oi_1
X_2433_ _4103_/D _3965_/A0 hold770/X _2440_/S VPWR VGND sg13cmos5l_mux2_1
X_2364_ _4044_/D _3951_/A0 hold772/X _2370_/S VPWR VGND sg13cmos5l_mux2_1
X_4103_ _4103_/Q clkload7/A _4103_/D _4103_/RESET_B VPWR VGND sg13cmos5l_dfrbpq_1
X_2295_ _2295_/Y _2629_/A _2266_/Y _2658_/S1 VPWR VGND sg13cmos5l_a21oi_1
XFILLER_49_280 VPWR VGND sg13cmos5l_fill_1
XFILLER_38_965 VPWR VGND sg13cmos5l_decap_8
X_4034_ _4034_/Q clkload3/A _4034_/D _4034_/RESET_B VPWR VGND sg13cmos5l_dfrbpq_1
X_4017__536 _4017_/RESET_B VPWR VGND sg13cmos5l_tiehi
XFILLER_25_626 VPWR VGND sg13cmos5l_fill_2
XFILLER_21_843 VPWR VGND sg13cmos5l_decap_4
X_3818_ _3819_/B _4314_/Q _4313_/Q VPWR VGND sg13cmos5l_nand2b_1
XFILLER_20_364 VPWR VGND sg13cmos5l_fill_2
XFILLER_20_375 VPWR VGND sg13cmos5l_fill_2
XFILLER_21_25 VPWR VGND sg13cmos5l_decap_8
X_3749_ _3749_/X _3599_/Y _3748_/Y _3757_/B VPWR VGND sg13cmos5l_mux2_1
XFILLER_4_519 VPWR VGND sg13cmos5l_decap_4
XFILLER_21_58 VPWR VGND sg13cmos5l_decap_8
XFILLER_0_758 VPWR VGND sg13cmos5l_decap_8
XFILLER_47_206 VPWR VGND sg13cmos5l_fill_1
X_4057__327 _4057_/RESET_B VPWR VGND sg13cmos5l_tiehi
XFILLER_29_954 VPWR VGND sg13cmos5l_decap_8
XFILLER_16_615 VPWR VGND sg13cmos5l_decap_8
XFILLER_44_946 VPWR VGND sg13cmos5l_decap_8
XFILLER_16_659 VPWR VGND sg13cmos5l_decap_8
XFILLER_43_445 VPWR VGND sg13cmos5l_decap_8
XFILLER_15_158 VPWR VGND sg13cmos5l_decap_8
XFILLER_24_670 VPWR VGND sg13cmos5l_fill_2
XFILLER_30_106 VPWR VGND sg13cmos5l_decap_8
XFILLER_12_843 VPWR VGND sg13cmos5l_fill_2
XFILLER_7_324 VPWR VGND sg13cmos5l_decap_8
XFILLER_12_876 VPWR VGND sg13cmos5l_decap_8
XFILLER_7_49 VPWR VGND sg13cmos5l_fill_1
XFILLER_7_38 VPWR VGND sg13cmos5l_fill_1
XFILLER_11_386 VPWR VGND sg13cmos5l_fill_2
X_4328__392 _4328_/RESET_B VPWR VGND sg13cmos5l_tiehi
X_4335__385 _4335_/RESET_B VPWR VGND sg13cmos5l_tiehi
XFILLER_19_442 VPWR VGND sg13cmos5l_decap_8
XFILLER_21_106 VPWR VGND sg13cmos5l_decap_4
X_2982_ _2983_/C _4237_/Q _2980_/B _2995_/A VPWR VGND sg13cmos5l_o21ai_1
XFILLER_30_640 VPWR VGND sg13cmos5l_decap_8
X_4307__421 _4307_/RESET_B VPWR VGND sg13cmos5l_tiehi
XFILLER_30_673 VPWR VGND sg13cmos5l_decap_4
X_3603_ _3603_/Y _3600_/S _3602_/Y _3620_/B VPWR VGND sg13cmos5l_o21ai_1
Xhold803 hold803/X _3982_/Q VPWR VGND sg13cmos5l_dlygate4sd3_1
X_4342__378 _4342_/RESET_B VPWR VGND sg13cmos5l_tiehi
X_3534_ _4306_/D _3619_/B _3626_/A VPWR VGND sg13cmos5l_nor2_1
Xhold814 _3426_/A _4285_/Q VPWR VGND sg13cmos5l_dlygate4sd3_1
Xhold825 _3901_/B _4370_/Q VPWR VGND sg13cmos5l_dlygate4sd3_1
Xhold836 _3087_/A _4228_/Q VPWR VGND sg13cmos5l_dlygate4sd3_1
Xhold869 _2855_/A _4208_/Q VPWR VGND sg13cmos5l_dlygate4sd3_1
Xhold847 _3617_/A _4300_/Q VPWR VGND sg13cmos5l_dlygate4sd3_1
Xhold858 hold858/X _3244_/Y VPWR VGND sg13cmos5l_dlygate4sd3_1
X_3465_ _3489_/A _4297_/Q _3477_/B _3481_/A VPWR VGND sg13cmos5l_a21o_1
X_2416_ _4089_/D _2436_/A0 hold757/X _2420_/S VPWR VGND sg13cmos5l_mux2_1
X_3396_ _3396_/Y _4252_/Q _4301_/Q VPWR VGND sg13cmos5l_nand2b_1
X_2347_ _4031_/D _3958_/A hold755/X _2349_/S VPWR VGND sg13cmos5l_mux2_1
X_4314__414 _4314_/RESET_B VPWR VGND sg13cmos5l_tiehi
X_2278_ _3588_/B _2278_/A VPWR VGND sg13cmos5l_inv_1
XFILLER_37_250 VPWR VGND sg13cmos5l_fill_2
X_4017_ _4017_/Q clkload3/A _4017_/D _4017_/RESET_B VPWR VGND sg13cmos5l_dfrbpq_1
XFILLER_26_946 VPWR VGND sg13cmos5l_decap_8
XFILLER_26_957 VPWR VGND sg13cmos5l_fill_1
XFILLER_41_927 VPWR VGND sg13cmos5l_decap_8
XFILLER_12_106 VPWR VGND sg13cmos5l_decap_8
XFILLER_12_117 VPWR VGND sg13cmos5l_fill_2
XFILLER_20_183 VPWR VGND sg13cmos5l_decap_4
XFILLER_5_817 VPWR VGND sg13cmos5l_decap_8
XFILLER_10_1004 VPWR VGND sg13cmos5l_decap_8
XFILLER_28_250 VPWR VGND sg13cmos5l_fill_2
XFILLER_44_721 VPWR VGND sg13cmos5l_decap_8
XFILLER_28_261 VPWR VGND sg13cmos5l_decap_8
XFILLER_25_990 VPWR VGND sg13cmos5l_decap_8
XFILLER_31_404 VPWR VGND sg13cmos5l_decap_4
XFILLER_12_673 VPWR VGND sg13cmos5l_decap_8
XFILLER_8_677 VPWR VGND sg13cmos5l_decap_8
XFILLER_8_699 VPWR VGND sg13cmos5l_decap_8
XFILLER_3_360 VPWR VGND sg13cmos5l_decap_8
XFILLER_3_382 VPWR VGND sg13cmos5l_decap_8
X_3250_ _4258_/D _2224_/Y _3251_/A2 _3249_/Y VPWR VGND sg13cmos5l_a21oi_1
XFILLER_26_1011 VPWR VGND sg13cmos5l_decap_8
XFILLER_39_504 VPWR VGND sg13cmos5l_decap_8
XFILLER_21_4 VPWR VGND sg13cmos5l_decap_8
X_3181_ _3188_/B _4217_/Q _4218_/Q _4215_/Q _4216_/Q VPWR VGND sg13cmos5l_nor4_1
XFILLER_19_250 VPWR VGND sg13cmos5l_decap_8
X_4190__172 _4190_/D VPWR VGND sg13cmos5l_tielo
XFILLER_22_426 VPWR VGND sg13cmos5l_decap_8
XFILLER_35_798 VPWR VGND sg13cmos5l_decap_8
XFILLER_34_286 VPWR VGND sg13cmos5l_decap_4
XFILLER_31_971 VPWR VGND sg13cmos5l_decap_8
X_2965_ _2966_/B _4237_/Q _4238_/Q _4239_/Q VPWR VGND sg13cmos5l_nor3_1
X_2896_ _2896_/Y _2892_/Y _2893_/Y _2895_/Y VPWR VGND sg13cmos5l_o21ai_1
X_4047__337 _4047_/RESET_B VPWR VGND sg13cmos5l_tiehi
XFILLER_8_92 VPWR VGND sg13cmos5l_fill_1
XFILLER_8_81 VPWR VGND sg13cmos5l_decap_8
Xhold600 _2789_/A _4156_/Q VPWR VGND sg13cmos5l_dlygate4sd3_1
Xhold611 _3616_/B _4294_/Q VPWR VGND sg13cmos5l_dlygate4sd3_1
Xhold633 hold633/X _4134_/Q VPWR VGND sg13cmos5l_dlygate4sd3_1
X_3517_ _3517_/Y _4306_/Q _4305_/Q _4332_/Q VPWR VGND sg13cmos5l_nand3b_1
Xhold644 _3246_/B _4225_/Q VPWR VGND sg13cmos5l_dlygate4sd3_1
Xhold622 _2724_/A _4150_/Q VPWR VGND sg13cmos5l_dlygate4sd3_1
Xhold677 hold677/X _4084_/Q VPWR VGND sg13cmos5l_dlygate4sd3_1
Xhold655 _4114_/D _2458_/Y VPWR VGND sg13cmos5l_dlygate4sd3_1
Xhold688 _4137_/D _2543_/Y VPWR VGND sg13cmos5l_dlygate4sd3_1
Xhold666 hold666/X _4001_/Q VPWR VGND sg13cmos5l_dlygate4sd3_1
X_3448_ _3448_/Y _3359_/B _3483_/A _3447_/X VPWR VGND sg13cmos5l_o21ai_1
Xhold699 hold699/X _4059_/Q VPWR VGND sg13cmos5l_dlygate4sd3_1
X_3379_ _3379_/Y _3380_/A _3380_/B _3378_/X VPWR VGND sg13cmos5l_o21ai_1
XFILLER_40_1008 VPWR VGND sg13cmos5l_decap_8
XFILLER_17_209 VPWR VGND sg13cmos5l_fill_2
XFILLER_27_68 VPWR VGND sg13cmos5l_decap_8
XFILLER_14_905 VPWR VGND sg13cmos5l_fill_1
XFILLER_25_231 VPWR VGND sg13cmos5l_decap_8
XFILLER_13_404 VPWR VGND sg13cmos5l_decap_8
XFILLER_25_275 VPWR VGND sg13cmos5l_decap_4
XFILLER_41_735 VPWR VGND sg13cmos5l_decap_8
XFILLER_40_234 VPWR VGND sg13cmos5l_decap_4
XFILLER_22_960 VPWR VGND sg13cmos5l_fill_1
X_4249__485 _4249_/RESET_B VPWR VGND sg13cmos5l_tiehi
X_4167__185 _4167_/RESET_B VPWR VGND sg13cmos5l_tiehi
XFILLER_5_647 VPWR VGND sg13cmos5l_decap_8
X_4325__395 _4325_/RESET_B VPWR VGND sg13cmos5l_tiehi
XFILLER_5_669 VPWR VGND sg13cmos5l_decap_8
XFILLER_1_831 VPWR VGND sg13cmos5l_decap_8
XFILLER_49_813 VPWR VGND sg13cmos5l_decap_8
XFILLER_0_363 VPWR VGND sg13cmos5l_decap_8
XFILLER_0_374 VPWR VGND sg13cmos5l_fill_1
X_4256__478 _4256_/RESET_B VPWR VGND sg13cmos5l_tiehi
XFILLER_1_1013 VPWR VGND sg13cmos5l_decap_8
XFILLER_17_721 VPWR VGND sg13cmos5l_decap_8
X_4332__388 _4332_/RESET_B VPWR VGND sg13cmos5l_tiehi
XFILLER_16_253 VPWR VGND sg13cmos5l_fill_1
XFILLER_17_776 VPWR VGND sg13cmos5l_fill_2
XFILLER_17_787 VPWR VGND sg13cmos5l_decap_4
XFILLER_44_595 VPWR VGND sg13cmos5l_decap_8
XFILLER_13_960 VPWR VGND sg13cmos5l_decap_8
X_2750_ _2751_/A _2916_/A _2869_/A VPWR VGND sg13cmos5l_and2_1
X_2681_ _2681_/Y _2680_/A _3976_/Q _2680_/Y VPWR VGND sg13cmos5l_a21oi_1
XFILLER_9_986 VPWR VGND sg13cmos5l_decap_8
X_4304__424 _4304_/RESET_B VPWR VGND sg13cmos5l_tiehi
X_4351_ _4351_/Q _4353_/CLK _4351_/D _4351_/RESET_B VPWR VGND sg13cmos5l_dfrbpq_1
X_4282_ _4282_/Q _4333_/CLK _4282_/D _4282_/RESET_B VPWR VGND sg13cmos5l_dfrbpq_1
X_3302_ _3319_/A _3208_/B _3270_/Y _3301_/Y VPWR VGND sg13cmos5l_a21oi_1
X_3233_ _3233_/Y _2282_/Y _3241_/A _3232_/Y VPWR VGND sg13cmos5l_o21ai_1
X_3164_ _3164_/X _3164_/A _3371_/A VPWR VGND sg13cmos5l_and2_1
X_3095_ _3095_/Y _3115_/A _3095_/B VPWR VGND sg13cmos5l_nand2_1
X_4311__417 _4311_/RESET_B VPWR VGND sg13cmos5l_tiehi
XFILLER_22_201 VPWR VGND sg13cmos5l_fill_2
XFILLER_35_551 VPWR VGND sg13cmos5l_decap_8
Xfanout38 _3802_/B _3790_/Y VPWR VGND sg13cmos5l_buf_1
Xfanout27 _3935_/S _3934_/S VPWR VGND sg13cmos5l_buf_1
X_3997_ _3997_/Q _4161_/CLK _3997_/D _3997_/RESET_B VPWR VGND sg13cmos5l_dfrbpq_1
Xfanout49 _3681_/A _3506_/Y VPWR VGND sg13cmos5l_buf_1
XFILLER_22_289 VPWR VGND sg13cmos5l_decap_8
X_2948_ _2949_/B _2948_/A _2948_/B VPWR VGND sg13cmos5l_xnor2_1
X_2879_ _2941_/B _2879_/A _2879_/B VPWR VGND sg13cmos5l_nor2_1
XFILLER_1_116 VPWR VGND sg13cmos5l_decap_8
XFILLER_38_45 VPWR VGND sg13cmos5l_decap_8
XFILLER_46_838 VPWR VGND sg13cmos5l_decap_8
XFILLER_18_529 VPWR VGND sg13cmos5l_decap_4
XFILLER_13_234 VPWR VGND sg13cmos5l_decap_4
XFILLER_14_746 VPWR VGND sg13cmos5l_fill_1
XFILLER_26_584 VPWR VGND sg13cmos5l_decap_8
XFILLER_10_941 VPWR VGND sg13cmos5l_decap_8
Xclkload19 clkload19/Y _4209_/CLK VPWR VGND sg13cmos5l_inv_1
XFILLER_6_923 VPWR VGND sg13cmos5l_decap_8
XFILLER_5_422 VPWR VGND sg13cmos5l_fill_2
XFILLER_49_632 VPWR VGND sg13cmos5l_decap_8
XFILLER_0_171 VPWR VGND sg13cmos5l_decap_8
XFILLER_1_672 VPWR VGND sg13cmos5l_decap_8
XFILLER_49_676 VPWR VGND sg13cmos5l_decap_8
XFILLER_48_131 VPWR VGND sg13cmos5l_decap_4
XFILLER_0_193 VPWR VGND sg13cmos5l_decap_8
XFILLER_23_1025 VPWR VGND sg13cmos5l_decap_4
XFILLER_49_698 VPWR VGND sg13cmos5l_fill_1
XFILLER_48_186 VPWR VGND sg13cmos5l_decap_8
X_4037__347 _4037_/RESET_B VPWR VGND sg13cmos5l_tiehi
XFILLER_36_315 VPWR VGND sg13cmos5l_decap_8
XFILLER_45_882 VPWR VGND sg13cmos5l_decap_8
X_3920_ _3977_/D _3952_/A hold729/X _3925_/S VPWR VGND sg13cmos5l_mux2_1
XFILLER_44_381 VPWR VGND sg13cmos5l_decap_8
X_3851_ _3852_/C _3851_/A _3851_/B _3851_/C VPWR VGND sg13cmos5l_and3_1
X_3782_ _4353_/D _3782_/A _3786_/B VPWR VGND sg13cmos5l_nor2_1
X_2802_ _2803_/B _2802_/A _2802_/B VPWR VGND sg13cmos5l_nor2_1
X_2733_ _2733_/Y _4157_/Q _4158_/Q _4159_/Q VPWR VGND sg13cmos5l_o21ai_1
X_4083__301 _4083_/RESET_B VPWR VGND sg13cmos5l_tiehi
X_2664_ _2664_/Y _2664_/A1 _4090_/Q _2667_/B2 VPWR VGND sg13cmos5l_a21oi_1
X_2595_ _2595_/Y _2698_/A _4066_/Q VPWR VGND sg13cmos5l_nor2b_1
X_4334_ _4334_/Q _4353_/CLK _4334_/D _4334_/RESET_B VPWR VGND sg13cmos5l_dfrbpq_1
X_4265_ _4265_/Q _4272_/CLK _4265_/D _4265_/RESET_B VPWR VGND sg13cmos5l_dfrbpq_1
X_3216_ _3221_/B _3212_/Y _3214_/Y _3215_/Y VPWR VGND sg13cmos5l_o21ai_1
X_4196_ _4196_/Q _4225_/CLK _4196_/D _4196_/RESET_B VPWR VGND sg13cmos5l_dfrbpq_1
X_4239__495 _4239_/RESET_B VPWR VGND sg13cmos5l_tiehi
X_4157__195 _4157_/RESET_B VPWR VGND sg13cmos5l_tiehi
X_3147_ _3147_/Y _3169_/A _3168_/A _3380_/A _3169_/B VPWR VGND sg13cmos5l_a22oi_1
XFILLER_28_838 VPWR VGND sg13cmos5l_decap_4
XFILLER_27_337 VPWR VGND sg13cmos5l_decap_4
XFILLER_42_307 VPWR VGND sg13cmos5l_fill_2
X_3078_ _4234_/D _3078_/A _3079_/B VPWR VGND sg13cmos5l_nor2_1
XFILLER_35_392 VPWR VGND sg13cmos5l_decap_8
XFILLER_10_237 VPWR VGND sg13cmos5l_decap_8
XFILLER_10_248 VPWR VGND sg13cmos5l_fill_1
X_4246__488 _4246_/RESET_B VPWR VGND sg13cmos5l_tiehi
X_4164__188 _4164_/RESET_B VPWR VGND sg13cmos5l_tiehi
XFILLER_3_915 VPWR VGND sg13cmos5l_decap_8
XFILLER_49_11 VPWR VGND sg13cmos5l_decap_8
XFILLER_2_447 VPWR VGND sg13cmos5l_decap_8
XFILLER_49_88 VPWR VGND sg13cmos5l_decap_8
XFILLER_46_668 VPWR VGND sg13cmos5l_decap_8
XFILLER_45_134 VPWR VGND sg13cmos5l_fill_1
XFILLER_42_863 VPWR VGND sg13cmos5l_decap_8
XFILLER_14_554 VPWR VGND sg13cmos5l_decap_4
XFILLER_10_760 VPWR VGND sg13cmos5l_fill_1
X_4301__427 _4301_/RESET_B VPWR VGND sg13cmos5l_tiehi
XFILLER_46_6 VPWR VGND sg13cmos5l_fill_1
X_2380_ _4059_/D input5/X hold699/X _2380_/S VPWR VGND sg13cmos5l_mux2_1
XFILLER_2_981 VPWR VGND sg13cmos5l_decap_8
XFILLER_49_440 VPWR VGND sg13cmos5l_decap_8
X_4050_ _4050_/Q clkload8/A _4050_/D _4050_/RESET_B VPWR VGND sg13cmos5l_dfrbpq_1
XFILLER_49_484 VPWR VGND sg13cmos5l_decap_8
Xinput6 input6/X uio_in[0] VPWR VGND sg13cmos5l_buf_1
X_3001_ _3112_/A _2998_/A _3189_/A _2973_/Y _2988_/B VPWR VGND sg13cmos5l_a22oi_1
XFILLER_36_101 VPWR VGND sg13cmos5l_decap_8
XFILLER_37_646 VPWR VGND sg13cmos5l_decap_8
XFILLER_36_145 VPWR VGND sg13cmos5l_decap_8
X_3903_ _3903_/Y _4372_/Q _3903_/B _3903_/C VPWR VGND sg13cmos5l_nor3_1
X_3834_ _3836_/B _3834_/A _3834_/B VPWR VGND sg13cmos5l_or2_1
XFILLER_32_373 VPWR VGND sg13cmos5l_decap_8
XFILLER_20_546 VPWR VGND sg13cmos5l_decap_4
X_3765_ _3766_/B hold917/X _3751_/A _3771_/S VPWR VGND sg13cmos5l_mux2_1
X_3696_ _3696_/Y _3726_/A _3689_/X _3692_/Y _3695_/A _3693_/Y VPWR VGND sg13cmos5l_a221oi_1
X_2716_ _2717_/A _2724_/A _2784_/A2 _2718_/A VPWR VGND sg13cmos5l_o21ai_1
X_2647_ _2647_/Y _2647_/A _4001_/Q VPWR VGND sg13cmos5l_nor2b_1
XFILLER_0_907 VPWR VGND sg13cmos5l_decap_8
X_2578_ _2578_/Y _2680_/A _3992_/Q VPWR VGND sg13cmos5l_nor2b_1
X_4317_ _4317_/Q clkload5/A _4317_/D _4317_/RESET_B VPWR VGND sg13cmos5l_dfrbpq_1
X_4248_ _4248_/Q _4302_/CLK _4248_/D _4248_/RESET_B VPWR VGND sg13cmos5l_dfrbpq_1
XFILLER_27_134 VPWR VGND sg13cmos5l_decap_8
X_4179_ _4179_/Q _4225_/CLK _4179_/D _4179_/RESET_B VPWR VGND sg13cmos5l_dfrbpq_1
XFILLER_43_605 VPWR VGND sg13cmos5l_decap_8
XFILLER_16_819 VPWR VGND sg13cmos5l_decap_8
XFILLER_24_863 VPWR VGND sg13cmos5l_fill_1
XFILLER_24_874 VPWR VGND sg13cmos5l_decap_4
XFILLER_23_384 VPWR VGND sg13cmos5l_decap_4
XFILLER_11_579 VPWR VGND sg13cmos5l_decap_4
XFILLER_13_1002 VPWR VGND sg13cmos5l_decap_8
X_4027__357 _4027_/RESET_B VPWR VGND sg13cmos5l_tiehi
XFILLER_47_933 VPWR VGND sg13cmos5l_decap_8
XFILLER_20_1028 VPWR VGND sg13cmos5l_fill_1
X_4073__311 _4073_/RESET_B VPWR VGND sg13cmos5l_tiehi
XFILLER_46_476 VPWR VGND sg13cmos5l_decap_4
XFILLER_18_178 VPWR VGND sg13cmos5l_fill_2
XFILLER_33_159 VPWR VGND sg13cmos5l_decap_8
XFILLER_42_682 VPWR VGND sg13cmos5l_fill_2
XFILLER_15_885 VPWR VGND sg13cmos5l_decap_8
XFILLER_42_693 VPWR VGND sg13cmos5l_fill_2
X_4080__304 _4080_/RESET_B VPWR VGND sg13cmos5l_tiehi
X_3550_ _3552_/A _4279_/Q _4278_/Q VPWR VGND sg13cmos5l_xor2_1
XFILLER_6_550 VPWR VGND sg13cmos5l_fill_2
X_2501_ _2502_/B _2501_/A _3926_/B VPWR VGND sg13cmos5l_nand2_1
X_3481_ _3481_/X _3481_/A _3490_/A _3481_/C VPWR VGND sg13cmos5l_or3_1
X_2432_ _4102_/D _3950_/A0 hold743/X _2440_/S VPWR VGND sg13cmos5l_mux2_1
X_2363_ _4043_/D _3964_/A0 hold740/X _2370_/S VPWR VGND sg13cmos5l_mux2_1
X_4102_ _4102_/Q clkload2/A _4102_/D _4102_/RESET_B VPWR VGND sg13cmos5l_dfrbpq_1
X_4033_ _4033_/Q clkload9/A _4033_/D _4033_/RESET_B VPWR VGND sg13cmos5l_dfrbpq_1
XFILLER_38_922 VPWR VGND sg13cmos5l_fill_2
XFILLER_38_911 VPWR VGND sg13cmos5l_decap_8
X_2294_ _2528_/B _4123_/Q _2294_/B VPWR VGND sg13cmos5l_nor2_1
XFILLER_37_454 VPWR VGND sg13cmos5l_fill_2
XFILLER_25_616 VPWR VGND sg13cmos5l_fill_1
X_4236__498 _4236_/RESET_B VPWR VGND sg13cmos5l_tiehi
X_4154__198 _4154_/RESET_B VPWR VGND sg13cmos5l_tiehi
XFILLER_24_137 VPWR VGND sg13cmos5l_fill_2
XFILLER_36_1024 VPWR VGND sg13cmos5l_decap_4
XFILLER_33_660 VPWR VGND sg13cmos5l_fill_2
XFILLER_32_181 VPWR VGND sg13cmos5l_fill_2
XFILLER_32_192 VPWR VGND sg13cmos5l_fill_1
X_3817_ _3819_/A _4312_/Q _4310_/Q _4311_/Q VPWR VGND sg13cmos5l_nor3_1
XFILLER_21_899 VPWR VGND sg13cmos5l_fill_2
X_3748_ _3748_/Y _4363_/Q _3748_/B VPWR VGND sg13cmos5l_nand2b_1
XFILLER_21_48 VPWR VGND sg13cmos5l_fill_1
X_3679_ _3681_/B _3679_/A _3680_/A VPWR VGND sg13cmos5l_nor2b_1
XFILLER_43_1028 VPWR VGND sg13cmos5l_fill_1
XFILLER_43_1017 VPWR VGND sg13cmos5l_decap_8
XFILLER_44_925 VPWR VGND sg13cmos5l_decap_8
XFILLER_43_413 VPWR VGND sg13cmos5l_decap_8
XFILLER_43_468 VPWR VGND sg13cmos5l_decap_8
XFILLER_31_619 VPWR VGND sg13cmos5l_decap_8
XFILLER_12_855 VPWR VGND sg13cmos5l_decap_8
XFILLER_30_129 VPWR VGND sg13cmos5l_decap_8
XFILLER_8_848 VPWR VGND sg13cmos5l_fill_2
XFILLER_47_741 VPWR VGND sg13cmos5l_decap_4
XFILLER_35_903 VPWR VGND sg13cmos5l_decap_8
XFILLER_46_273 VPWR VGND sg13cmos5l_fill_1
XFILLER_34_468 VPWR VGND sg13cmos5l_decap_8
X_2981_ _2995_/A _4210_/Q _4211_/Q VPWR VGND sg13cmos5l_xnor2_1
XFILLER_15_693 VPWR VGND sg13cmos5l_decap_4
X_3602_ _3602_/Y _3745_/A _3602_/B VPWR VGND sg13cmos5l_nor2_1
XFILLER_30_685 VPWR VGND sg13cmos5l_decap_8
Xhold804 hold804/X _4030_/Q VPWR VGND sg13cmos5l_dlygate4sd3_1
X_3533_ _3626_/A _3515_/X _3532_/Y _3536_/C VPWR VGND sg13cmos5l_mux2_1
Xhold815 _4285_/D _3428_/Y VPWR VGND sg13cmos5l_dlygate4sd3_1
Xhold826 _2535_/B _2576_/A VPWR VGND sg13cmos5l_dlygate4sd3_1
Xhold837 _2915_/A _4179_/Q VPWR VGND sg13cmos5l_dlygate4sd3_1
Xhold848 _2222_/A _4315_/Q VPWR VGND sg13cmos5l_dlygate4sd3_1
Xhold859 _4254_/D _3245_/Y VPWR VGND sg13cmos5l_dlygate4sd3_1
X_3464_ _3481_/A _3480_/A _3480_/B _3480_/C VPWR VGND sg13cmos5l_a21oi_1
X_2415_ _4088_/D _2435_/A0 hold747/X _2420_/S VPWR VGND sg13cmos5l_mux2_1
X_3395_ _4281_/D _3444_/B _3487_/B VPWR VGND sg13cmos5l_and2_1
X_2346_ _4030_/D _3956_/A hold804/X _2349_/S VPWR VGND sg13cmos5l_mux2_1
X_2277_ _2277_/Y _4284_/Q VPWR VGND sg13cmos5l_inv_1
X_4016_ _4016_/Q _4161_/CLK _4016_/D _4016_/RESET_B VPWR VGND sg13cmos5l_dfrbpq_1
XFILLER_26_914 VPWR VGND sg13cmos5l_decap_8
XFILLER_38_785 VPWR VGND sg13cmos5l_decap_8
XFILLER_37_262 VPWR VGND sg13cmos5l_decap_8
XFILLER_25_413 VPWR VGND sg13cmos5l_fill_1
XFILLER_16_37 VPWR VGND sg13cmos5l_decap_4
XFILLER_26_969 VPWR VGND sg13cmos5l_decap_8
XFILLER_40_449 VPWR VGND sg13cmos5l_fill_1
X_4063__321 _4063_/RESET_B VPWR VGND sg13cmos5l_tiehi
XFILLER_0_534 VPWR VGND sg13cmos5l_decap_8
XFILLER_0_545 VPWR VGND sg13cmos5l_fill_1
XFILLER_29_763 VPWR VGND sg13cmos5l_decap_8
X_4070__314 _4070_/RESET_B VPWR VGND sg13cmos5l_tiehi
XFILLER_16_413 VPWR VGND sg13cmos5l_fill_2
XFILLER_29_785 VPWR VGND sg13cmos5l_fill_1
XFILLER_44_799 VPWR VGND sg13cmos5l_decap_8
XFILLER_32_939 VPWR VGND sg13cmos5l_fill_2
Xclkbuf_leaf_23_clk clkload5/A clkbuf_leaf_4_clk/A VPWR VGND sg13cmos5l_buf_8
XFILLER_12_630 VPWR VGND sg13cmos5l_decap_8
XFILLER_40_994 VPWR VGND sg13cmos5l_decap_8
XFILLER_8_656 VPWR VGND sg13cmos5l_decap_8
XFILLER_7_122 VPWR VGND sg13cmos5l_fill_2
X_3180_ _3180_/X _3180_/A _3180_/B VPWR VGND sg13cmos5l_and2_1
XFILLER_14_4 VPWR VGND sg13cmos5l_fill_2
X_4116__266 _4116_/RESET_B VPWR VGND sg13cmos5l_tiehi
XFILLER_35_766 VPWR VGND sg13cmos5l_decap_4
XFILLER_34_254 VPWR VGND sg13cmos5l_decap_8
X_2964_ _3029_/A _3246_/B _3254_/A VPWR VGND sg13cmos5l_nand2b_1
Xclkbuf_leaf_14_clk _4238_/CLK clkload1/A VPWR VGND sg13cmos5l_buf_8
XFILLER_31_950 VPWR VGND sg13cmos5l_decap_8
X_2895_ _2895_/Y _4192_/Q _2892_/B _2894_/Y _4193_/Q VPWR VGND sg13cmos5l_a22oi_1
XFILLER_33_1027 VPWR VGND sg13cmos5l_fill_2
Xhold612 _2225_/A _4257_/Q VPWR VGND sg13cmos5l_dlygate4sd3_1
Xhold601 _4178_/D _2789_/X VPWR VGND sg13cmos5l_dlygate4sd3_1
Xhold634 _2469_/B _2468_/Y VPWR VGND sg13cmos5l_dlygate4sd3_1
X_3516_ _3516_/Y _4306_/Q _4305_/Q VPWR VGND sg13cmos5l_xnor2_1
Xhold645 _2235_/A _4126_/Q VPWR VGND sg13cmos5l_dlygate4sd3_1
Xhold623 _4172_/D _2784_/Y VPWR VGND sg13cmos5l_dlygate4sd3_1
Xhold656 hold656/X _4072_/Q VPWR VGND sg13cmos5l_dlygate4sd3_1
Xhold678 hold678/X _4058_/Q VPWR VGND sg13cmos5l_dlygate4sd3_1
Xhold667 hold667/X _3992_/Q VPWR VGND sg13cmos5l_dlygate4sd3_1
X_3447_ _3447_/X _3447_/A _3447_/B _3447_/C _3447_/D VPWR VGND sg13cmos5l_or4_1
Xhold689 hold689/X _4026_/Q VPWR VGND sg13cmos5l_dlygate4sd3_1
X_3378_ _3378_/X _3377_/B _3371_/C _3371_/A VPWR VGND sg13cmos5l_a21o_1
X_2329_ _4018_/D _3951_/A0 hold712/X _2336_/B VPWR VGND sg13cmos5l_mux2_1
XFILLER_38_560 VPWR VGND sg13cmos5l_decap_8
XFILLER_40_257 VPWR VGND sg13cmos5l_decap_8
XFILLER_21_460 VPWR VGND sg13cmos5l_decap_8
XFILLER_5_615 VPWR VGND sg13cmos5l_decap_4
XFILLER_49_1023 VPWR VGND sg13cmos5l_decap_4
XFILLER_1_810 VPWR VGND sg13cmos5l_decap_8
XFILLER_0_331 VPWR VGND sg13cmos5l_decap_8
XFILLER_1_887 VPWR VGND sg13cmos5l_decap_8
XFILLER_49_869 VPWR VGND sg13cmos5l_decap_8
XFILLER_48_379 VPWR VGND sg13cmos5l_decap_8
XFILLER_16_210 VPWR VGND sg13cmos5l_decap_4
XFILLER_44_552 VPWR VGND sg13cmos5l_fill_1
XFILLER_17_766 VPWR VGND sg13cmos5l_fill_1
XFILLER_31_202 VPWR VGND sg13cmos5l_decap_8
XFILLER_31_213 VPWR VGND sg13cmos5l_fill_2
XFILLER_12_471 VPWR VGND sg13cmos5l_fill_1
XFILLER_31_279 VPWR VGND sg13cmos5l_fill_2
X_2680_ _2680_/Y _2680_/A _3993_/Q VPWR VGND sg13cmos5l_nor2b_1
XFILLER_9_965 VPWR VGND sg13cmos5l_decap_8
X_4350_ _4350_/Q _4377_/CLK _4350_/D _4350_/RESET_B VPWR VGND sg13cmos5l_dfrbpq_1
XFILLER_4_670 VPWR VGND sg13cmos5l_decap_4
X_3301_ _3301_/Y _3293_/B _3293_/C _3167_/B VPWR VGND sg13cmos5l_a21oi_1
X_4281_ _4281_/Q _4333_/CLK _4281_/D _4281_/RESET_B VPWR VGND sg13cmos5l_dfrbpq_1
X_3232_ _3232_/Y _4254_/Q _3234_/B VPWR VGND sg13cmos5l_nand2_1
Xclkbuf_leaf_3_clk _4378_/CLK clkbuf_leaf_3_clk/A VPWR VGND sg13cmos5l_buf_8
XFILLER_39_302 VPWR VGND sg13cmos5l_fill_1
X_3163_ _4242_/D _3258_/B _3163_/B VPWR VGND sg13cmos5l_nor2_1
XFILLER_48_880 VPWR VGND sg13cmos5l_decap_8
X_3094_ _3094_/Y _3094_/A VPWR VGND sg13cmos5l_inv_1
X_4053__331 _4053_/RESET_B VPWR VGND sg13cmos5l_tiehi
XFILLER_35_530 VPWR VGND sg13cmos5l_decap_4
XFILLER_35_563 VPWR VGND sg13cmos5l_decap_8
XFILLER_22_213 VPWR VGND sg13cmos5l_decap_8
Xfanout28 _3962_/S _3949_/Y VPWR VGND sg13cmos5l_buf_1
X_3996_ _3996_/Q _4181_/CLK _3996_/D _3996_/RESET_B VPWR VGND sg13cmos5l_dfrbpq_1
Xfanout39 _3667_/B _3638_/Y VPWR VGND sg13cmos5l_buf_1
X_2947_ _2947_/Y _2951_/A _2959_/A VPWR VGND sg13cmos5l_nand2_1
X_2878_ _2879_/B _2866_/B _2866_/C _2874_/A VPWR VGND sg13cmos5l_a21oi_1
XFILLER_2_607 VPWR VGND sg13cmos5l_decap_4
X_4060__324 _4060_/RESET_B VPWR VGND sg13cmos5l_tiehi
XFILLER_46_817 VPWR VGND sg13cmos5l_decap_8
XFILLER_41_544 VPWR VGND sg13cmos5l_fill_2
XFILLER_10_920 VPWR VGND sg13cmos5l_decap_8
XFILLER_10_997 VPWR VGND sg13cmos5l_decap_8
XFILLER_6_979 VPWR VGND sg13cmos5l_decap_8
XFILLER_49_611 VPWR VGND sg13cmos5l_decap_8
XFILLER_23_1004 VPWR VGND sg13cmos5l_decap_8
XFILLER_37_839 VPWR VGND sg13cmos5l_decap_8
XFILLER_36_305 VPWR VGND sg13cmos5l_decap_4
XFILLER_45_861 VPWR VGND sg13cmos5l_decap_8
X_3850_ _3850_/Y _3848_/X _3849_/Y _3868_/A VPWR VGND sg13cmos5l_o21ai_1
X_3781_ _3781_/Y _2211_/Y _3781_/A2 _3780_/Y VPWR VGND sg13cmos5l_a21oi_1
X_2801_ _2801_/Y _2806_/B _2808_/A _2801_/C VPWR VGND sg13cmos5l_nor3_1
X_2732_ _2744_/B _4157_/Q _4158_/Q _4159_/Q VPWR VGND sg13cmos5l_nor3_1
XFILLER_12_290 VPWR VGND sg13cmos5l_fill_2
XFILLER_9_795 VPWR VGND sg13cmos5l_decap_4
X_2663_ _2663_/Y _2629_/A _4107_/Q VPWR VGND sg13cmos5l_nand2b_1
X_2594_ _2594_/Y _2698_/A _4083_/Q _2708_/S1 VPWR VGND sg13cmos5l_a21oi_1
X_4333_ _4333_/Q _4333_/CLK _4333_/D _4333_/RESET_B VPWR VGND sg13cmos5l_dfrbpq_1
X_4264_ _4264_/Q _4272_/CLK _4264_/D _4264_/RESET_B VPWR VGND sg13cmos5l_dfrbpq_1
X_3215_ _3215_/Y _4272_/Q _3064_/A _4223_/Q _2258_/Y VPWR VGND sg13cmos5l_a22oi_1
X_4195_ _4195_/Q _4234_/CLK _4195_/D _4195_/RESET_B VPWR VGND sg13cmos5l_dfrbpq_1
XFILLER_39_154 VPWR VGND sg13cmos5l_fill_2
X_3146_ _3146_/Y _3380_/A _3169_/B _3145_/X VPWR VGND sg13cmos5l_o21ai_1
XFILLER_28_817 VPWR VGND sg13cmos5l_decap_8
X_3077_ _4233_/D _3077_/A _3079_/B VPWR VGND sg13cmos5l_nor2_1
XFILLER_10_216 VPWR VGND sg13cmos5l_decap_8
XFILLER_11_717 VPWR VGND sg13cmos5l_fill_1
X_3979_ _3979_/Q _4181_/CLK _3979_/D _3979_/RESET_B VPWR VGND sg13cmos5l_dfrbpq_1
XFILLER_40_58 VPWR VGND sg13cmos5l_decap_8
XFILLER_49_67 VPWR VGND sg13cmos5l_decap_8
XFILLER_46_636 VPWR VGND sg13cmos5l_fill_2
XFILLER_45_124 VPWR VGND sg13cmos5l_decap_4
XFILLER_45_157 VPWR VGND sg13cmos5l_fill_1
XFILLER_27_872 VPWR VGND sg13cmos5l_fill_1
XFILLER_45_179 VPWR VGND sg13cmos5l_decap_4
XFILLER_14_533 VPWR VGND sg13cmos5l_decap_8
XFILLER_6_710 VPWR VGND sg13cmos5l_decap_8
XFILLER_6_743 VPWR VGND sg13cmos5l_decap_8
X_4043__341 _4043_/RESET_B VPWR VGND sg13cmos5l_tiehi
XFILLER_2_960 VPWR VGND sg13cmos5l_decap_8
Xinput7 input7/X uio_in[1] VPWR VGND sg13cmos5l_buf_1
X_3000_ _4212_/D _3079_/B _3113_/A VPWR VGND sg13cmos5l_nor2_1
XFILLER_18_861 VPWR VGND sg13cmos5l_decap_8
XFILLER_33_831 VPWR VGND sg13cmos5l_decap_4
XFILLER_36_179 VPWR VGND sg13cmos5l_decap_8
X_4050__334 _4050_/RESET_B VPWR VGND sg13cmos5l_tiehi
X_3902_ _3909_/B _4372_/Q _3903_/C VPWR VGND sg13cmos5l_nor2_1
X_3833_ _3836_/A _3834_/B _3833_/B VPWR VGND sg13cmos5l_nand2_1
XFILLER_20_525 VPWR VGND sg13cmos5l_decap_8
X_3764_ _3771_/S _3764_/A _3764_/B VPWR VGND sg13cmos5l_nor2_1
X_3695_ _3695_/Y _3695_/A VPWR VGND sg13cmos5l_inv_1
X_2715_ _4149_/D _2232_/Y _2910_/A2 _2714_/Y VPWR VGND sg13cmos5l_a21oi_1
X_2646_ _4148_/D _2784_/A2 _2723_/B _2645_/Y VPWR VGND sg13cmos5l_a21oi_1
XFILLER_10_39 VPWR VGND sg13cmos5l_decap_8
X_2577_ _2577_/Y _2680_/A _4026_/Q VPWR VGND sg13cmos5l_nand2b_1
X_4316_ _4316_/Q clkload6/A _4316_/D _4316_/RESET_B VPWR VGND sg13cmos5l_dfrbpq_1
X_4247_ _4247_/Q _4302_/CLK _4247_/D _4247_/RESET_B VPWR VGND sg13cmos5l_dfrbpq_1
X_4178_ _4178_/Q _4225_/CLK _4178_/D _4178_/RESET_B VPWR VGND sg13cmos5l_dfrbpq_1
XFILLER_27_113 VPWR VGND sg13cmos5l_decap_8
XFILLER_43_617 VPWR VGND sg13cmos5l_fill_2
X_3129_ _3169_/A _4245_/Q _3129_/B VPWR VGND sg13cmos5l_xor2_1
X_4252__482 _4252_/RESET_B VPWR VGND sg13cmos5l_tiehi
XFILLER_11_525 VPWR VGND sg13cmos5l_decap_8
XFILLER_7_529 VPWR VGND sg13cmos5l_decap_8
XFILLER_3_757 VPWR VGND sg13cmos5l_fill_2
XFILLER_2_256 VPWR VGND sg13cmos5l_decap_4
XFILLER_47_912 VPWR VGND sg13cmos5l_decap_8
XFILLER_47_989 VPWR VGND sg13cmos5l_decap_8
XFILLER_18_157 VPWR VGND sg13cmos5l_decap_8
XFILLER_34_606 VPWR VGND sg13cmos5l_decap_4
XFILLER_15_864 VPWR VGND sg13cmos5l_decap_8
XFILLER_42_661 VPWR VGND sg13cmos5l_decap_8
XFILLER_6_562 VPWR VGND sg13cmos5l_fill_1
X_3480_ _3481_/C _3480_/A _3480_/B _3480_/C VPWR VGND sg13cmos5l_and3_1
X_2500_ _3926_/B _2500_/A _2500_/B _2500_/C VPWR VGND sg13cmos5l_nand3_1
X_2431_ _2439_/S _3949_/A _2431_/B VPWR VGND sg13cmos5l_nand2_1
XFILLER_29_1010 VPWR VGND sg13cmos5l_decap_8
X_2362_ _2370_/S _3963_/B _2371_/C VPWR VGND sg13cmos5l_nand2_1
X_4101_ _4101_/Q clkload8/A _4101_/D _4101_/RESET_B VPWR VGND sg13cmos5l_dfrbpq_1
X_2293_ _2294_/B _2293_/A VPWR VGND sg13cmos5l_inv_1
X_4032_ _4032_/Q _4181_/CLK _4032_/D _4032_/RESET_B VPWR VGND sg13cmos5l_dfrbpq_1
XFILLER_2_84 VPWR VGND sg13cmos5l_fill_1
XFILLER_37_499 VPWR VGND sg13cmos5l_fill_2
XFILLER_36_1003 VPWR VGND sg13cmos5l_decap_8
XFILLER_33_683 VPWR VGND sg13cmos5l_fill_1
XFILLER_32_171 VPWR VGND sg13cmos5l_fill_1
X_3816_ _3816_/Y _3785_/A _4313_/Q _4312_/Q _3784_/A _3822_/A VPWR VGND sg13cmos5l_a221oi_1
XFILLER_20_366 VPWR VGND sg13cmos5l_fill_1
X_3747_ _3747_/Y _3757_/B _3746_/Y _3745_/Y VPWR VGND sg13cmos5l_a21oi_1
X_4126__246 _4126_/RESET_B VPWR VGND sg13cmos5l_tiehi
X_3678_ _4333_/D _3655_/X _3680_/A _3677_/Y VPWR VGND sg13cmos5l_a21oi_1
X_2629_ _2629_/Y _2629_/A _4072_/Q VPWR VGND sg13cmos5l_nor2b_1
XFILLER_0_727 VPWR VGND sg13cmos5l_fill_1
XFILLER_29_923 VPWR VGND sg13cmos5l_decap_8
XFILLER_28_411 VPWR VGND sg13cmos5l_fill_1
XFILLER_44_904 VPWR VGND sg13cmos5l_decap_8
XFILLER_29_989 VPWR VGND sg13cmos5l_decap_8
XFILLER_43_425 VPWR VGND sg13cmos5l_fill_1
X_4033__351 _4033_/RESET_B VPWR VGND sg13cmos5l_tiehi
XFILLER_8_816 VPWR VGND sg13cmos5l_decap_8
XFILLER_11_388 VPWR VGND sg13cmos5l_fill_1
XFILLER_3_576 VPWR VGND sg13cmos5l_decap_8
X_4040__344 _4040_/RESET_B VPWR VGND sg13cmos5l_tiehi
XFILLER_38_219 VPWR VGND sg13cmos5l_decap_8
XFILLER_38_208 VPWR VGND sg13cmos5l_fill_1
XFILLER_4_1012 VPWR VGND sg13cmos5l_decap_8
XFILLER_19_411 VPWR VGND sg13cmos5l_decap_8
XFILLER_19_466 VPWR VGND sg13cmos5l_decap_8
XFILLER_47_786 VPWR VGND sg13cmos5l_decap_8
XFILLER_34_403 VPWR VGND sg13cmos5l_decap_8
XFILLER_35_926 VPWR VGND sg13cmos5l_decap_4
X_2980_ _2983_/B _4237_/Q _2980_/B VPWR VGND sg13cmos5l_nand2_1
XFILLER_42_491 VPWR VGND sg13cmos5l_decap_8
Xinput10 input10/X uio_in[4] VPWR VGND sg13cmos5l_buf_1
X_3601_ _4316_/D _3681_/A _3601_/B VPWR VGND sg13cmos5l_nor2_1
XFILLER_7_860 VPWR VGND sg13cmos5l_decap_8
Xhold805 hold805/X _4098_/Q VPWR VGND sg13cmos5l_dlygate4sd3_1
Xhold816 _2218_/A _4344_/Q VPWR VGND sg13cmos5l_dlygate4sd3_1
X_3532_ _3532_/Y _3532_/A _3536_/B VPWR VGND sg13cmos5l_nand2_1
Xhold827 _2610_/A _4139_/Q VPWR VGND sg13cmos5l_dlygate4sd3_1
Xhold838 _3761_/B _4362_/Q VPWR VGND sg13cmos5l_dlygate4sd3_1
Xhold849 _4315_/D _3598_/Y VPWR VGND sg13cmos5l_dlygate4sd3_1
X_3463_ _3480_/C _4297_/Q _3477_/B VPWR VGND sg13cmos5l_xnor2_1
X_4242__492 _4242_/RESET_B VPWR VGND sg13cmos5l_tiehi
X_4160__192 _4160_/RESET_B VPWR VGND sg13cmos5l_tiehi
X_2414_ _4087_/D _2434_/A0 hold806/X _2420_/S VPWR VGND sg13cmos5l_mux2_1
X_3394_ _3487_/B _3369_/X _3380_/B _3168_/Y VPWR VGND sg13cmos5l_o21ai_1
XFILLER_35_0 VPWR VGND sg13cmos5l_decap_4
X_2345_ _4029_/D _3954_/A hold720/X _2349_/S VPWR VGND sg13cmos5l_mux2_1
XFILLER_38_720 VPWR VGND sg13cmos5l_fill_1
X_2276_ _3580_/B _4285_/Q VPWR VGND sg13cmos5l_inv_1
XFILLER_29_219 VPWR VGND sg13cmos5l_fill_2
XFILLER_38_764 VPWR VGND sg13cmos5l_decap_8
X_4015_ _4015_/Q _4181_/CLK _4015_/D _4015_/RESET_B VPWR VGND sg13cmos5l_dfrbpq_1
XFILLER_37_252 VPWR VGND sg13cmos5l_fill_1
XFILLER_16_16 VPWR VGND sg13cmos5l_fill_2
XFILLER_40_406 VPWR VGND sg13cmos5l_fill_2
XFILLER_13_609 VPWR VGND sg13cmos5l_fill_2
XFILLER_33_491 VPWR VGND sg13cmos5l_fill_1
XFILLER_34_992 VPWR VGND sg13cmos5l_decap_8
XFILLER_21_675 VPWR VGND sg13cmos5l_decap_4
XFILLER_0_568 VPWR VGND sg13cmos5l_decap_8
XFILLER_29_720 VPWR VGND sg13cmos5l_decap_4
X_3978__581 _3978_/RESET_B VPWR VGND sg13cmos5l_tiehi
XFILLER_17_904 VPWR VGND sg13cmos5l_fill_2
XFILLER_29_742 VPWR VGND sg13cmos5l_decap_8
XFILLER_43_200 VPWR VGND sg13cmos5l_fill_1
XFILLER_29_775 VPWR VGND sg13cmos5l_decap_4
XFILLER_29_797 VPWR VGND sg13cmos5l_decap_8
XFILLER_43_233 VPWR VGND sg13cmos5l_fill_1
XFILLER_43_211 VPWR VGND sg13cmos5l_fill_2
XFILLER_31_417 VPWR VGND sg13cmos5l_fill_1
XFILLER_40_973 VPWR VGND sg13cmos5l_decap_8
XFILLER_11_130 VPWR VGND sg13cmos5l_fill_1
XFILLER_4_874 VPWR VGND sg13cmos5l_decap_4
X_4196__553 _4196_/RESET_B VPWR VGND sg13cmos5l_tiehi
XFILLER_47_594 VPWR VGND sg13cmos5l_decap_8
X_2963_ _2963_/Y _3323_/A _3246_/B VPWR VGND sg13cmos5l_nor2_1
XFILLER_34_277 VPWR VGND sg13cmos5l_decap_4
XFILLER_33_1006 VPWR VGND sg13cmos5l_decap_8
X_2894_ _2894_/Y _2776_/A _4167_/Q _3027_/B VPWR VGND sg13cmos5l_a21oi_1
XFILLER_8_72 VPWR VGND sg13cmos5l_decap_4
Xhold602 _2266_/A _4025_/Q VPWR VGND sg13cmos5l_dlygate4sd3_1
X_3515_ _3515_/X _3515_/A _3515_/B VPWR VGND sg13cmos5l_xor2_1
Xhold635 _2448_/A _4125_/Q VPWR VGND sg13cmos5l_dlygate4sd3_1
Xhold624 _3440_/B _4262_/Q VPWR VGND sg13cmos5l_dlygate4sd3_1
Xhold613 _4289_/D _3433_/Y VPWR VGND sg13cmos5l_dlygate4sd3_1
Xhold657 hold657/X _4226_/Q VPWR VGND sg13cmos5l_dlygate4sd3_1
Xhold646 _3255_/B _4231_/Q VPWR VGND sg13cmos5l_dlygate4sd3_1
Xhold668 _2778_/B _4147_/Q VPWR VGND sg13cmos5l_dlygate4sd3_1
Xhold679 _4058_/D _2379_/X VPWR VGND sg13cmos5l_dlygate4sd3_1
X_3446_ _3446_/Y _3350_/B _3452_/A _3473_/A _3355_/B VPWR VGND sg13cmos5l_a22oi_1
X_4023__361 _4023_/RESET_B VPWR VGND sg13cmos5l_tiehi
X_3377_ _3380_/B _4249_/Q _3377_/B VPWR VGND sg13cmos5l_xor2_1
X_2328_ _4017_/D _3950_/A0 hold788/X _2336_/B VPWR VGND sg13cmos5l_mux2_1
X_2259_ _3445_/A _3225_/B VPWR VGND sg13cmos5l_inv_1
XFILLER_26_701 VPWR VGND sg13cmos5l_fill_1
XFILLER_38_594 VPWR VGND sg13cmos5l_decap_8
XFILLER_41_715 VPWR VGND sg13cmos5l_decap_8
XFILLER_41_704 VPWR VGND sg13cmos5l_fill_2
XFILLER_14_929 VPWR VGND sg13cmos5l_fill_2
XFILLER_43_36 VPWR VGND sg13cmos5l_decap_4
XFILLER_41_726 VPWR VGND sg13cmos5l_fill_1
XFILLER_43_69 VPWR VGND sg13cmos5l_fill_1
X_4030__354 _4030_/RESET_B VPWR VGND sg13cmos5l_tiehi
XFILLER_40_247 VPWR VGND sg13cmos5l_fill_1
XFILLER_22_940 VPWR VGND sg13cmos5l_decap_8
XFILLER_22_984 VPWR VGND sg13cmos5l_fill_2
XFILLER_49_1002 VPWR VGND sg13cmos5l_decap_8
XFILLER_4_126 VPWR VGND sg13cmos5l_fill_2
XFILLER_1_866 VPWR VGND sg13cmos5l_decap_8
XFILLER_49_848 VPWR VGND sg13cmos5l_decap_8
XFILLER_36_509 VPWR VGND sg13cmos5l_fill_1
XFILLER_44_531 VPWR VGND sg13cmos5l_decap_4
XFILLER_17_745 VPWR VGND sg13cmos5l_decap_8
XFILLER_17_778 VPWR VGND sg13cmos5l_fill_1
XFILLER_16_277 VPWR VGND sg13cmos5l_decap_8
XFILLER_32_726 VPWR VGND sg13cmos5l_decap_8
XFILLER_31_247 VPWR VGND sg13cmos5l_fill_2
XFILLER_9_944 VPWR VGND sg13cmos5l_decap_8
XFILLER_13_995 VPWR VGND sg13cmos5l_decap_8
XFILLER_8_443 VPWR VGND sg13cmos5l_decap_8
XFILLER_8_465 VPWR VGND sg13cmos5l_decap_8
X_3300_ _3300_/X _3300_/A _3308_/A _3300_/C VPWR VGND sg13cmos5l_or3_1
X_4280_ _4280_/Q _4333_/CLK _4280_/D _4280_/RESET_B VPWR VGND sg13cmos5l_dfrbpq_1
X_3231_ _3234_/B _3444_/A _3445_/A _3064_/A _4223_/Q VPWR VGND sg13cmos5l_a22oi_1
X_3162_ _3162_/X _3148_/Y _3388_/A _3159_/Y VPWR VGND sg13cmos5l_a21o_1
X_3093_ _3094_/A _3115_/B _3093_/B VPWR VGND sg13cmos5l_nor2_1
XFILLER_47_391 VPWR VGND sg13cmos5l_decap_8
XFILLER_23_704 VPWR VGND sg13cmos5l_decap_8
XFILLER_23_715 VPWR VGND sg13cmos5l_fill_2
Xfanout29 _3960_/S _3949_/Y VPWR VGND sg13cmos5l_buf_1
X_3995_ _3995_/Q clkload9/A _3995_/D _3995_/RESET_B VPWR VGND sg13cmos5l_dfrbpq_1
X_2946_ _2959_/A _2853_/X _2877_/B _2946_/S VPWR VGND sg13cmos5l_mux2_1
XFILLER_13_17 VPWR VGND sg13cmos5l_fill_2
XFILLER_22_269 VPWR VGND sg13cmos5l_fill_1
XFILLER_31_781 VPWR VGND sg13cmos5l_decap_8
X_2877_ _4188_/D _2962_/A _2877_/B VPWR VGND sg13cmos5l_and2_1
X_3429_ _3429_/Y _3429_/A _3429_/B VPWR VGND sg13cmos5l_nand2_1
X_4277__160 _4277_/D VPWR VGND sg13cmos5l_tielo
XFILLER_45_306 VPWR VGND sg13cmos5l_fill_2
XFILLER_45_339 VPWR VGND sg13cmos5l_fill_1
XFILLER_14_704 VPWR VGND sg13cmos5l_decap_8
XFILLER_13_214 VPWR VGND sg13cmos5l_decap_4
XFILLER_14_737 VPWR VGND sg13cmos5l_fill_1
XFILLER_13_247 VPWR VGND sg13cmos5l_decap_8
XFILLER_13_258 VPWR VGND sg13cmos5l_fill_2
XFILLER_22_792 VPWR VGND sg13cmos5l_fill_2
XFILLER_10_976 VPWR VGND sg13cmos5l_decap_8
XFILLER_6_958 VPWR VGND sg13cmos5l_decap_8
X_3982__555 _3982_/RESET_B VPWR VGND sg13cmos5l_tiehi
XFILLER_5_468 VPWR VGND sg13cmos5l_decap_4
XFILLER_0_151 VPWR VGND sg13cmos5l_fill_2
XFILLER_37_807 VPWR VGND sg13cmos5l_decap_8
XFILLER_45_840 VPWR VGND sg13cmos5l_decap_8
XFILLER_28_80 VPWR VGND sg13cmos5l_fill_1
XFILLER_29_391 VPWR VGND sg13cmos5l_decap_8
XFILLER_17_542 VPWR VGND sg13cmos5l_decap_8
XFILLER_32_501 VPWR VGND sg13cmos5l_decap_8
XFILLER_44_90 VPWR VGND sg13cmos5l_fill_2
X_3780_ _3780_/Y _4352_/Q _3781_/A2 _3615_/A VPWR VGND sg13cmos5l_o21ai_1
X_2800_ _2801_/C _2800_/A _2800_/B VPWR VGND sg13cmos5l_nor2_1
X_2731_ _2866_/A _2765_/B _4181_/Q VPWR VGND sg13cmos5l_xnor2_1
X_2662_ _2679_/B _2441_/B _2653_/Y _2661_/Y VPWR VGND sg13cmos5l_o21ai_1
X_2593_ _2593_/Y _2698_/A _4100_/Q VPWR VGND sg13cmos5l_nand2b_1
X_4332_ _4332_/Q _4333_/CLK _4332_/D _4332_/RESET_B VPWR VGND sg13cmos5l_dfrbpq_1
XFILLER_4_490 VPWR VGND sg13cmos5l_fill_1
X_4263_ _4263_/Q _4272_/CLK _4263_/D _4263_/RESET_B VPWR VGND sg13cmos5l_dfrbpq_1
X_3214_ _3214_/Y _3443_/A _4222_/Q _3213_/Y VPWR VGND sg13cmos5l_o21ai_1
X_4020__364 _4020_/RESET_B VPWR VGND sg13cmos5l_tiehi
X_4194_ _4194_/Q _4262_/CLK _4194_/D _4194_/RESET_B VPWR VGND sg13cmos5l_dfrbpq_1
XFILLER_39_177 VPWR VGND sg13cmos5l_fill_1
XFILLER_39_166 VPWR VGND sg13cmos5l_decap_8
X_3145_ _3145_/X _3144_/B _3135_/B _3371_/A VPWR VGND sg13cmos5l_a21o_1
X_3994__437 _3994_/RESET_B VPWR VGND sg13cmos5l_tiehi
X_3076_ _4232_/D _3076_/A _3123_/A VPWR VGND sg13cmos5l_and2_1
XFILLER_39_1012 VPWR VGND sg13cmos5l_decap_8
XFILLER_36_862 VPWR VGND sg13cmos5l_fill_1
X_4350__265 _4350_/RESET_B VPWR VGND sg13cmos5l_tiehi
XFILLER_23_556 VPWR VGND sg13cmos5l_decap_8
X_3978_ _3978_/Q clkload9/A _3978_/D _3978_/RESET_B VPWR VGND sg13cmos5l_dfrbpq_1
X_4309__156 _4309_/D VPWR VGND sg13cmos5l_tielo
X_2929_ _2948_/B _2927_/Y _2928_/Y _2926_/Y VPWR VGND sg13cmos5l_a21oi_1
XFILLER_49_46 VPWR VGND sg13cmos5l_decap_8
XFILLER_46_1027 VPWR VGND sg13cmos5l_fill_2
X_4136__226 _4136_/RESET_B VPWR VGND sg13cmos5l_tiehi
XFILLER_46_648 VPWR VGND sg13cmos5l_fill_2
XFILLER_26_361 VPWR VGND sg13cmos5l_decap_8
XFILLER_26_372 VPWR VGND sg13cmos5l_fill_2
XFILLER_26_383 VPWR VGND sg13cmos5l_fill_2
XFILLER_41_342 VPWR VGND sg13cmos5l_fill_2
XFILLER_41_386 VPWR VGND sg13cmos5l_fill_1
XFILLER_49_475 VPWR VGND sg13cmos5l_fill_1
Xinput8 input8/X uio_in[2] VPWR VGND sg13cmos5l_buf_1
XFILLER_37_615 VPWR VGND sg13cmos5l_decap_4
XFILLER_18_884 VPWR VGND sg13cmos5l_decap_8
X_3901_ _3903_/C _4375_/Q _3901_/B VPWR VGND sg13cmos5l_nor2_1
X_3832_ _3833_/B _3811_/Y _3819_/A _3826_/A VPWR VGND sg13cmos5l_o21ai_1
XFILLER_33_887 VPWR VGND sg13cmos5l_decap_8
X_3763_ _3764_/B _3773_/B _3761_/Y _3773_/A VPWR VGND sg13cmos5l_o21ai_1
X_3694_ _3695_/A _4337_/Q _4338_/Q VPWR VGND sg13cmos5l_xor2_1
X_2714_ _2714_/Y _2910_/A2 _2722_/B _2718_/A VPWR VGND sg13cmos5l_o21ai_1
XFILLER_10_18 VPWR VGND sg13cmos5l_decap_8
X_2645_ _2645_/Y _2233_/A _2784_/A2 _2718_/A VPWR VGND sg13cmos5l_o21ai_1
X_4315_ _4315_/Q clkload6/A _4315_/D _4315_/RESET_B VPWR VGND sg13cmos5l_dfrbpq_1
X_2576_ _2576_/Y _2576_/A _2576_/B VPWR VGND sg13cmos5l_nand2_1
X_4246_ _4246_/Q _4303_/CLK _4246_/D _4246_/RESET_B VPWR VGND sg13cmos5l_dfrbpq_1
X_4177_ _4177_/Q _4225_/CLK _4177_/D _4177_/RESET_B VPWR VGND sg13cmos5l_dfrbpq_1
X_3128_ _3129_/B _4243_/Q _4244_/Q _4241_/Q _4242_/Q VPWR VGND sg13cmos5l_nor4_1
XFILLER_28_637 VPWR VGND sg13cmos5l_decap_4
XFILLER_28_659 VPWR VGND sg13cmos5l_fill_2
XFILLER_27_169 VPWR VGND sg13cmos5l_decap_8
X_3059_ _3059_/Y _3059_/A _3059_/B VPWR VGND sg13cmos5l_nand2_1
XFILLER_7_508 VPWR VGND sg13cmos5l_decap_8
XFILLER_19_648 VPWR VGND sg13cmos5l_fill_2
XFILLER_20_1019 VPWR VGND sg13cmos5l_decap_8
XFILLER_47_968 VPWR VGND sg13cmos5l_decap_8
XFILLER_15_843 VPWR VGND sg13cmos5l_decap_8
XFILLER_42_695 VPWR VGND sg13cmos5l_fill_1
XFILLER_41_161 VPWR VGND sg13cmos5l_decap_4
XFILLER_25_92 VPWR VGND sg13cmos5l_fill_2
XFILLER_30_868 VPWR VGND sg13cmos5l_fill_1
XFILLER_10_570 VPWR VGND sg13cmos5l_decap_8
XFILLER_6_530 VPWR VGND sg13cmos5l_fill_1
X_2430_ _4101_/D _2439_/A0 hold765/X _2430_/S VPWR VGND sg13cmos5l_mux2_1
X_2361_ _2371_/C _4129_/Q _2500_/B VPWR VGND sg13cmos5l_nor2b_1
X_4100_ _4100_/Q _4128_/CLK _4100_/D _4100_/RESET_B VPWR VGND sg13cmos5l_dfrbpq_1
XFILLER_2_791 VPWR VGND sg13cmos5l_fill_2
X_2292_ _2293_/A _4122_/Q _4121_/Q _2480_/A VPWR VGND sg13cmos5l_nor3_1
X_4031_ _4031_/Q _4161_/CLK _4031_/D _4031_/RESET_B VPWR VGND sg13cmos5l_dfrbpq_1
XFILLER_2_41 VPWR VGND sg13cmos5l_decap_8
XFILLER_37_401 VPWR VGND sg13cmos5l_decap_4
XFILLER_38_979 VPWR VGND sg13cmos5l_decap_8
XFILLER_37_456 VPWR VGND sg13cmos5l_fill_1
XFILLER_37_478 VPWR VGND sg13cmos5l_decap_8
XFILLER_33_673 VPWR VGND sg13cmos5l_fill_1
X_3815_ _3815_/X _3783_/A _3814_/Y _3813_/X VPWR VGND sg13cmos5l_a21o_1
XFILLER_21_868 VPWR VGND sg13cmos5l_decap_8
X_3746_ _3746_/Y _4363_/Q _4358_/Q VPWR VGND sg13cmos5l_nor2b_1
XFILLER_21_39 VPWR VGND sg13cmos5l_decap_4
X_3677_ _3677_/Y _3656_/A _3680_/A _3620_/B VPWR VGND sg13cmos5l_o21ai_1
X_2628_ _2628_/Y _2629_/A _4089_/Q _2667_/B2 VPWR VGND sg13cmos5l_a21oi_1
X_2559_ _2566_/B _2788_/A _2789_/A VPWR VGND sg13cmos5l_nor2b_1
XFILLER_0_739 VPWR VGND sg13cmos5l_decap_8
X_4229_ _4229_/Q _4262_/CLK _4229_/D _4229_/RESET_B VPWR VGND sg13cmos5l_dfrbpq_1
XFILLER_28_434 VPWR VGND sg13cmos5l_decap_8
XFILLER_29_968 VPWR VGND sg13cmos5l_decap_8
XFILLER_16_629 VPWR VGND sg13cmos5l_fill_2
XFILLER_7_338 VPWR VGND sg13cmos5l_decap_4
XFILLER_3_511 VPWR VGND sg13cmos5l_fill_1
XFILLER_3_533 VPWR VGND sg13cmos5l_fill_2
XFILLER_46_231 VPWR VGND sg13cmos5l_decap_8
XFILLER_19_456 VPWR VGND sg13cmos5l_fill_2
XFILLER_46_264 VPWR VGND sg13cmos5l_decap_8
XFILLER_36_91 VPWR VGND sg13cmos5l_fill_1
XFILLER_43_982 VPWR VGND sg13cmos5l_decap_8
XFILLER_15_640 VPWR VGND sg13cmos5l_decap_4
Xinput11 input11/X uio_in[5] VPWR VGND sg13cmos5l_buf_1
X_3600_ _3601_/B _3599_/Y _3587_/Y _3600_/S VPWR VGND sg13cmos5l_mux2_1
X_3531_ _4305_/D _3619_/B _3531_/B VPWR VGND sg13cmos5l_nor2_1
Xhold828 hold828/X _4349_/Q VPWR VGND sg13cmos5l_dlygate4sd3_1
XFILLER_7_883 VPWR VGND sg13cmos5l_decap_8
Xhold817 _4131_/D _2506_/Y VPWR VGND sg13cmos5l_dlygate4sd3_1
Xhold806 hold806/X _4087_/Q VPWR VGND sg13cmos5l_dlygate4sd3_1
Xhold839 hold839/X _3761_/Y VPWR VGND sg13cmos5l_dlygate4sd3_1
X_3462_ _3480_/B _4291_/Q _4262_/Q _4296_/Q VPWR VGND sg13cmos5l_nand3_1
X_3393_ _4280_/D _3444_/B _3483_/A VPWR VGND sg13cmos5l_and2_1
X_2413_ _4086_/D _3965_/A0 hold719/X _2420_/S VPWR VGND sg13cmos5l_mux2_1
X_2344_ _4028_/D _3952_/A hold710/X _2349_/S VPWR VGND sg13cmos5l_mux2_1
X_2275_ _3429_/A _4287_/Q VPWR VGND sg13cmos5l_inv_1
X_4014_ _4014_/Q _4161_/CLK _4014_/D _4014_/RESET_B VPWR VGND sg13cmos5l_dfrbpq_1
XFILLER_25_404 VPWR VGND sg13cmos5l_decap_8
XFILLER_16_28 VPWR VGND sg13cmos5l_decap_4
XFILLER_4_308 VPWR VGND sg13cmos5l_decap_8
X_3729_ _4339_/D _3879_/A _3729_/B VPWR VGND sg13cmos5l_nor2_1
XFILLER_10_1018 VPWR VGND sg13cmos5l_decap_8
XFILLER_0_503 VPWR VGND sg13cmos5l_decap_8
XFILLER_29_710 VPWR VGND sg13cmos5l_decap_4
XFILLER_17_927 VPWR VGND sg13cmos5l_decap_4
XFILLER_44_735 VPWR VGND sg13cmos5l_fill_2
XFILLER_17_949 VPWR VGND sg13cmos5l_decap_4
XFILLER_32_919 VPWR VGND sg13cmos5l_fill_2
XFILLER_12_621 VPWR VGND sg13cmos5l_fill_1
XFILLER_19_1021 VPWR VGND sg13cmos5l_decap_8
XFILLER_40_952 VPWR VGND sg13cmos5l_decap_8
XFILLER_12_687 VPWR VGND sg13cmos5l_decap_4
XFILLER_11_175 VPWR VGND sg13cmos5l_decap_8
X_4109__275 _4109_/RESET_B VPWR VGND sg13cmos5l_tiehi
XFILLER_4_853 VPWR VGND sg13cmos5l_fill_2
XFILLER_4_886 VPWR VGND sg13cmos5l_decap_8
XFILLER_26_1025 VPWR VGND sg13cmos5l_decap_4
XFILLER_39_518 VPWR VGND sg13cmos5l_fill_1
XFILLER_14_6 VPWR VGND sg13cmos5l_fill_1
XFILLER_19_264 VPWR VGND sg13cmos5l_decap_8
XFILLER_34_201 VPWR VGND sg13cmos5l_decap_8
XFILLER_34_223 VPWR VGND sg13cmos5l_fill_2
XFILLER_43_790 VPWR VGND sg13cmos5l_decap_4
X_2962_ _4208_/D _2962_/A _2962_/B VPWR VGND sg13cmos5l_and2_1
XFILLER_15_470 VPWR VGND sg13cmos5l_fill_2
XFILLER_22_418 VPWR VGND sg13cmos5l_fill_2
XFILLER_8_40 VPWR VGND sg13cmos5l_fill_1
X_2893_ _2893_/Y _2893_/A _2893_/B VPWR VGND sg13cmos5l_nand2_1
XFILLER_31_985 VPWR VGND sg13cmos5l_decap_8
Xhold603 _2267_/A _3995_/Q VPWR VGND sg13cmos5l_dlygate4sd3_1
X_3514_ _3514_/Y _4332_/Q _4305_/Q VPWR VGND sg13cmos5l_nand2_1
Xhold636 _3973_/A _2447_/Y VPWR VGND sg13cmos5l_dlygate4sd3_1
Xhold614 _2265_/A _4004_/Q VPWR VGND sg13cmos5l_dlygate4sd3_1
Xhold625 _3066_/B _4195_/Q VPWR VGND sg13cmos5l_dlygate4sd3_1
X_3445_ _4299_/D _3445_/A _3502_/A VPWR VGND sg13cmos5l_nor2_1
Xhold647 _2522_/A _4371_/Q VPWR VGND sg13cmos5l_dlygate4sd3_1
Xhold669 hold669/X _4290_/Q VPWR VGND sg13cmos5l_dlygate4sd3_1
Xhold658 _2233_/A _4148_/Q VPWR VGND sg13cmos5l_dlygate4sd3_1
X_3376_ _3376_/X _3376_/A _3376_/B _3376_/C VPWR VGND sg13cmos5l_and3_1
X_2327_ _2334_/S _3775_/A _2500_/C _3963_/A VPWR VGND sg13cmos5l_nand3_1
X_2258_ _2258_/Y _4271_/Q VPWR VGND sg13cmos5l_inv_1
XFILLER_26_757 VPWR VGND sg13cmos5l_decap_8
XFILLER_14_919 VPWR VGND sg13cmos5l_fill_2
XFILLER_25_245 VPWR VGND sg13cmos5l_fill_2
XFILLER_41_749 VPWR VGND sg13cmos5l_decap_4
XFILLER_13_418 VPWR VGND sg13cmos5l_decap_8
XFILLER_4_105 VPWR VGND sg13cmos5l_decap_8
XFILLER_1_845 VPWR VGND sg13cmos5l_decap_8
XFILLER_49_827 VPWR VGND sg13cmos5l_decap_8
XFILLER_0_388 VPWR VGND sg13cmos5l_decap_8
XFILLER_17_702 VPWR VGND sg13cmos5l_decap_8
XFILLER_29_551 VPWR VGND sg13cmos5l_decap_4
XFILLER_1_1027 VPWR VGND sg13cmos5l_fill_2
XFILLER_44_565 VPWR VGND sg13cmos5l_decap_8
XFILLER_17_93 VPWR VGND sg13cmos5l_decap_4
XFILLER_31_226 VPWR VGND sg13cmos5l_fill_2
XFILLER_9_923 VPWR VGND sg13cmos5l_decap_8
XFILLER_13_974 VPWR VGND sg13cmos5l_decap_8
XFILLER_40_793 VPWR VGND sg13cmos5l_decap_8
X_4007__368 _4007_/RESET_B VPWR VGND sg13cmos5l_tiehi
X_3230_ _3230_/Y _3230_/A _3229_/Y VPWR VGND sg13cmos5l_nor2b_1
X_3161_ _3163_/B _3148_/Y _3388_/A _3159_/Y VPWR VGND sg13cmos5l_a21oi_1
X_3092_ _3093_/B _3092_/A _3092_/B VPWR VGND sg13cmos5l_xnor2_1
XFILLER_23_738 VPWR VGND sg13cmos5l_decap_8
X_3994_ _3994_/Q clkload4/A _3994_/D _3994_/RESET_B VPWR VGND sg13cmos5l_dfrbpq_1
X_2945_ _2951_/A _2949_/A _2945_/B VPWR VGND sg13cmos5l_nand2b_1
XFILLER_13_29 VPWR VGND sg13cmos5l_fill_2
X_2876_ _2877_/B _2751_/Y _2868_/B _2875_/Y VPWR VGND sg13cmos5l_o21ai_1
X_3428_ _3428_/Y _3442_/B _3428_/B _3428_/C VPWR VGND sg13cmos5l_nor3_1
X_3359_ _4275_/D _3442_/B _3359_/B VPWR VGND sg13cmos5l_nor2_1
XFILLER_38_59 VPWR VGND sg13cmos5l_fill_2
XFILLER_41_546 VPWR VGND sg13cmos5l_fill_1
XFILLER_16_1013 VPWR VGND sg13cmos5l_decap_8
XFILLER_10_955 VPWR VGND sg13cmos5l_decap_8
XFILLER_6_937 VPWR VGND sg13cmos5l_decap_8
XFILLER_5_447 VPWR VGND sg13cmos5l_decap_8
XFILLER_5_414 VPWR VGND sg13cmos5l_fill_2
X_4106__278 _4106_/RESET_B VPWR VGND sg13cmos5l_tiehi
XFILLER_0_130 VPWR VGND sg13cmos5l_decap_8
XFILLER_49_646 VPWR VGND sg13cmos5l_decap_8
XFILLER_45_896 VPWR VGND sg13cmos5l_decap_8
XFILLER_13_760 VPWR VGND sg13cmos5l_decap_8
X_2730_ _2741_/B _2765_/B _4181_/Q VPWR VGND sg13cmos5l_nor2_1
XFILLER_12_281 VPWR VGND sg13cmos5l_fill_2
XFILLER_8_263 VPWR VGND sg13cmos5l_decap_4
X_2661_ _2661_/Y _2441_/B _2660_/Y _4138_/Q VPWR VGND sg13cmos5l_a21oi_1
XFILLER_8_274 VPWR VGND sg13cmos5l_fill_1
X_2592_ _2592_/Y _2607_/A _2583_/Y _2591_/Y VPWR VGND sg13cmos5l_o21ai_1
XFILLER_5_41 VPWR VGND sg13cmos5l_decap_4
X_4331_ _4331_/Q _4333_/CLK _4331_/D _4331_/RESET_B VPWR VGND sg13cmos5l_dfrbpq_1
X_4262_ _4262_/Q _4262_/CLK _4262_/D _4262_/RESET_B VPWR VGND sg13cmos5l_dfrbpq_1
X_3213_ _3213_/Y _4223_/Q _4271_/Q VPWR VGND sg13cmos5l_nand2b_1
X_4193_ _4193_/Q _4262_/CLK _4193_/D _4193_/RESET_B VPWR VGND sg13cmos5l_dfrbpq_1
XFILLER_39_156 VPWR VGND sg13cmos5l_fill_1
X_3144_ _3169_/B _3144_/A _3144_/B VPWR VGND sg13cmos5l_xor2_1
X_3075_ _4231_/D _3254_/A _3087_/B VPWR VGND sg13cmos5l_and2_1
XFILLER_36_841 VPWR VGND sg13cmos5l_decap_8
XFILLER_35_362 VPWR VGND sg13cmos5l_fill_2
XFILLER_24_17 VPWR VGND sg13cmos5l_fill_2
XFILLER_24_39 VPWR VGND sg13cmos5l_decap_4
X_3977_ _3977_/Q _4181_/CLK _3977_/D _3977_/RESET_B VPWR VGND sg13cmos5l_dfrbpq_1
X_4348__151 _4348_/D VPWR VGND sg13cmos5l_tielo
XFILLER_10_207 VPWR VGND sg13cmos5l_fill_1
XFILLER_11_708 VPWR VGND sg13cmos5l_decap_8
X_2928_ _2928_/Y _4197_/Q _4174_/Q VPWR VGND sg13cmos5l_xnor2_1
XFILLER_31_590 VPWR VGND sg13cmos5l_fill_1
X_2859_ _2866_/C _4161_/Q _4162_/Q _2859_/B1 VPWR VGND sg13cmos5l_o21ai_1
XFILLER_3_929 VPWR VGND sg13cmos5l_decap_8
XFILLER_46_1006 VPWR VGND sg13cmos5l_decap_8
XFILLER_2_428 VPWR VGND sg13cmos5l_decap_8
XFILLER_2_439 VPWR VGND sg13cmos5l_decap_4
XFILLER_49_25 VPWR VGND sg13cmos5l_decap_8
XFILLER_46_638 VPWR VGND sg13cmos5l_fill_1
XFILLER_18_329 VPWR VGND sg13cmos5l_fill_1
XFILLER_26_340 VPWR VGND sg13cmos5l_decap_4
XFILLER_27_885 VPWR VGND sg13cmos5l_decap_8
XFILLER_41_354 VPWR VGND sg13cmos5l_fill_1
XFILLER_10_741 VPWR VGND sg13cmos5l_decap_4
XFILLER_10_752 VPWR VGND sg13cmos5l_fill_1
XFILLER_14_83 VPWR VGND sg13cmos5l_fill_2
XFILLER_10_796 VPWR VGND sg13cmos5l_decap_8
XFILLER_5_255 VPWR VGND sg13cmos5l_fill_2
XFILLER_6_789 VPWR VGND sg13cmos5l_decap_4
XFILLER_2_995 VPWR VGND sg13cmos5l_decap_8
XFILLER_1_472 VPWR VGND sg13cmos5l_fill_2
XFILLER_49_454 VPWR VGND sg13cmos5l_fill_2
XFILLER_49_498 VPWR VGND sg13cmos5l_decap_8
Xinput9 input9/X uio_in[3] VPWR VGND sg13cmos5l_buf_1
XFILLER_36_159 VPWR VGND sg13cmos5l_decap_8
XFILLER_44_192 VPWR VGND sg13cmos5l_decap_8
XFILLER_44_181 VPWR VGND sg13cmos5l_decap_8
XFILLER_17_395 VPWR VGND sg13cmos5l_fill_1
X_3900_ _3903_/B _3900_/A _2289_/B VPWR VGND sg13cmos5l_nor2b_1
XFILLER_33_844 VPWR VGND sg13cmos5l_decap_8
X_3831_ _3831_/Y _3723_/X _3845_/A _3848_/A _3719_/X VPWR VGND sg13cmos5l_a22oi_1
XFILLER_20_505 VPWR VGND sg13cmos5l_decap_8
XFILLER_33_866 VPWR VGND sg13cmos5l_decap_8
X_3762_ _3764_/A _4346_/Q _3759_/B _3761_/Y _4347_/Q _3760_/Y VPWR VGND sg13cmos5l_a221oi_1
X_3693_ _3693_/Y _3748_/B _3693_/B VPWR VGND sg13cmos5l_nor2_1
XFILLER_9_572 VPWR VGND sg13cmos5l_fill_1
X_2713_ _2722_/B _2679_/A _2712_/Y _2679_/Y VPWR VGND sg13cmos5l_o21ai_1
X_2644_ _2723_/B _2592_/Y _2610_/Y _2626_/Y _2643_/Y VPWR VGND sg13cmos5l_a22oi_1
X_2575_ _2575_/X _2576_/A _2576_/B VPWR VGND sg13cmos5l_and2_1
X_4314_ _4314_/Q clkload5/A _4314_/D _4314_/RESET_B VPWR VGND sg13cmos5l_dfrbpq_1
X_4245_ _4245_/Q _4303_/CLK _4245_/D _4245_/RESET_B VPWR VGND sg13cmos5l_dfrbpq_1
X_4176_ _4176_/Q _4181_/CLK _4176_/D _4176_/RESET_B VPWR VGND sg13cmos5l_dfrbpq_1
X_3127_ _3144_/B _4243_/Q _4241_/Q _4242_/Q VPWR VGND sg13cmos5l_or3_1
X_4016__209 _4016_/RESET_B VPWR VGND sg13cmos5l_tiehi
XFILLER_27_148 VPWR VGND sg13cmos5l_decap_8
XFILLER_35_16 VPWR VGND sg13cmos5l_decap_4
XFILLER_43_619 VPWR VGND sg13cmos5l_fill_1
X_3058_ _3058_/Y _3042_/Y _3059_/B _3057_/Y VPWR VGND sg13cmos5l_a21oi_1
XFILLER_23_310 VPWR VGND sg13cmos5l_fill_1
XFILLER_11_549 VPWR VGND sg13cmos5l_decap_4
XFILLER_13_1016 VPWR VGND sg13cmos5l_decap_8
XFILLER_13_1027 VPWR VGND sg13cmos5l_fill_2
X_4374__542 _4374_/RESET_B VPWR VGND sg13cmos5l_tiehi
XFILLER_47_947 VPWR VGND sg13cmos5l_decap_8
XFILLER_19_638 VPWR VGND sg13cmos5l_decap_4
XFILLER_15_822 VPWR VGND sg13cmos5l_decap_8
XFILLER_25_60 VPWR VGND sg13cmos5l_fill_1
XFILLER_25_71 VPWR VGND sg13cmos5l_fill_2
X_4299__429 _4299_/RESET_B VPWR VGND sg13cmos5l_tiehi
X_2360_ _3963_/B _4127_/Q _3937_/A VPWR VGND sg13cmos5l_and2_1
X_2291_ _2291_/Y _2535_/A _2289_/B VPWR VGND sg13cmos5l_nor2b_1
X_4030_ _4030_/Q clkload9/A _4030_/D _4030_/RESET_B VPWR VGND sg13cmos5l_dfrbpq_1
XFILLER_38_958 VPWR VGND sg13cmos5l_decap_8
XFILLER_18_660 VPWR VGND sg13cmos5l_decap_4
XFILLER_33_630 VPWR VGND sg13cmos5l_fill_1
XFILLER_21_803 VPWR VGND sg13cmos5l_decap_4
XFILLER_21_847 VPWR VGND sg13cmos5l_fill_1
X_3814_ _3814_/Y _3782_/A _4310_/Q _4311_/Q VPWR VGND sg13cmos5l_o21ai_1
X_3745_ _3745_/Y _3745_/A _3745_/B _3757_/B VPWR VGND sg13cmos5l_nor3_1
XFILLER_21_18 VPWR VGND sg13cmos5l_decap_8
X_3676_ _4332_/D _3634_/X _3680_/A _3675_/Y VPWR VGND sg13cmos5l_a21oi_1
X_2627_ _2627_/Y _2629_/A _4106_/Q VPWR VGND sg13cmos5l_nand2b_1
X_2558_ _2757_/A _2804_/A _2804_/B VPWR VGND sg13cmos5l_nand2_1
XFILLER_0_718 VPWR VGND sg13cmos5l_fill_1
X_2489_ _2489_/Y _2481_/A _2488_/Y _2487_/Y VPWR VGND sg13cmos5l_a21oi_1
X_4228_ _4228_/Q _4234_/CLK _4228_/D _4228_/RESET_B VPWR VGND sg13cmos5l_dfrbpq_1
XFILLER_29_947 VPWR VGND sg13cmos5l_decap_8
X_4159_ _4159_/Q _4161_/CLK _4159_/D _4159_/RESET_B VPWR VGND sg13cmos5l_dfrbpq_1
XFILLER_44_939 VPWR VGND sg13cmos5l_decap_8
XFILLER_28_468 VPWR VGND sg13cmos5l_decap_4
XFILLER_43_438 VPWR VGND sg13cmos5l_decap_8
XFILLER_24_641 VPWR VGND sg13cmos5l_decap_8
XFILLER_12_836 VPWR VGND sg13cmos5l_decap_8
XFILLER_7_306 VPWR VGND sg13cmos5l_fill_1
XFILLER_12_869 VPWR VGND sg13cmos5l_decap_8
XFILLER_7_317 VPWR VGND sg13cmos5l_decap_8
XFILLER_19_435 VPWR VGND sg13cmos5l_decap_8
XFILLER_35_917 VPWR VGND sg13cmos5l_fill_2
XFILLER_43_961 VPWR VGND sg13cmos5l_decap_8
X_3990__474 _3990_/RESET_B VPWR VGND sg13cmos5l_tiehi
XFILLER_42_482 VPWR VGND sg13cmos5l_decap_4
XFILLER_30_633 VPWR VGND sg13cmos5l_decap_8
Xinput12 input12/X uio_in[6] VPWR VGND sg13cmos5l_buf_1
XFILLER_30_666 VPWR VGND sg13cmos5l_decap_8
X_3530_ _3531_/B _3515_/B _3529_/Y _3536_/C VPWR VGND sg13cmos5l_mux2_1
Xhold818 hold818/X _4105_/Q VPWR VGND sg13cmos5l_dlygate4sd3_1
Xhold807 hold807/X _3975_/Q VPWR VGND sg13cmos5l_dlygate4sd3_1
XFILLER_6_394 VPWR VGND sg13cmos5l_fill_2
Xhold829 hold829/X _4123_/Q VPWR VGND sg13cmos5l_dlygate4sd3_1
X_3461_ _3480_/A _4295_/Q _3477_/B VPWR VGND sg13cmos5l_nand2_1
X_3392_ _3483_/A _3164_/X _3388_/B _3391_/Y VPWR VGND sg13cmos5l_a21o_1
X_2412_ _4085_/D _3950_/A0 hold672/X _2420_/S VPWR VGND sg13cmos5l_mux2_1
X_2343_ _4027_/D _3951_/A0 hold744/X _2349_/S VPWR VGND sg13cmos5l_mux2_1
X_2274_ _2888_/B _2274_/A VPWR VGND sg13cmos5l_inv_1
X_4013_ _4013_/Q _4181_/CLK _4013_/D _4013_/RESET_B VPWR VGND sg13cmos5l_dfrbpq_1
XFILLER_38_711 VPWR VGND sg13cmos5l_decap_8
XFILLER_37_210 VPWR VGND sg13cmos5l_fill_2
XFILLER_38_799 VPWR VGND sg13cmos5l_decap_8
XFILLER_37_243 VPWR VGND sg13cmos5l_decap_8
XFILLER_26_928 VPWR VGND sg13cmos5l_fill_1
XFILLER_26_939 VPWR VGND sg13cmos5l_decap_8
XFILLER_16_18 VPWR VGND sg13cmos5l_fill_1
XFILLER_25_438 VPWR VGND sg13cmos5l_decap_4
XFILLER_40_408 VPWR VGND sg13cmos5l_fill_1
Xclkbuf_leaf_17_clk _4323_/CLK clkbuf_leaf_3_clk/A VPWR VGND sg13cmos5l_buf_8
XFILLER_34_972 VPWR VGND sg13cmos5l_fill_2
XFILLER_33_460 VPWR VGND sg13cmos5l_decap_8
XFILLER_20_132 VPWR VGND sg13cmos5l_decap_8
X_3728_ _3729_/B _3731_/S _3726_/Y _3727_/Y VPWR VGND sg13cmos5l_a21o_1
X_3659_ _3659_/Y _3634_/A _3634_/B _3658_/Y VPWR VGND sg13cmos5l_a21oi_1
XFILLER_44_714 VPWR VGND sg13cmos5l_decap_8
XFILLER_28_243 VPWR VGND sg13cmos5l_decap_8
XFILLER_19_1000 VPWR VGND sg13cmos5l_decap_8
XFILLER_25_961 VPWR VGND sg13cmos5l_fill_2
XFILLER_31_408 VPWR VGND sg13cmos5l_fill_1
XFILLER_40_931 VPWR VGND sg13cmos5l_decap_8
XFILLER_12_600 VPWR VGND sg13cmos5l_decap_8
XFILLER_24_471 VPWR VGND sg13cmos5l_decap_4
XFILLER_11_110 VPWR VGND sg13cmos5l_decap_8
XFILLER_12_644 VPWR VGND sg13cmos5l_fill_2
XFILLER_11_143 VPWR VGND sg13cmos5l_decap_4
XFILLER_12_666 VPWR VGND sg13cmos5l_decap_8
XFILLER_7_147 VPWR VGND sg13cmos5l_fill_1
XFILLER_4_832 VPWR VGND sg13cmos5l_decap_8
XFILLER_3_320 VPWR VGND sg13cmos5l_decap_8
XFILLER_3_353 VPWR VGND sg13cmos5l_decap_8
XFILLER_3_375 VPWR VGND sg13cmos5l_fill_2
XFILLER_26_1004 VPWR VGND sg13cmos5l_decap_8
XFILLER_47_563 VPWR VGND sg13cmos5l_fill_1
XFILLER_47_80 VPWR VGND sg13cmos5l_decap_4
XFILLER_19_243 VPWR VGND sg13cmos5l_decap_8
XFILLER_35_736 VPWR VGND sg13cmos5l_decap_4
XFILLER_22_408 VPWR VGND sg13cmos5l_fill_2
X_2961_ _2962_/B _2940_/A _2953_/A _2941_/X VPWR VGND sg13cmos5l_o21ai_1
XFILLER_31_920 VPWR VGND sg13cmos5l_decap_8
XFILLER_34_268 VPWR VGND sg13cmos5l_decap_4
XFILLER_15_493 VPWR VGND sg13cmos5l_decap_8
XFILLER_31_964 VPWR VGND sg13cmos5l_decap_8
X_2892_ _2892_/Y _4192_/Q _2892_/B VPWR VGND sg13cmos5l_nor2_1
Xhold615 _2788_/A _4155_/Q VPWR VGND sg13cmos5l_dlygate4sd3_1
X_3513_ _3513_/X _3523_/B _3519_/C _3834_/A VPWR VGND sg13cmos5l_a21o_1
Xhold626 _2306_/A _4366_/Q VPWR VGND sg13cmos5l_dlygate4sd3_1
Xhold604 _2270_/A _4005_/Q VPWR VGND sg13cmos5l_dlygate4sd3_1
Xclkbuf_leaf_6_clk _4128_/CLK clkload0/A VPWR VGND sg13cmos5l_buf_8
Xhold648 hold648/X _4135_/Q VPWR VGND sg13cmos5l_dlygate4sd3_1
Xhold637 _4125_/D _3973_/Y VPWR VGND sg13cmos5l_dlygate4sd3_1
X_3444_ _4298_/D _3444_/A _3444_/B VPWR VGND sg13cmos5l_and2_1
Xhold659 _4170_/D _2780_/Y VPWR VGND sg13cmos5l_dlygate4sd3_1
X_3375_ _3376_/C _3442_/A _3375_/B VPWR VGND sg13cmos5l_nand2_1
X_2326_ _3963_/A _2500_/B _4129_/Q VPWR VGND sg13cmos5l_nor2b_1
X_4353__253 _4353_/RESET_B VPWR VGND sg13cmos5l_tiehi
X_2257_ _3443_/A _3222_/A VPWR VGND sg13cmos5l_inv_1
XFILLER_38_574 VPWR VGND sg13cmos5l_fill_2
XFILLER_38_541 VPWR VGND sg13cmos5l_decap_8
XFILLER_26_714 VPWR VGND sg13cmos5l_fill_2
XFILLER_25_224 VPWR VGND sg13cmos5l_decap_8
XFILLER_41_706 VPWR VGND sg13cmos5l_fill_1
XFILLER_40_238 VPWR VGND sg13cmos5l_fill_1
XFILLER_22_931 VPWR VGND sg13cmos5l_decap_4
XFILLER_22_986 VPWR VGND sg13cmos5l_fill_1
XFILLER_21_474 VPWR VGND sg13cmos5l_fill_2
XFILLER_4_128 VPWR VGND sg13cmos5l_fill_1
XFILLER_1_824 VPWR VGND sg13cmos5l_decap_8
XFILLER_49_806 VPWR VGND sg13cmos5l_decap_8
XFILLER_0_323 VPWR VGND sg13cmos5l_decap_4
XFILLER_0_345 VPWR VGND sg13cmos5l_fill_2
XFILLER_0_356 VPWR VGND sg13cmos5l_decap_8
XFILLER_1_1006 VPWR VGND sg13cmos5l_decap_8
XFILLER_44_500 VPWR VGND sg13cmos5l_decap_8
XFILLER_16_246 VPWR VGND sg13cmos5l_fill_2
XFILLER_44_588 VPWR VGND sg13cmos5l_decap_8
XFILLER_9_902 VPWR VGND sg13cmos5l_decap_8
XFILLER_13_953 VPWR VGND sg13cmos5l_decap_8
X_4228__507 _4228_/RESET_B VPWR VGND sg13cmos5l_tiehi
XFILLER_40_772 VPWR VGND sg13cmos5l_decap_8
XFILLER_9_979 VPWR VGND sg13cmos5l_decap_8
XFILLER_33_71 VPWR VGND sg13cmos5l_fill_2
XFILLER_33_82 VPWR VGND sg13cmos5l_decap_8
X_3160_ _3388_/A _3442_/A _3168_/A VPWR VGND sg13cmos5l_and2_1
X_3091_ _3115_/B _3115_/A _3090_/X _3084_/Y VPWR VGND sg13cmos5l_o21ai_1
XFILLER_12_4 VPWR VGND sg13cmos5l_decap_8
XFILLER_48_894 VPWR VGND sg13cmos5l_decap_8
XFILLER_35_577 VPWR VGND sg13cmos5l_decap_8
X_3993_ _3993_/Q clkload9/A _3993_/D _3993_/RESET_B VPWR VGND sg13cmos5l_dfrbpq_1
XFILLER_22_227 VPWR VGND sg13cmos5l_fill_2
XFILLER_31_750 VPWR VGND sg13cmos5l_decap_8
X_2944_ _2944_/X _2944_/A _2944_/B VPWR VGND sg13cmos5l_xor2_1
X_2875_ _2875_/Y _2868_/B _2869_/Y _2874_/Y VPWR VGND sg13cmos5l_o21ai_1
XFILLER_8_990 VPWR VGND sg13cmos5l_decap_8
X_3427_ _3428_/C _3427_/A _3426_/B VPWR VGND sg13cmos5l_nor2b_1
X_3358_ _3359_/B _3349_/S _3356_/X _3357_/Y VPWR VGND sg13cmos5l_o21ai_1
XFILLER_38_38 VPWR VGND sg13cmos5l_decap_8
X_2309_ _2309_/Y _3882_/B _2526_/A _3907_/A VPWR VGND sg13cmos5l_a21oi_1
X_3289_ _3290_/B _4263_/Q _3296_/B _3274_/Y VPWR VGND sg13cmos5l_a21oi_1
XFILLER_26_577 VPWR VGND sg13cmos5l_fill_2
XFILLER_22_750 VPWR VGND sg13cmos5l_decap_8
XFILLER_10_934 VPWR VGND sg13cmos5l_decap_8
Xhold990 _3725_/B _3723_/X VPWR VGND sg13cmos5l_dlygate4sd3_1
XFILLER_49_625 VPWR VGND sg13cmos5l_fill_2
XFILLER_0_153 VPWR VGND sg13cmos5l_fill_1
XFILLER_48_124 VPWR VGND sg13cmos5l_decap_8
XFILLER_23_1018 VPWR VGND sg13cmos5l_decap_8
X_4193__558 _4193_/RESET_B VPWR VGND sg13cmos5l_tiehi
XFILLER_49_669 VPWR VGND sg13cmos5l_decap_8
X_4234__500 _4234_/RESET_B VPWR VGND sg13cmos5l_tiehi
XFILLER_48_179 VPWR VGND sg13cmos5l_decap_8
X_4152__200 _4152_/RESET_B VPWR VGND sg13cmos5l_tiehi
XFILLER_45_875 VPWR VGND sg13cmos5l_decap_8
XFILLER_44_352 VPWR VGND sg13cmos5l_fill_2
X_4367__219 _4367_/RESET_B VPWR VGND sg13cmos5l_tiehi
XFILLER_44_70 VPWR VGND sg13cmos5l_decap_4
X_2660_ _2660_/Y _2656_/Y _2657_/Y _2659_/Y VPWR VGND sg13cmos5l_o21ai_1
X_2591_ _2591_/Y _2607_/A _2590_/Y _4138_/Q VPWR VGND sg13cmos5l_a21oi_1
XFILLER_5_982 VPWR VGND sg13cmos5l_decap_8
X_4330_ _4330_/Q _4333_/CLK _4330_/D _4330_/RESET_B VPWR VGND sg13cmos5l_dfrbpq_1
XFILLER_5_97 VPWR VGND sg13cmos5l_fill_2
X_4261_ _4261_/Q _4323_/CLK _4261_/D _4261_/RESET_B VPWR VGND sg13cmos5l_dfrbpq_1
X_3212_ _3212_/Y _3443_/A _4222_/Q _4221_/Q _3442_/A _3211_/Y VPWR VGND sg13cmos5l_a221oi_1
X_4192_ _4192_/Q _4262_/CLK _4192_/D _4192_/RESET_B VPWR VGND sg13cmos5l_dfrbpq_1
XFILLER_39_146 VPWR VGND sg13cmos5l_decap_4
X_3143_ _3380_/A _3131_/B _3143_/B VPWR VGND sg13cmos5l_nand2b_1
X_3074_ _4230_/D _3254_/A _3074_/B VPWR VGND sg13cmos5l_and2_1
XFILLER_48_691 VPWR VGND sg13cmos5l_fill_2
XFILLER_47_190 VPWR VGND sg13cmos5l_decap_4
X_3976_ _3976_/Q clkload9/A _3976_/D _3976_/RESET_B VPWR VGND sg13cmos5l_dfrbpq_1
XFILLER_23_569 VPWR VGND sg13cmos5l_fill_2
X_2927_ _2927_/Y _4196_/Q _4173_/Q VPWR VGND sg13cmos5l_xnor2_1
X_2858_ _2866_/B _4161_/Q _4162_/Q _4163_/Q VPWR VGND sg13cmos5l_or3_1
XFILLER_3_908 VPWR VGND sg13cmos5l_decap_8
X_2789_ _2789_/X _2789_/A _2789_/B VPWR VGND sg13cmos5l_and2_1
XFILLER_42_856 VPWR VGND sg13cmos5l_decap_8
XFILLER_41_322 VPWR VGND sg13cmos5l_decap_4
XFILLER_14_547 VPWR VGND sg13cmos5l_decap_8
XFILLER_26_385 VPWR VGND sg13cmos5l_fill_1
X_4112__272 _4112_/RESET_B VPWR VGND sg13cmos5l_tiehi
XFILLER_14_558 VPWR VGND sg13cmos5l_fill_1
XFILLER_6_724 VPWR VGND sg13cmos5l_fill_1
XFILLER_6_757 VPWR VGND sg13cmos5l_decap_4
XFILLER_30_61 VPWR VGND sg13cmos5l_decap_8
XFILLER_2_974 VPWR VGND sg13cmos5l_decap_8
XFILLER_49_411 VPWR VGND sg13cmos5l_decap_8
XFILLER_7_1012 VPWR VGND sg13cmos5l_decap_8
XFILLER_39_81 VPWR VGND sg13cmos5l_decap_8
XFILLER_37_639 VPWR VGND sg13cmos5l_decap_8
XFILLER_18_820 VPWR VGND sg13cmos5l_decap_8
XFILLER_18_875 VPWR VGND sg13cmos5l_decap_4
XFILLER_45_683 VPWR VGND sg13cmos5l_fill_1
X_3830_ _3848_/A _4332_/Q _3829_/Y _3834_/B VPWR VGND sg13cmos5l_mux2_1
XFILLER_32_333 VPWR VGND sg13cmos5l_fill_2
X_3761_ _3761_/Y _4363_/Q _3761_/B VPWR VGND sg13cmos5l_nand2b_1
XFILLER_20_539 VPWR VGND sg13cmos5l_decap_8
X_2712_ _2712_/Y _2711_/Y _2712_/B VPWR VGND sg13cmos5l_nand2b_1
XFILLER_9_551 VPWR VGND sg13cmos5l_decap_8
X_3692_ _3692_/Y _3748_/B _3693_/B VPWR VGND sg13cmos5l_nand2_1
X_2643_ _2643_/Y _2643_/A _2643_/B VPWR VGND sg13cmos5l_nor2_1
X_2574_ _4147_/D _3916_/A _2574_/B VPWR VGND sg13cmos5l_nor2_1
X_4313_ _4313_/Q _4353_/CLK _4313_/D _4313_/RESET_B VPWR VGND sg13cmos5l_dfrbpq_1
X_4244_ _4244_/Q _4303_/CLK _4244_/D _4244_/RESET_B VPWR VGND sg13cmos5l_dfrbpq_1
XFILLER_19_29 VPWR VGND sg13cmos5l_decap_8
X_4175_ _4175_/Q _4234_/CLK _4175_/D _4175_/RESET_B VPWR VGND sg13cmos5l_dfrbpq_1
X_3126_ _4239_/D _3112_/A hold928/X _3029_/A VPWR VGND sg13cmos5l_a21oi_1
XFILLER_27_127 VPWR VGND sg13cmos5l_decap_8
X_3057_ _3057_/Y _2285_/A _3059_/B _3123_/A VPWR VGND sg13cmos5l_o21ai_1
XFILLER_23_322 VPWR VGND sg13cmos5l_decap_8
XFILLER_24_878 VPWR VGND sg13cmos5l_fill_2
XFILLER_24_889 VPWR VGND sg13cmos5l_decap_4
XFILLER_11_539 VPWR VGND sg13cmos5l_decap_4
XFILLER_23_388 VPWR VGND sg13cmos5l_fill_2
X_3959_ _4005_/D _2270_/Y _3960_/S _3958_/Y VPWR VGND sg13cmos5l_a21oi_1
XFILLER_47_926 VPWR VGND sg13cmos5l_decap_8
X_4231__503 _4231_/RESET_B VPWR VGND sg13cmos5l_tiehi
XFILLER_15_801 VPWR VGND sg13cmos5l_decap_8
XFILLER_26_160 VPWR VGND sg13cmos5l_decap_8
XFILLER_41_130 VPWR VGND sg13cmos5l_decap_4
XFILLER_15_878 VPWR VGND sg13cmos5l_decap_8
XFILLER_42_675 VPWR VGND sg13cmos5l_decap_8
XFILLER_30_826 VPWR VGND sg13cmos5l_decap_4
XFILLER_41_93 VPWR VGND sg13cmos5l_decap_4
XFILLER_29_1024 VPWR VGND sg13cmos5l_decap_4
X_2290_ _4378_/D _4374_/D _4371_/D VPWR VGND sg13cmos5l_or2_1
XFILLER_49_241 VPWR VGND sg13cmos5l_decap_8
XFILLER_38_904 VPWR VGND sg13cmos5l_decap_8
XFILLER_49_252 VPWR VGND sg13cmos5l_fill_2
XFILLER_49_285 VPWR VGND sg13cmos5l_fill_2
XFILLER_25_609 VPWR VGND sg13cmos5l_decap_8
XFILLER_46_992 VPWR VGND sg13cmos5l_decap_8
XFILLER_24_119 VPWR VGND sg13cmos5l_fill_2
XFILLER_36_1017 VPWR VGND sg13cmos5l_decap_8
XFILLER_32_130 VPWR VGND sg13cmos5l_decap_8
XFILLER_33_642 VPWR VGND sg13cmos5l_decap_8
XFILLER_36_1028 VPWR VGND sg13cmos5l_fill_1
X_3813_ _3813_/X _4334_/Q _3813_/B _3813_/C VPWR VGND sg13cmos5l_and3_1
X_3744_ _3757_/B _4363_/Q _3743_/Y _3742_/Y VPWR VGND sg13cmos5l_o21ai_1
X_3675_ _3675_/Y hold982/X _3680_/A _3620_/B VPWR VGND sg13cmos5l_o21ai_1
XFILLER_9_381 VPWR VGND sg13cmos5l_decap_8
X_2626_ _2626_/Y _2441_/B _2617_/Y _2625_/Y VPWR VGND sg13cmos5l_o21ai_1
X_2557_ _2557_/Y _2789_/A _2804_/A VPWR VGND sg13cmos5l_nor2b_1
X_2488_ _2488_/Y _2488_/A _2488_/B VPWR VGND sg13cmos5l_nand2_1
X_4102__282 _4102_/RESET_B VPWR VGND sg13cmos5l_tiehi
X_4227_ _4227_/Q _4262_/CLK _4227_/D _4227_/RESET_B VPWR VGND sg13cmos5l_dfrbpq_1
X_4158_ _4158_/Q _4161_/CLK _4158_/D _4158_/RESET_B VPWR VGND sg13cmos5l_dfrbpq_1
XFILLER_28_425 VPWR VGND sg13cmos5l_decap_4
XFILLER_44_918 VPWR VGND sg13cmos5l_decap_8
X_3109_ _3109_/Y _3111_/B _3111_/C _3111_/A VPWR VGND sg13cmos5l_a21oi_1
X_4089_ _4089_/Q clkload3/A _4089_/D _4089_/RESET_B VPWR VGND sg13cmos5l_dfrbpq_1
XFILLER_15_119 VPWR VGND sg13cmos5l_fill_2
XFILLER_24_620 VPWR VGND sg13cmos5l_fill_1
X_4363__233 _4363_/RESET_B VPWR VGND sg13cmos5l_tiehi
XFILLER_11_52 VPWR VGND sg13cmos5l_fill_2
X_4298__430 _4298_/RESET_B VPWR VGND sg13cmos5l_tiehi
XFILLER_47_712 VPWR VGND sg13cmos5l_fill_2
XFILLER_47_734 VPWR VGND sg13cmos5l_decap_8
XFILLER_4_1026 VPWR VGND sg13cmos5l_fill_2
XFILLER_28_981 VPWR VGND sg13cmos5l_decap_8
XFILLER_34_439 VPWR VGND sg13cmos5l_fill_2
XFILLER_36_71 VPWR VGND sg13cmos5l_decap_8
XFILLER_43_940 VPWR VGND sg13cmos5l_decap_8
XFILLER_14_130 VPWR VGND sg13cmos5l_decap_8
XFILLER_42_472 VPWR VGND sg13cmos5l_decap_4
XFILLER_14_152 VPWR VGND sg13cmos5l_decap_8
XFILLER_15_675 VPWR VGND sg13cmos5l_decap_8
XFILLER_15_686 VPWR VGND sg13cmos5l_decap_8
XFILLER_15_697 VPWR VGND sg13cmos5l_fill_1
X_4149__205 _4149_/RESET_B VPWR VGND sg13cmos5l_tiehi
Xinput13 input13/X uio_in[7] VPWR VGND sg13cmos5l_buf_1
XFILLER_7_830 VPWR VGND sg13cmos5l_decap_8
XFILLER_7_874 VPWR VGND sg13cmos5l_decap_4
Xhold819 _2217_/A _4345_/Q VPWR VGND sg13cmos5l_dlygate4sd3_1
Xhold808 hold808/X _4015_/Q VPWR VGND sg13cmos5l_dlygate4sd3_1
X_3460_ _3460_/Y _3460_/A _3477_/B VPWR VGND sg13cmos5l_nand2_1
XFILLER_42_4 VPWR VGND sg13cmos5l_decap_4
X_3391_ _3391_/Y _3377_/B _3371_/C _3388_/B _3168_/A _3369_/X VPWR VGND sg13cmos5l_a221oi_1
X_2411_ _2419_/S _2501_/A _2500_/C _2411_/C VPWR VGND sg13cmos5l_nand3_1
X_2342_ _4026_/D _3964_/A0 hold689/X _2349_/S VPWR VGND sg13cmos5l_mux2_1
XFILLER_42_1010 VPWR VGND sg13cmos5l_decap_8
X_2273_ _2890_/B _2273_/A VPWR VGND sg13cmos5l_inv_1
X_4012_ _4012_/Q clkload9/A _4012_/D _4012_/RESET_B VPWR VGND sg13cmos5l_dfrbpq_1
XFILLER_38_778 VPWR VGND sg13cmos5l_decap_8
XFILLER_37_277 VPWR VGND sg13cmos5l_decap_4
XFILLER_19_981 VPWR VGND sg13cmos5l_decap_8
XFILLER_33_472 VPWR VGND sg13cmos5l_decap_4
X_3727_ _3727_/Y _3709_/Y _3713_/Y _3716_/A _3716_/B _3690_/Y VPWR VGND sg13cmos5l_a221oi_1
X_3658_ _3658_/Y _3669_/A _3658_/B VPWR VGND sg13cmos5l_nor2_1
X_2609_ _2610_/C _2675_/A _2604_/X _2608_/Y VPWR VGND sg13cmos5l_a21oi_1
X_3589_ _3589_/Y _3822_/A _3782_/A VPWR VGND sg13cmos5l_nor2_1
XFILLER_0_527 VPWR VGND sg13cmos5l_decap_8
XFILLER_28_222 VPWR VGND sg13cmos5l_decap_8
XFILLER_29_756 VPWR VGND sg13cmos5l_decap_8
XFILLER_16_406 VPWR VGND sg13cmos5l_decap_8
Xclkbuf_2_2__f_clk clkbuf_leaf_3_clk/A clkbuf_0_clk/X VPWR VGND sg13cmos5l_buf_8
XFILLER_44_737 VPWR VGND sg13cmos5l_fill_1
XFILLER_16_428 VPWR VGND sg13cmos5l_fill_2
XFILLER_44_759 VPWR VGND sg13cmos5l_decap_8
XFILLER_40_987 VPWR VGND sg13cmos5l_decap_8
XFILLER_8_649 VPWR VGND sg13cmos5l_decap_8
XFILLER_4_822 VPWR VGND sg13cmos5l_fill_2
XFILLER_4_855 VPWR VGND sg13cmos5l_fill_1
XFILLER_3_332 VPWR VGND sg13cmos5l_fill_2
XFILLER_0_0 VPWR VGND sg13cmos5l_decap_8
XFILLER_47_542 VPWR VGND sg13cmos5l_decap_8
XFILLER_16_951 VPWR VGND sg13cmos5l_fill_2
XFILLER_34_247 VPWR VGND sg13cmos5l_decap_8
X_2960_ _4207_/D _2960_/A _2960_/B _2960_/C VPWR VGND sg13cmos5l_nor3_1
XFILLER_15_472 VPWR VGND sg13cmos5l_fill_1
X_2891_ _2892_/B _2855_/B _2885_/Y _2887_/Y _2890_/Y VPWR VGND sg13cmos5l_a22oi_1
XFILLER_8_20 VPWR VGND sg13cmos5l_decap_4
XFILLER_30_475 VPWR VGND sg13cmos5l_decap_4
XFILLER_30_486 VPWR VGND sg13cmos5l_fill_2
Xhold616 _4177_/D _2788_/X VPWR VGND sg13cmos5l_dlygate4sd3_1
X_3512_ _3519_/C _4306_/Q _4305_/Q _4307_/Q VPWR VGND sg13cmos5l_o21ai_1
Xhold627 _3895_/B _3894_/Y VPWR VGND sg13cmos5l_dlygate4sd3_1
Xhold605 _2262_/A _3994_/Q VPWR VGND sg13cmos5l_dlygate4sd3_1
Xhold649 _2471_/B _2470_/Y VPWR VGND sg13cmos5l_dlygate4sd3_1
Xhold638 _2448_/B _4124_/Q VPWR VGND sg13cmos5l_dlygate4sd3_1
X_3443_ _4297_/D _3443_/A _3502_/A VPWR VGND sg13cmos5l_nor2_1
X_3374_ _3376_/B _3442_/A _3375_/B _3372_/X VPWR VGND sg13cmos5l_o21ai_1
XFILLER_33_0 VPWR VGND sg13cmos5l_decap_8
X_2325_ _3949_/A _2501_/A _2474_/A VPWR VGND sg13cmos5l_and2_1
X_2256_ _3442_/A _2256_/A VPWR VGND sg13cmos5l_inv_1
XFILLER_25_214 VPWR VGND sg13cmos5l_fill_1
XFILLER_26_726 VPWR VGND sg13cmos5l_fill_2
XFILLER_25_247 VPWR VGND sg13cmos5l_fill_1
XFILLER_22_910 VPWR VGND sg13cmos5l_fill_1
XFILLER_22_954 VPWR VGND sg13cmos5l_fill_1
XFILLER_21_453 VPWR VGND sg13cmos5l_decap_8
XFILLER_5_619 VPWR VGND sg13cmos5l_fill_1
XFILLER_49_1016 VPWR VGND sg13cmos5l_decap_8
XFILLER_49_1027 VPWR VGND sg13cmos5l_fill_2
XFILLER_0_302 VPWR VGND sg13cmos5l_decap_8
X_4295__433 _4295_/RESET_B VPWR VGND sg13cmos5l_tiehi
XFILLER_29_575 VPWR VGND sg13cmos5l_decap_4
XFILLER_16_225 VPWR VGND sg13cmos5l_decap_4
XFILLER_17_62 VPWR VGND sg13cmos5l_decap_4
XFILLER_17_759 VPWR VGND sg13cmos5l_fill_1
XFILLER_13_932 VPWR VGND sg13cmos5l_decap_8
XFILLER_31_228 VPWR VGND sg13cmos5l_fill_1
XFILLER_9_958 VPWR VGND sg13cmos5l_decap_8
XFILLER_4_663 VPWR VGND sg13cmos5l_decap_8
XFILLER_4_696 VPWR VGND sg13cmos5l_fill_2
XFILLER_3_173 VPWR VGND sg13cmos5l_decap_4
X_3090_ _3090_/X _4234_/Q _3092_/B _3095_/B VPWR VGND sg13cmos5l_a21o_1
XFILLER_48_873 VPWR VGND sg13cmos5l_decap_8
XFILLER_47_372 VPWR VGND sg13cmos5l_decap_8
XFILLER_47_361 VPWR VGND sg13cmos5l_fill_2
XFILLER_35_501 VPWR VGND sg13cmos5l_decap_8
XFILLER_35_523 VPWR VGND sg13cmos5l_fill_2
XFILLER_35_534 VPWR VGND sg13cmos5l_fill_1
X_3992_ _3992_/Q clkload4/A _3992_/D _3992_/RESET_B VPWR VGND sg13cmos5l_dfrbpq_1
X_2943_ _2944_/B _4202_/Q _2948_/B _2926_/Y VPWR VGND sg13cmos5l_a21oi_1
X_4348__367 _4348_/RESET_B VPWR VGND sg13cmos5l_tiehi
X_2874_ _2874_/Y _2874_/A _2863_/Y VPWR VGND sg13cmos5l_nor2b_1
XFILLER_31_773 VPWR VGND sg13cmos5l_fill_1
XFILLER_31_795 VPWR VGND sg13cmos5l_decap_4
X_3426_ _3428_/B _3426_/A _3426_/B VPWR VGND sg13cmos5l_nor2_1
X_3357_ _3357_/Y _3357_/A _3357_/B _3357_/C _3357_/D VPWR VGND sg13cmos5l_nand4_1
XFILLER_38_28 VPWR VGND sg13cmos5l_fill_1
X_2308_ _2522_/C _2526_/A VPWR VGND sg13cmos5l_inv_1
X_3288_ _3308_/A _3286_/X _3287_/X _3279_/Y VPWR VGND sg13cmos5l_o21ai_1
X_2239_ _3078_/A _2855_/A VPWR VGND sg13cmos5l_inv_1
XFILLER_38_383 VPWR VGND sg13cmos5l_fill_2
XFILLER_41_515 VPWR VGND sg13cmos5l_fill_1
XFILLER_14_718 VPWR VGND sg13cmos5l_fill_1
XFILLER_14_729 VPWR VGND sg13cmos5l_decap_4
XFILLER_41_537 VPWR VGND sg13cmos5l_decap_8
XFILLER_22_740 VPWR VGND sg13cmos5l_fill_1
XFILLER_1_611 VPWR VGND sg13cmos5l_fill_2
Xhold991 _2870_/A _4161_/Q VPWR VGND sg13cmos5l_dlygate4sd3_1
XFILLER_1_633 VPWR VGND sg13cmos5l_decap_8
X_4006__370 _4006_/RESET_B VPWR VGND sg13cmos5l_tiehi
Xhold980 _2237_/A _4237_/Q VPWR VGND sg13cmos5l_dlygate4sd3_1
XFILLER_49_604 VPWR VGND sg13cmos5l_decap_8
XFILLER_0_165 VPWR VGND sg13cmos5l_fill_1
XFILLER_36_309 VPWR VGND sg13cmos5l_fill_1
XFILLER_17_512 VPWR VGND sg13cmos5l_fill_2
XFILLER_45_854 VPWR VGND sg13cmos5l_decap_8
XFILLER_44_331 VPWR VGND sg13cmos5l_fill_1
XFILLER_32_526 VPWR VGND sg13cmos5l_fill_2
XFILLER_8_221 VPWR VGND sg13cmos5l_decap_8
XFILLER_12_250 VPWR VGND sg13cmos5l_decap_8
XFILLER_40_592 VPWR VGND sg13cmos5l_fill_2
XFILLER_8_243 VPWR VGND sg13cmos5l_decap_4
XFILLER_9_755 VPWR VGND sg13cmos5l_decap_4
XFILLER_9_788 VPWR VGND sg13cmos5l_decap_8
XFILLER_9_799 VPWR VGND sg13cmos5l_fill_2
X_2590_ _2590_/Y _2586_/Y _2587_/Y _2589_/Y VPWR VGND sg13cmos5l_o21ai_1
XFILLER_5_961 VPWR VGND sg13cmos5l_decap_8
X_4260_ _4260_/Q _4323_/CLK _4260_/D _4260_/RESET_B VPWR VGND sg13cmos5l_dfrbpq_1
X_3211_ _3211_/Y _4269_/Q _3224_/B _3217_/B _4268_/Q VPWR VGND sg13cmos5l_a22oi_1
X_4191_ _4191_/Q _4262_/CLK _4191_/D _4191_/RESET_B VPWR VGND sg13cmos5l_dfrbpq_1
X_3142_ _3143_/B _4269_/Q _4270_/Q _4271_/Q VPWR VGND sg13cmos5l_o21ai_1
X_3073_ _4229_/D _3607_/A _3073_/B VPWR VGND sg13cmos5l_and2_1
XFILLER_47_180 VPWR VGND sg13cmos5l_fill_1
XFILLER_39_1026 VPWR VGND sg13cmos5l_fill_2
XFILLER_36_876 VPWR VGND sg13cmos5l_fill_1
XFILLER_35_364 VPWR VGND sg13cmos5l_fill_1
X_3975_ _3975_/Q clkload4/A _3975_/D _3975_/RESET_B VPWR VGND sg13cmos5l_dfrbpq_1
X_2926_ _2926_/Y _4198_/Q _4175_/Q VPWR VGND sg13cmos5l_nand2_1
X_2857_ _4185_/D _2918_/B _2857_/B VPWR VGND sg13cmos5l_nor2_1
X_2788_ _2788_/X _2788_/A _2789_/B VPWR VGND sg13cmos5l_and2_1
X_3409_ _3409_/Y _3618_/A _4304_/Q VPWR VGND sg13cmos5l_nor2_1
X_4292__436 _4292_/RESET_B VPWR VGND sg13cmos5l_tiehi
XFILLER_46_629 VPWR VGND sg13cmos5l_decap_8
XFILLER_45_128 VPWR VGND sg13cmos5l_fill_2
XFILLER_27_854 VPWR VGND sg13cmos5l_fill_2
XFILLER_27_865 VPWR VGND sg13cmos5l_decap_8
XFILLER_26_397 VPWR VGND sg13cmos5l_decap_4
XFILLER_6_703 VPWR VGND sg13cmos5l_decap_8
XFILLER_14_85 VPWR VGND sg13cmos5l_fill_1
XFILLER_22_592 VPWR VGND sg13cmos5l_fill_1
XFILLER_6_736 VPWR VGND sg13cmos5l_decap_8
XFILLER_5_257 VPWR VGND sg13cmos5l_fill_1
XFILLER_2_953 VPWR VGND sg13cmos5l_decap_8
XFILLER_1_430 VPWR VGND sg13cmos5l_decap_8
XFILLER_49_401 VPWR VGND sg13cmos5l_decap_4
XFILLER_1_474 VPWR VGND sg13cmos5l_fill_1
XFILLER_49_456 VPWR VGND sg13cmos5l_fill_1
XFILLER_37_629 VPWR VGND sg13cmos5l_decap_4
XFILLER_18_854 VPWR VGND sg13cmos5l_decap_8
XFILLER_18_898 VPWR VGND sg13cmos5l_decap_8
XFILLER_33_835 VPWR VGND sg13cmos5l_fill_1
XFILLER_32_345 VPWR VGND sg13cmos5l_fill_1
X_3760_ _3760_/Y _2217_/Y _3754_/A _3755_/Y _3751_/X _3759_/Y VPWR VGND sg13cmos5l_a221oi_1
X_2711_ _2711_/Y _2700_/Y _2705_/Y _2710_/Y VPWR VGND sg13cmos5l_o21ai_1
XFILLER_41_890 VPWR VGND sg13cmos5l_fill_1
XFILLER_9_541 VPWR VGND sg13cmos5l_fill_1
X_3691_ _3693_/B _4358_/Q _4337_/Q VPWR VGND sg13cmos5l_nand2_1
X_2642_ _2643_/B _2631_/Y _2636_/Y _2679_/A VPWR VGND sg13cmos5l_o21ai_1
X_2573_ _4145_/D _2556_/Y hold862/X _2567_/A VPWR VGND sg13cmos5l_a21oi_1
X_4312_ _4312_/Q _4353_/CLK _4312_/D _4312_/RESET_B VPWR VGND sg13cmos5l_dfrbpq_1
X_4243_ _4243_/Q _4302_/CLK _4243_/D _4243_/RESET_B VPWR VGND sg13cmos5l_dfrbpq_1
XFILLER_19_19 VPWR VGND sg13cmos5l_fill_1
X_4174_ _4174_/Q _4225_/CLK _4174_/D _4174_/RESET_B VPWR VGND sg13cmos5l_dfrbpq_1
XFILLER_27_106 VPWR VGND sg13cmos5l_decap_8
X_3125_ _4238_/D _3115_/X _3122_/S _3124_/Y VPWR VGND sg13cmos5l_a21oi_1
X_3056_ _3059_/B _3055_/Y _3056_/B VPWR VGND sg13cmos5l_nand2b_1
XFILLER_23_301 VPWR VGND sg13cmos5l_fill_1
X_3958_ _3958_/Y _3958_/A _3960_/S VPWR VGND sg13cmos5l_nor2_1
X_3889_ _3889_/Y _3881_/A _3887_/Y _3896_/B VPWR VGND sg13cmos5l_a21oi_1
X_2909_ _4197_/D _2227_/Y _3251_/A2 _2908_/Y VPWR VGND sg13cmos5l_a21oi_1
XFILLER_2_227 VPWR VGND sg13cmos5l_fill_2
XFILLER_2_249 VPWR VGND sg13cmos5l_decap_8
XFILLER_47_905 VPWR VGND sg13cmos5l_decap_8
XFILLER_27_662 VPWR VGND sg13cmos5l_decap_8
XFILLER_42_632 VPWR VGND sg13cmos5l_fill_2
XFILLER_15_857 VPWR VGND sg13cmos5l_decap_8
XFILLER_10_562 VPWR VGND sg13cmos5l_fill_1
XFILLER_6_577 VPWR VGND sg13cmos5l_decap_4
XFILLER_6_555 VPWR VGND sg13cmos5l_decap_8
XFILLER_29_1003 VPWR VGND sg13cmos5l_decap_8
XFILLER_37_7 VPWR VGND sg13cmos5l_fill_2
XFILLER_49_220 VPWR VGND sg13cmos5l_decap_8
XFILLER_2_77 VPWR VGND sg13cmos5l_decap_8
XFILLER_49_297 VPWR VGND sg13cmos5l_decap_8
XFILLER_2_99 VPWR VGND sg13cmos5l_decap_8
XFILLER_46_971 VPWR VGND sg13cmos5l_decap_8
X_3812_ _3813_/C _4332_/Q _4312_/Q VPWR VGND sg13cmos5l_nand2b_1
X_3743_ _3743_/Y _4319_/Q _4362_/Q VPWR VGND sg13cmos5l_nor2_1
X_3674_ _3680_/A _3665_/Y _3671_/Y _3673_/Y VPWR VGND sg13cmos5l_o21ai_1
X_2625_ _2625_/Y _2441_/B _2624_/Y _4138_/Q VPWR VGND sg13cmos5l_a21oi_1
X_2556_ _2556_/Y _2789_/A _2788_/A VPWR VGND sg13cmos5l_nand2b_1
X_2487_ _2487_/Y _2484_/A _2481_/A _2449_/A VPWR VGND sg13cmos5l_o21ai_1
X_4226_ _4226_/Q _4323_/CLK _4226_/D _4226_/RESET_B VPWR VGND sg13cmos5l_dfrbpq_1
X_4157_ _4157_/Q _4161_/CLK _4157_/D _4157_/RESET_B VPWR VGND sg13cmos5l_dfrbpq_1
X_3108_ _3108_/Y _3111_/B _3111_/C VPWR VGND sg13cmos5l_nand2_1
X_4088_ _4088_/Q clkload2/A _4088_/D _4088_/RESET_B VPWR VGND sg13cmos5l_dfrbpq_1
XFILLER_37_982 VPWR VGND sg13cmos5l_decap_8
X_3039_ _3047_/C _4240_/Q _3038_/Y _3037_/Y VPWR VGND sg13cmos5l_o21ai_1
XFILLER_8_809 VPWR VGND sg13cmos5l_decap_8
XFILLER_3_547 VPWR VGND sg13cmos5l_fill_2
XFILLER_4_1005 VPWR VGND sg13cmos5l_decap_8
XFILLER_47_779 VPWR VGND sg13cmos5l_decap_8
XFILLER_27_481 VPWR VGND sg13cmos5l_decap_4
XFILLER_43_996 VPWR VGND sg13cmos5l_decap_8
XFILLER_14_197 VPWR VGND sg13cmos5l_fill_1
XFILLER_11_860 VPWR VGND sg13cmos5l_fill_2
XFILLER_11_893 VPWR VGND sg13cmos5l_decap_8
XFILLER_6_352 VPWR VGND sg13cmos5l_decap_4
XFILLER_10_381 VPWR VGND sg13cmos5l_fill_1
Xhold809 hold809/X _4068_/Q VPWR VGND sg13cmos5l_dlygate4sd3_1
X_2410_ _4084_/D _2439_/A0 hold677/X _2410_/S VPWR VGND sg13cmos5l_mux2_1
XFILLER_7_897 VPWR VGND sg13cmos5l_decap_8
XFILLER_6_396 VPWR VGND sg13cmos5l_fill_1
XFILLER_6_385 VPWR VGND sg13cmos5l_fill_1
X_3390_ _4279_/D _3444_/B _3473_/A VPWR VGND sg13cmos5l_and2_1
X_2341_ _2349_/S _3937_/A _2350_/B VPWR VGND sg13cmos5l_nand2_1
XFILLER_35_4 VPWR VGND sg13cmos5l_fill_2
X_2272_ _2272_/Y _4167_/Q VPWR VGND sg13cmos5l_inv_1
X_4011_ _4011_/Q clkload9/A _4011_/D _4011_/RESET_B VPWR VGND sg13cmos5l_dfrbpq_1
XFILLER_38_757 VPWR VGND sg13cmos5l_decap_8
XFILLER_21_602 VPWR VGND sg13cmos5l_decap_4
XFILLER_34_985 VPWR VGND sg13cmos5l_decap_8
XFILLER_21_624 VPWR VGND sg13cmos5l_fill_2
XFILLER_21_679 VPWR VGND sg13cmos5l_fill_1
X_3726_ _3726_/Y _3726_/A _3730_/B VPWR VGND sg13cmos5l_nand2_1
X_3657_ _3658_/B _3657_/A _3667_/B VPWR VGND sg13cmos5l_xnor2_1
X_2608_ _2608_/Y _2675_/A _2606_/Y _2607_/Y VPWR VGND sg13cmos5l_o21ai_1
X_3588_ _3588_/Y _4287_/Q _3588_/B VPWR VGND sg13cmos5l_nor2_1
XFILLER_0_517 VPWR VGND sg13cmos5l_decap_4
X_2539_ _2539_/Y _2539_/A _2724_/B _2539_/C VPWR VGND sg13cmos5l_nor3_1
X_4209_ _4209_/Q _4209_/CLK _4209_/D _4209_/RESET_B VPWR VGND sg13cmos5l_dfrbpq_1
XFILLER_29_735 VPWR VGND sg13cmos5l_decap_8
XFILLER_43_226 VPWR VGND sg13cmos5l_decap_8
X_4189__564 _4189_/RESET_B VPWR VGND sg13cmos5l_tiehi
XFILLER_40_966 VPWR VGND sg13cmos5l_decap_8
XFILLER_8_639 VPWR VGND sg13cmos5l_fill_2
XFILLER_7_116 VPWR VGND sg13cmos5l_fill_1
XFILLER_11_189 VPWR VGND sg13cmos5l_decap_4
XFILLER_4_801 VPWR VGND sg13cmos5l_decap_8
XFILLER_4_867 VPWR VGND sg13cmos5l_decap_8
XFILLER_47_521 VPWR VGND sg13cmos5l_decap_8
XFILLER_47_71 VPWR VGND sg13cmos5l_decap_4
XFILLER_35_705 VPWR VGND sg13cmos5l_decap_8
XFILLER_19_278 VPWR VGND sg13cmos5l_decap_4
XFILLER_31_900 VPWR VGND sg13cmos5l_decap_8
X_2890_ _2890_/Y _4168_/Q _2890_/B VPWR VGND sg13cmos5l_nor2_1
XFILLER_8_10 VPWR VGND sg13cmos5l_fill_1
XFILLER_8_76 VPWR VGND sg13cmos5l_fill_1
XFILLER_31_999 VPWR VGND sg13cmos5l_decap_8
XFILLER_11_690 VPWR VGND sg13cmos5l_decap_4
X_3511_ _3834_/A _4334_/Q _3783_/A VPWR VGND sg13cmos5l_xnor2_1
Xhold606 _2269_/A _4003_/Q VPWR VGND sg13cmos5l_dlygate4sd3_1
Xhold617 _2263_/A _3998_/Q VPWR VGND sg13cmos5l_dlygate4sd3_1
Xhold628 _2804_/A _4154_/Q VPWR VGND sg13cmos5l_dlygate4sd3_1
Xhold639 hold639/X _4136_/Q VPWR VGND sg13cmos5l_dlygate4sd3_1
X_3442_ _4296_/D _3442_/A _3442_/B VPWR VGND sg13cmos5l_nor2_1
X_3373_ _3375_/B _4247_/Q _4246_/Q VPWR VGND sg13cmos5l_xor2_1
X_2324_ _2500_/C _2324_/A _2474_/A VPWR VGND sg13cmos5l_and2_1
X_2255_ _2561_/C _2553_/A VPWR VGND sg13cmos5l_inv_1
XFILLER_38_587 VPWR VGND sg13cmos5l_decap_8
XFILLER_26_716 VPWR VGND sg13cmos5l_fill_1
XFILLER_26_738 VPWR VGND sg13cmos5l_decap_4
XFILLER_26_749 VPWR VGND sg13cmos5l_fill_2
XFILLER_43_29 VPWR VGND sg13cmos5l_decap_8
XFILLER_40_207 VPWR VGND sg13cmos5l_decap_4
XFILLER_40_218 VPWR VGND sg13cmos5l_decap_8
XFILLER_34_782 VPWR VGND sg13cmos5l_decap_8
XFILLER_21_432 VPWR VGND sg13cmos5l_decap_8
XFILLER_22_977 VPWR VGND sg13cmos5l_decap_8
XFILLER_21_476 VPWR VGND sg13cmos5l_fill_1
X_3709_ _3709_/Y _3696_/Y _3703_/Y _3708_/Y VPWR VGND sg13cmos5l_o21ai_1
XFILLER_1_859 VPWR VGND sg13cmos5l_decap_8
XFILLER_0_347 VPWR VGND sg13cmos5l_fill_1
XFILLER_44_524 VPWR VGND sg13cmos5l_decap_8
XFILLER_44_535 VPWR VGND sg13cmos5l_fill_2
XFILLER_16_248 VPWR VGND sg13cmos5l_fill_1
XFILLER_32_719 VPWR VGND sg13cmos5l_decap_8
XFILLER_12_432 VPWR VGND sg13cmos5l_decap_8
XFILLER_8_436 VPWR VGND sg13cmos5l_decap_8
XFILLER_9_937 VPWR VGND sg13cmos5l_decap_8
XFILLER_12_465 VPWR VGND sg13cmos5l_fill_1
XFILLER_12_476 VPWR VGND sg13cmos5l_decap_4
XFILLER_13_988 VPWR VGND sg13cmos5l_decap_8
XFILLER_8_458 VPWR VGND sg13cmos5l_decap_8
XFILLER_4_642 VPWR VGND sg13cmos5l_decap_8
XFILLER_48_852 VPWR VGND sg13cmos5l_decap_8
X_3991_ _3991_/Q _4136_/CLK _3991_/D _3991_/RESET_B VPWR VGND sg13cmos5l_dfrbpq_1
X_2942_ _2953_/A _2942_/A _2942_/B VPWR VGND sg13cmos5l_and2_1
XFILLER_16_793 VPWR VGND sg13cmos5l_fill_1
XFILLER_31_730 VPWR VGND sg13cmos5l_fill_2
X_2873_ _4187_/D _2872_/A _2872_/B _2918_/B VPWR VGND sg13cmos5l_a21oi_1
XFILLER_30_251 VPWR VGND sg13cmos5l_fill_1
X_3425_ _3425_/Y _3410_/Y _3426_/B _3424_/Y VPWR VGND sg13cmos5l_a21oi_1
X_3356_ _3356_/X _3549_/A _3356_/B VPWR VGND sg13cmos5l_and2_1
X_4179__574 _4179_/RESET_B VPWR VGND sg13cmos5l_tiehi
XFILLER_39_830 VPWR VGND sg13cmos5l_decap_8
X_2307_ _2526_/A _3881_/A _2307_/B VPWR VGND sg13cmos5l_nand2_1
X_3287_ _3287_/X _4266_/Q _3306_/B _3278_/Y VPWR VGND sg13cmos5l_a21o_1
X_2238_ _3077_/A _2851_/A VPWR VGND sg13cmos5l_inv_1
XFILLER_13_207 VPWR VGND sg13cmos5l_decap_8
XFILLER_26_579 VPWR VGND sg13cmos5l_fill_1
XFILLER_13_218 VPWR VGND sg13cmos5l_fill_2
X_4186__567 _4186_/RESET_B VPWR VGND sg13cmos5l_tiehi
XFILLER_16_1027 VPWR VGND sg13cmos5l_fill_2
XFILLER_22_785 VPWR VGND sg13cmos5l_decap_8
XFILLER_10_969 VPWR VGND sg13cmos5l_decap_8
XFILLER_21_284 VPWR VGND sg13cmos5l_fill_2
Xhold981 _3657_/A _4327_/Q VPWR VGND sg13cmos5l_dlygate4sd3_1
Xhold970 _3279_/A _4267_/Q VPWR VGND sg13cmos5l_dlygate4sd3_1
XFILLER_0_144 VPWR VGND sg13cmos5l_decap_8
Xhold992 _3195_/A _4215_/Q VPWR VGND sg13cmos5l_dlygate4sd3_1
XFILLER_49_627 VPWR VGND sg13cmos5l_fill_1
XFILLER_28_73 VPWR VGND sg13cmos5l_decap_8
XFILLER_45_833 VPWR VGND sg13cmos5l_decap_8
XFILLER_9_745 VPWR VGND sg13cmos5l_fill_1
XFILLER_5_940 VPWR VGND sg13cmos5l_decap_8
XFILLER_5_22 VPWR VGND sg13cmos5l_decap_4
XFILLER_5_88 VPWR VGND sg13cmos5l_decap_4
X_4190_ _4190_/Q _4238_/CLK _4190_/D _4190_/RESET_B VPWR VGND sg13cmos5l_dfrbpq_1
XFILLER_5_99 VPWR VGND sg13cmos5l_fill_1
X_3210_ _4249_/D _3260_/B _3305_/B VPWR VGND sg13cmos5l_and2_1
X_3141_ _3141_/Y _3135_/X _3371_/A _3138_/Y _3157_/B _3139_/Y VPWR VGND sg13cmos5l_a221oi_1
X_3072_ _3072_/Y _2226_/Y _3072_/A2 _3071_/Y VPWR VGND sg13cmos5l_a21oi_1
XFILLER_36_855 VPWR VGND sg13cmos5l_decap_8
XFILLER_39_1005 VPWR VGND sg13cmos5l_decap_8
XFILLER_36_888 VPWR VGND sg13cmos5l_decap_8
X_3974_ _4126_/D _2235_/Y _2449_/B _2451_/Y VPWR VGND sg13cmos5l_a21oi_1
X_2925_ _2955_/A _2847_/Y _2872_/Y _2946_/S VPWR VGND sg13cmos5l_mux2_1
X_2856_ _2941_/A _4209_/Q _2841_/B _2855_/B _2855_/A _2856_/C1 VPWR VGND sg13cmos5l_a221oi_1
X_2787_ _4175_/D _2905_/A _2797_/B VPWR VGND sg13cmos5l_and2_1
XFILLER_49_39 VPWR VGND sg13cmos5l_decap_8
X_3408_ _3408_/X _4252_/Q _3411_/B VPWR VGND sg13cmos5l_and2_1
X_4218__519 _4218_/RESET_B VPWR VGND sg13cmos5l_tiehi
XFILLER_46_608 VPWR VGND sg13cmos5l_decap_4
X_3339_ _3339_/X _4303_/Q _3339_/B VPWR VGND sg13cmos5l_xor2_1
X_4192__560 _4192_/RESET_B VPWR VGND sg13cmos5l_tiehi
XFILLER_27_833 VPWR VGND sg13cmos5l_fill_2
XFILLER_38_192 VPWR VGND sg13cmos5l_fill_2
XFILLER_14_516 VPWR VGND sg13cmos5l_fill_2
XFILLER_27_899 VPWR VGND sg13cmos5l_decap_4
XFILLER_41_335 VPWR VGND sg13cmos5l_decap_8
XFILLER_10_711 VPWR VGND sg13cmos5l_decap_8
XFILLER_5_203 VPWR VGND sg13cmos5l_fill_2
XFILLER_10_777 VPWR VGND sg13cmos5l_decap_8
XFILLER_14_97 VPWR VGND sg13cmos5l_decap_4
XFILLER_30_30 VPWR VGND sg13cmos5l_fill_2
XFILLER_30_74 VPWR VGND sg13cmos5l_decap_4
XFILLER_2_932 VPWR VGND sg13cmos5l_decap_8
X_4201__545 _4201_/RESET_B VPWR VGND sg13cmos5l_tiehi
XFILLER_49_468 VPWR VGND sg13cmos5l_decap_8
XFILLER_37_619 VPWR VGND sg13cmos5l_fill_1
XFILLER_37_608 VPWR VGND sg13cmos5l_decap_8
XFILLER_20_519 VPWR VGND sg13cmos5l_fill_1
X_2710_ _2710_/Y _2710_/A _2710_/B _2710_/C VPWR VGND sg13cmos5l_nand3_1
X_3690_ _3690_/Y _3701_/B _3690_/B VPWR VGND sg13cmos5l_nand2_1
X_2641_ _2643_/A _2300_/A _2637_/X _2640_/Y VPWR VGND sg13cmos5l_a21oi_1
X_2572_ _4144_/D _2569_/Y _2571_/Y _2567_/A VPWR VGND sg13cmos5l_a21oi_1
XFILLER_5_781 VPWR VGND sg13cmos5l_decap_4
X_4311_ _4311_/Q _4353_/CLK _4311_/D _4311_/RESET_B VPWR VGND sg13cmos5l_dfrbpq_1
X_4242_ _4242_/Q _4272_/CLK _4242_/D _4242_/RESET_B VPWR VGND sg13cmos5l_dfrbpq_1
X_4173_ _4173_/Q _4225_/CLK _4173_/D _4173_/RESET_B VPWR VGND sg13cmos5l_dfrbpq_1
X_4176__577 _4176_/RESET_B VPWR VGND sg13cmos5l_tiehi
X_3124_ _3124_/Y _3113_/Y _3122_/S _2963_/Y VPWR VGND sg13cmos5l_o21ai_1
X_3055_ _3055_/Y _3064_/B _3052_/Y _3064_/A VPWR VGND sg13cmos5l_o21ai_1
XFILLER_35_151 VPWR VGND sg13cmos5l_decap_8
X_3957_ _4004_/D _2265_/Y _3960_/S _3956_/Y VPWR VGND sg13cmos5l_a21oi_1
X_2908_ _2908_/Y hold660/X _3251_/A2 _2913_/A VPWR VGND sg13cmos5l_o21ai_1
XFILLER_32_880 VPWR VGND sg13cmos5l_fill_2
X_3888_ _3892_/B _4365_/Q _4364_/Q _3881_/A VPWR VGND sg13cmos5l_o21ai_1
X_2839_ _3019_/A _4209_/Q _2841_/B VPWR VGND sg13cmos5l_nor2_1
XFILLER_42_611 VPWR VGND sg13cmos5l_decap_8
XFILLER_41_40 VPWR VGND sg13cmos5l_fill_2
XFILLER_6_512 VPWR VGND sg13cmos5l_decap_8
XFILLER_10_596 VPWR VGND sg13cmos5l_fill_2
XFILLER_6_567 VPWR VGND sg13cmos5l_fill_1
XFILLER_2_784 VPWR VGND sg13cmos5l_decap_8
XFILLER_2_12 VPWR VGND sg13cmos5l_fill_2
XFILLER_49_265 VPWR VGND sg13cmos5l_decap_4
XFILLER_49_287 VPWR VGND sg13cmos5l_fill_1
XFILLER_46_950 VPWR VGND sg13cmos5l_decap_8
X_3811_ _3811_/Y _3813_/B VPWR VGND sg13cmos5l_inv_1
XFILLER_33_666 VPWR VGND sg13cmos5l_decap_8
XFILLER_33_699 VPWR VGND sg13cmos5l_fill_2
X_4208__529 _4208_/RESET_B VPWR VGND sg13cmos5l_tiehi
X_3742_ _3742_/Y _3737_/Y _3739_/Y _3741_/Y VPWR VGND sg13cmos5l_o21ai_1
X_3673_ _3673_/Y _3639_/Y _3647_/X _3672_/Y VPWR VGND sg13cmos5l_a21oi_1
X_2624_ _2624_/Y _2620_/Y _2621_/Y _2623_/Y VPWR VGND sg13cmos5l_o21ai_1
X_2555_ _2804_/B _2789_/A _2788_/A VPWR VGND sg13cmos5l_nor2b_1
X_2486_ _2488_/B _2486_/A _2486_/B _2486_/C VPWR VGND sg13cmos5l_nand3_1
X_4225_ _4225_/Q _4225_/CLK _4225_/D _4225_/RESET_B VPWR VGND sg13cmos5l_dfrbpq_1
X_4156_ _4156_/Q _4181_/CLK _4156_/D _4156_/RESET_B VPWR VGND sg13cmos5l_dfrbpq_1
X_3107_ _3111_/C _3107_/A _3107_/B _3107_/C VPWR VGND sg13cmos5l_or3_1
XFILLER_37_961 VPWR VGND sg13cmos5l_decap_8
X_4087_ _4087_/Q clkload2/A _4087_/D _4087_/RESET_B VPWR VGND sg13cmos5l_dfrbpq_1
XFILLER_24_611 VPWR VGND sg13cmos5l_decap_8
X_3038_ _3038_/Y _4194_/Q _4239_/Q VPWR VGND sg13cmos5l_nor2_1
XFILLER_24_666 VPWR VGND sg13cmos5l_decap_4
XFILLER_20_850 VPWR VGND sg13cmos5l_fill_2
XFILLER_3_526 VPWR VGND sg13cmos5l_decap_8
XFILLER_11_54 VPWR VGND sg13cmos5l_fill_1
XFILLER_47_703 VPWR VGND sg13cmos5l_fill_1
XFILLER_46_224 VPWR VGND sg13cmos5l_decap_8
XFILLER_4_1028 VPWR VGND sg13cmos5l_fill_1
X_4218__168 _4218_/D VPWR VGND sg13cmos5l_tielo
XFILLER_46_257 VPWR VGND sg13cmos5l_fill_2
XFILLER_19_449 VPWR VGND sg13cmos5l_decap_8
XFILLER_15_600 VPWR VGND sg13cmos5l_decap_8
XFILLER_36_40 VPWR VGND sg13cmos5l_fill_2
XFILLER_15_633 VPWR VGND sg13cmos5l_decap_8
XFILLER_15_644 VPWR VGND sg13cmos5l_fill_2
XFILLER_43_975 VPWR VGND sg13cmos5l_decap_8
XFILLER_42_441 VPWR VGND sg13cmos5l_decap_4
XFILLER_30_647 VPWR VGND sg13cmos5l_fill_1
X_2340_ _2350_/B _4127_/Q _3963_/A VPWR VGND sg13cmos5l_nor2b_1
X_2271_ _2776_/A _4168_/Q VPWR VGND sg13cmos5l_inv_1
XFILLER_2_592 VPWR VGND sg13cmos5l_fill_2
X_4010_ _4010_/Q clkload9/A _4010_/D _4010_/RESET_B VPWR VGND sg13cmos5l_dfrbpq_1
XFILLER_28_4 VPWR VGND sg13cmos5l_decap_8
XFILLER_19_950 VPWR VGND sg13cmos5l_decap_4
XFILLER_34_920 VPWR VGND sg13cmos5l_decap_8
XFILLER_33_496 VPWR VGND sg13cmos5l_decap_8
X_3725_ _4338_/D _3879_/A _3725_/B VPWR VGND sg13cmos5l_nor2_1
Xclkbuf_leaf_9_clk _4161_/CLK clkload0/A VPWR VGND sg13cmos5l_buf_8
X_3656_ _3656_/Y _3656_/A _3656_/B _3656_/C VPWR VGND sg13cmos5l_nand3_1
X_2607_ _2607_/Y _2607_/A _4138_/Q VPWR VGND sg13cmos5l_nor2b_1
X_3587_ _3587_/Y _3587_/A VPWR VGND sg13cmos5l_inv_1
X_2538_ _2539_/C _2538_/A _2538_/B VPWR VGND sg13cmos5l_nand2_1
X_4208_ _4208_/Q _4209_/CLK _4208_/D _4208_/RESET_B VPWR VGND sg13cmos5l_dfrbpq_1
X_2469_ _4118_/D _2516_/A _2469_/B VPWR VGND sg13cmos5l_nor2_1
XFILLER_29_703 VPWR VGND sg13cmos5l_decap_8
XFILLER_28_202 VPWR VGND sg13cmos5l_decap_4
XFILLER_29_714 VPWR VGND sg13cmos5l_fill_1
X_4139_ _4139_/Q _4378_/CLK _4139_/D _4139_/RESET_B VPWR VGND sg13cmos5l_dfrbpq_1
XFILLER_44_728 VPWR VGND sg13cmos5l_decap_8
XFILLER_25_920 VPWR VGND sg13cmos5l_fill_1
XFILLER_28_268 VPWR VGND sg13cmos5l_decap_8
XFILLER_24_430 VPWR VGND sg13cmos5l_decap_8
XFILLER_19_1014 VPWR VGND sg13cmos5l_decap_8
XFILLER_40_945 VPWR VGND sg13cmos5l_decap_8
XFILLER_12_614 VPWR VGND sg13cmos5l_decap_8
XFILLER_25_997 VPWR VGND sg13cmos5l_decap_8
XFILLER_7_128 VPWR VGND sg13cmos5l_fill_2
XFILLER_4_846 VPWR VGND sg13cmos5l_decap_8
XFILLER_3_367 VPWR VGND sg13cmos5l_fill_1
XFILLER_3_389 VPWR VGND sg13cmos5l_decap_8
XFILLER_26_1018 VPWR VGND sg13cmos5l_decap_8
XFILLER_47_50 VPWR VGND sg13cmos5l_decap_8
XFILLER_19_257 VPWR VGND sg13cmos5l_decap_8
XFILLER_28_780 VPWR VGND sg13cmos5l_fill_1
XFILLER_15_463 VPWR VGND sg13cmos5l_decap_8
XFILLER_43_794 VPWR VGND sg13cmos5l_fill_2
XFILLER_43_783 VPWR VGND sg13cmos5l_decap_8
XFILLER_42_282 VPWR VGND sg13cmos5l_decap_4
XFILLER_31_934 VPWR VGND sg13cmos5l_fill_1
XFILLER_42_293 VPWR VGND sg13cmos5l_decap_8
XFILLER_31_978 VPWR VGND sg13cmos5l_decap_8
XFILLER_30_488 VPWR VGND sg13cmos5l_fill_1
XFILLER_8_88 VPWR VGND sg13cmos5l_decap_4
X_3510_ _3510_/Y _4309_/Q _3510_/B VPWR VGND sg13cmos5l_xnor2_1
XFILLER_7_673 VPWR VGND sg13cmos5l_decap_4
Xhold607 _2264_/A _4002_/Q VPWR VGND sg13cmos5l_dlygate4sd3_1
X_4320__403 _4320_/RESET_B VPWR VGND sg13cmos5l_tiehi
Xhold618 _3998_/D _3947_/Y VPWR VGND sg13cmos5l_dlygate4sd3_1
XFILLER_6_172 VPWR VGND sg13cmos5l_decap_4
X_3441_ _4295_/D _3441_/A _3444_/B VPWR VGND sg13cmos5l_and2_1
Xhold629 _2228_/A _4196_/Q VPWR VGND sg13cmos5l_dlygate4sd3_1
X_3372_ _3372_/X _4268_/Q _4246_/Q VPWR VGND sg13cmos5l_or2_1
X_2323_ _2474_/A _4123_/Q _2293_/A _2322_/Y VPWR VGND sg13cmos5l_a21oi_1
X_2254_ _3782_/A _3529_/A VPWR VGND sg13cmos5l_inv_1
XFILLER_38_555 VPWR VGND sg13cmos5l_fill_1
XFILLER_26_728 VPWR VGND sg13cmos5l_fill_1
XFILLER_19_791 VPWR VGND sg13cmos5l_decap_8
XFILLER_25_238 VPWR VGND sg13cmos5l_decap_8
XFILLER_43_19 VPWR VGND sg13cmos5l_fill_1
XFILLER_22_901 VPWR VGND sg13cmos5l_decap_4
XFILLER_34_761 VPWR VGND sg13cmos5l_decap_8
X_3708_ _3708_/Y _3730_/A _3701_/X _3712_/A _3733_/A VPWR VGND sg13cmos5l_a22oi_1
X_3639_ _3639_/Y _4331_/Q _3667_/B VPWR VGND sg13cmos5l_nor2_1
XFILLER_1_838 VPWR VGND sg13cmos5l_decap_8
XFILLER_44_558 VPWR VGND sg13cmos5l_decap_8
XFILLER_17_97 VPWR VGND sg13cmos5l_fill_2
XFILLER_12_411 VPWR VGND sg13cmos5l_decap_8
XFILLER_31_219 VPWR VGND sg13cmos5l_decap_8
XFILLER_8_404 VPWR VGND sg13cmos5l_fill_2
XFILLER_9_916 VPWR VGND sg13cmos5l_decap_8
XFILLER_13_967 VPWR VGND sg13cmos5l_decap_8
XFILLER_40_786 VPWR VGND sg13cmos5l_decap_8
XFILLER_33_96 VPWR VGND sg13cmos5l_decap_8
XFILLER_4_698 VPWR VGND sg13cmos5l_fill_1
X_4122__254 _4122_/RESET_B VPWR VGND sg13cmos5l_tiehi
XFILLER_0_893 VPWR VGND sg13cmos5l_decap_8
XFILLER_48_831 VPWR VGND sg13cmos5l_decap_8
XFILLER_35_525 VPWR VGND sg13cmos5l_fill_1
X_3990_ _3990_/Q clkload4/A _3990_/D _3990_/RESET_B VPWR VGND sg13cmos5l_dfrbpq_1
XFILLER_35_558 VPWR VGND sg13cmos5l_fill_1
X_2941_ _2941_/X _2941_/A _2941_/B VPWR VGND sg13cmos5l_and2_1
XFILLER_15_271 VPWR VGND sg13cmos5l_fill_1
X_2872_ _2872_/Y _2872_/A _2872_/B VPWR VGND sg13cmos5l_nand2_1
X_3424_ _3424_/Y hold914/X _3426_/B _3323_/Y VPWR VGND sg13cmos5l_o21ai_1
X_3355_ _4274_/D _3442_/B _3355_/B VPWR VGND sg13cmos5l_nor2_1
X_2306_ _2523_/B _2306_/A _2306_/B _4364_/Q VPWR VGND sg13cmos5l_nor3_1
X_3286_ _3286_/X _3307_/A _3286_/B VPWR VGND sg13cmos5l_and2_1
X_2237_ _3257_/A _2237_/A VPWR VGND sg13cmos5l_inv_1
XFILLER_38_341 VPWR VGND sg13cmos5l_fill_2
XFILLER_22_731 VPWR VGND sg13cmos5l_decap_8
XFILLER_21_241 VPWR VGND sg13cmos5l_decap_8
XFILLER_21_252 VPWR VGND sg13cmos5l_decap_8
XFILLER_10_948 VPWR VGND sg13cmos5l_decap_8
XFILLER_21_274 VPWR VGND sg13cmos5l_decap_4
XFILLER_22_797 VPWR VGND sg13cmos5l_decap_8
XFILLER_5_407 VPWR VGND sg13cmos5l_decap_8
Xhold960 hold960/X _4273_/Q VPWR VGND sg13cmos5l_dlygate4sd3_1
XFILLER_1_613 VPWR VGND sg13cmos5l_fill_1
Xhold982 hold982/X _3658_/Y VPWR VGND sg13cmos5l_dlygate4sd3_1
Xhold971 _3296_/A _4263_/Q VPWR VGND sg13cmos5l_dlygate4sd3_1
Xhold993 _3515_/B _4305_/Q VPWR VGND sg13cmos5l_dlygate4sd3_1
XFILLER_0_123 VPWR VGND sg13cmos5l_decap_8
XFILLER_49_639 VPWR VGND sg13cmos5l_decap_8
XFILLER_0_178 VPWR VGND sg13cmos5l_decap_8
XFILLER_1_679 VPWR VGND sg13cmos5l_fill_2
XFILLER_45_812 VPWR VGND sg13cmos5l_decap_8
Xheichips26_dna_sequencer uio_oe[0] VPWR VGND sg13cmos5l_tielo
XFILLER_45_889 VPWR VGND sg13cmos5l_decap_8
XFILLER_44_388 VPWR VGND sg13cmos5l_fill_1
XFILLER_32_528 VPWR VGND sg13cmos5l_fill_1
XFILLER_13_753 VPWR VGND sg13cmos5l_decap_8
XFILLER_40_572 VPWR VGND sg13cmos5l_decap_8
XFILLER_40_594 VPWR VGND sg13cmos5l_fill_1
XFILLER_12_274 VPWR VGND sg13cmos5l_decap_8
XFILLER_12_296 VPWR VGND sg13cmos5l_decap_8
XFILLER_13_797 VPWR VGND sg13cmos5l_decap_8
XFILLER_8_278 VPWR VGND sg13cmos5l_fill_1
XFILLER_5_45 VPWR VGND sg13cmos5l_fill_1
XFILLER_5_996 VPWR VGND sg13cmos5l_decap_8
X_3140_ _3157_/B _4241_/Q _3140_/B VPWR VGND sg13cmos5l_xor2_1
XFILLER_10_4 VPWR VGND sg13cmos5l_decap_8
X_3071_ _3071_/Y _4228_/Q _3072_/A2 _3255_/A VPWR VGND sg13cmos5l_o21ai_1
XFILLER_47_171 VPWR VGND sg13cmos5l_decap_4
XFILLER_36_834 VPWR VGND sg13cmos5l_decap_8
XFILLER_36_823 VPWR VGND sg13cmos5l_decap_8
XFILLER_39_1028 VPWR VGND sg13cmos5l_fill_1
XFILLER_35_355 VPWR VGND sg13cmos5l_decap_8
XFILLER_35_399 VPWR VGND sg13cmos5l_decap_4
X_3973_ _3973_/Y _3973_/A _3973_/B VPWR VGND sg13cmos5l_nor2_1
X_2924_ _2946_/S _2921_/Y _2923_/Y _2919_/Y VPWR VGND sg13cmos5l_a21oi_1
XFILLER_31_550 VPWR VGND sg13cmos5l_decap_8
X_2855_ _2855_/Y _2855_/A _2855_/B VPWR VGND sg13cmos5l_nand2_1
XFILLER_31_583 VPWR VGND sg13cmos5l_decap_8
X_2786_ _4174_/D _2905_/A _2786_/B VPWR VGND sg13cmos5l_and2_1
XFILLER_49_18 VPWR VGND sg13cmos5l_decap_8
X_3407_ _3407_/Y _3580_/B _3427_/A VPWR VGND sg13cmos5l_nand2_1
X_3338_ _3360_/A _4303_/Q _3339_/B VPWR VGND sg13cmos5l_xnor2_1
XFILLER_22_1021 VPWR VGND sg13cmos5l_decap_8
X_3269_ _3293_/C _3264_/X _3265_/Y _3267_/Y VPWR VGND sg13cmos5l_a21o_1
XFILLER_39_694 VPWR VGND sg13cmos5l_fill_1
XFILLER_26_322 VPWR VGND sg13cmos5l_decap_8
XFILLER_26_344 VPWR VGND sg13cmos5l_fill_2
XFILLER_26_355 VPWR VGND sg13cmos5l_fill_2
XFILLER_27_856 VPWR VGND sg13cmos5l_fill_1
XFILLER_14_54 VPWR VGND sg13cmos5l_fill_2
XFILLER_10_734 VPWR VGND sg13cmos5l_decap_8
XFILLER_10_756 VPWR VGND sg13cmos5l_decap_4
XFILLER_5_226 VPWR VGND sg13cmos5l_fill_2
XFILLER_5_215 VPWR VGND sg13cmos5l_fill_1
XFILLER_10_789 VPWR VGND sg13cmos5l_decap_8
XFILLER_30_20 VPWR VGND sg13cmos5l_fill_1
XFILLER_2_911 VPWR VGND sg13cmos5l_decap_8
Xhold790 _2223_/A _4259_/Q VPWR VGND sg13cmos5l_dlygate4sd3_1
XFILLER_7_1026 VPWR VGND sg13cmos5l_fill_2
XFILLER_2_988 VPWR VGND sg13cmos5l_decap_8
XFILLER_1_465 VPWR VGND sg13cmos5l_decap_8
XFILLER_49_447 VPWR VGND sg13cmos5l_decap_8
XFILLER_49_425 VPWR VGND sg13cmos5l_decap_8
X_4156__180 _4156_/D VPWR VGND sg13cmos5l_tielo
XFILLER_29_160 VPWR VGND sg13cmos5l_decap_4
XFILLER_45_653 VPWR VGND sg13cmos5l_fill_2
XFILLER_17_333 VPWR VGND sg13cmos5l_decap_4
XFILLER_44_174 VPWR VGND sg13cmos5l_decap_8
XFILLER_9_532 VPWR VGND sg13cmos5l_decap_4
XFILLER_9_565 VPWR VGND sg13cmos5l_decap_8
X_2640_ _2640_/Y _2300_/A _2639_/Y _2710_/A VPWR VGND sg13cmos5l_o21ai_1
X_2571_ _2571_/Y _2788_/A hold862/X _2557_/Y VPWR VGND sg13cmos5l_o21ai_1
XFILLER_5_760 VPWR VGND sg13cmos5l_decap_8
X_4310_ _4310_/Q _4353_/CLK _4310_/D _4310_/RESET_B VPWR VGND sg13cmos5l_dfrbpq_1
XFILLER_4_281 VPWR VGND sg13cmos5l_fill_1
X_4241_ _4241_/Q _4272_/CLK _4241_/D _4241_/RESET_B VPWR VGND sg13cmos5l_dfrbpq_1
X_4172_ _4172_/Q _4225_/CLK _4172_/D _4172_/RESET_B VPWR VGND sg13cmos5l_dfrbpq_1
X_4217__520 _4217_/RESET_B VPWR VGND sg13cmos5l_tiehi
X_3123_ _4237_/D _3123_/A _3123_/B VPWR VGND sg13cmos5l_and2_1
XFILLER_49_981 VPWR VGND sg13cmos5l_decap_8
XFILLER_36_620 VPWR VGND sg13cmos5l_decap_8
X_3054_ _3056_/B _3050_/Y _3051_/Y _3053_/Y VPWR VGND sg13cmos5l_o21ai_1
XFILLER_35_185 VPWR VGND sg13cmos5l_decap_4
X_3956_ _3956_/Y _3956_/A _3960_/S VPWR VGND sg13cmos5l_nor2_1
X_2907_ _4196_/D _2228_/Y _2910_/A2 _2906_/Y VPWR VGND sg13cmos5l_a21oi_1
XFILLER_13_1009 VPWR VGND sg13cmos5l_decap_8
X_3887_ _3887_/Y _3887_/A _4364_/Q VPWR VGND sg13cmos5l_xnor2_1
X_2838_ _3027_/B _3078_/A _4209_/Q VPWR VGND sg13cmos5l_nor2_1
X_4224__513 _4224_/RESET_B VPWR VGND sg13cmos5l_tiehi
X_2769_ _2771_/A _4167_/Q _2740_/Y _2767_/Y _2274_/A _2768_/Y VPWR VGND sg13cmos5l_a221oi_1
XFILLER_18_108 VPWR VGND sg13cmos5l_fill_2
XFILLER_27_631 VPWR VGND sg13cmos5l_decap_8
XFILLER_14_303 VPWR VGND sg13cmos5l_decap_4
XFILLER_15_815 VPWR VGND sg13cmos5l_decap_8
XFILLER_25_53 VPWR VGND sg13cmos5l_decap_8
X_4186__173 _4186_/D VPWR VGND sg13cmos5l_tielo
XFILLER_10_542 VPWR VGND sg13cmos5l_fill_2
XFILLER_22_391 VPWR VGND sg13cmos5l_decap_8
XFILLER_6_546 VPWR VGND sg13cmos5l_decap_4
XFILLER_49_200 VPWR VGND sg13cmos5l_fill_2
XFILLER_38_918 VPWR VGND sg13cmos5l_decap_4
XFILLER_45_461 VPWR VGND sg13cmos5l_decap_4
X_4015__213 _4015_/RESET_B VPWR VGND sg13cmos5l_tiehi
XFILLER_18_686 VPWR VGND sg13cmos5l_fill_2
XFILLER_17_196 VPWR VGND sg13cmos5l_fill_2
XFILLER_33_656 VPWR VGND sg13cmos5l_decap_4
X_3810_ _3813_/B _4310_/Q _4311_/Q _4312_/Q VPWR VGND sg13cmos5l_o21ai_1
XFILLER_32_144 VPWR VGND sg13cmos5l_decap_8
X_3741_ _3741_/Y _4318_/Q _3756_/A _4363_/Q _3740_/Y VPWR VGND sg13cmos5l_a22oi_1
XFILLER_13_380 VPWR VGND sg13cmos5l_decap_8
X_3672_ _3672_/Y _3672_/A _3672_/B VPWR VGND sg13cmos5l_nor2_1
XFILLER_12_1020 VPWR VGND sg13cmos5l_decap_8
X_2623_ _2623_/Y _2659_/A _2623_/B VPWR VGND sg13cmos5l_nand2_1
X_4182__571 _4182_/RESET_B VPWR VGND sg13cmos5l_tiehi
X_2554_ _2566_/A _4141_/Q _2554_/B VPWR VGND sg13cmos5l_and2_1
X_2485_ _2488_/A _2486_/A _2486_/B _2486_/C VPWR VGND sg13cmos5l_a21o_1
X_4224_ _4224_/Q _4262_/CLK _4224_/D _4224_/RESET_B VPWR VGND sg13cmos5l_dfrbpq_1
X_4155_ _4155_/Q _4181_/CLK _4155_/D _4155_/RESET_B VPWR VGND sg13cmos5l_dfrbpq_1
XFILLER_29_907 VPWR VGND sg13cmos5l_decap_4
X_3106_ _3111_/B _3107_/B _3107_/C _2997_/B VPWR VGND sg13cmos5l_o21ai_1
XFILLER_37_940 VPWR VGND sg13cmos5l_decap_8
X_4086_ _4086_/Q clkload7/A _4086_/D _4086_/RESET_B VPWR VGND sg13cmos5l_dfrbpq_1
X_3037_ _3037_/Y _3032_/Y _3034_/Y _3036_/Y VPWR VGND sg13cmos5l_o21ai_1
XFILLER_36_472 VPWR VGND sg13cmos5l_decap_4
XFILLER_24_634 VPWR VGND sg13cmos5l_decap_8
XFILLER_12_807 VPWR VGND sg13cmos5l_fill_2
XFILLER_12_829 VPWR VGND sg13cmos5l_decap_8
X_3939_ _3993_/D _3965_/A0 hold663/X _3948_/S VPWR VGND sg13cmos5l_mux2_1
XFILLER_11_11 VPWR VGND sg13cmos5l_decap_4
XFILLER_11_88 VPWR VGND sg13cmos5l_fill_1
XFILLER_15_612 VPWR VGND sg13cmos5l_decap_8
XFILLER_28_995 VPWR VGND sg13cmos5l_decap_8
XFILLER_43_954 VPWR VGND sg13cmos5l_decap_8
XFILLER_36_85 VPWR VGND sg13cmos5l_fill_2
XFILLER_42_486 VPWR VGND sg13cmos5l_fill_2
XFILLER_30_626 VPWR VGND sg13cmos5l_decap_8
XFILLER_7_822 VPWR VGND sg13cmos5l_fill_2
XFILLER_11_873 VPWR VGND sg13cmos5l_fill_2
X_4207__530 _4207_/RESET_B VPWR VGND sg13cmos5l_tiehi
XFILLER_7_844 VPWR VGND sg13cmos5l_decap_4
XFILLER_10_372 VPWR VGND sg13cmos5l_decap_4
X_2270_ _2270_/Y _2270_/A VPWR VGND sg13cmos5l_inv_1
XFILLER_42_1024 VPWR VGND sg13cmos5l_decap_4
XFILLER_37_203 VPWR VGND sg13cmos5l_decap_8
XFILLER_37_236 VPWR VGND sg13cmos5l_decap_8
X_4214__523 _4214_/RESET_B VPWR VGND sg13cmos5l_tiehi
XFILLER_37_269 VPWR VGND sg13cmos5l_fill_2
X_4132__234 _4132_/RESET_B VPWR VGND sg13cmos5l_tiehi
XFILLER_34_965 VPWR VGND sg13cmos5l_decap_8
X_3724_ _3724_/X _3695_/Y _3722_/A _3731_/S VPWR VGND sg13cmos5l_mux2_1
X_3655_ _3655_/X _3656_/B _3656_/C VPWR VGND sg13cmos5l_and2_1
X_2606_ _2606_/Y _2606_/A VPWR VGND sg13cmos5l_inv_1
X_4221__516 _4221_/RESET_B VPWR VGND sg13cmos5l_tiehi
X_3586_ _3587_/A _3584_/Y _3585_/Y _3586_/S VPWR VGND sg13cmos5l_mux2_1
X_2537_ _2538_/B _4147_/Q _4195_/Q _4169_/Q _4256_/Q VPWR VGND sg13cmos5l_nor4_1
X_2468_ _2468_/Y _2461_/B _4118_/Q _2456_/B hold633/X VPWR VGND sg13cmos5l_a22oi_1
X_4207_ _4207_/Q _4209_/CLK _4207_/D _4207_/RESET_B VPWR VGND sg13cmos5l_dfrbpq_1
X_2399_ _2399_/X _2439_/A0 hold691/X _2399_/S VPWR VGND sg13cmos5l_mux2_1
X_4138_ _4138_/Q _4378_/CLK _4138_/D _4138_/RESET_B VPWR VGND sg13cmos5l_dfrbpq_1
XFILLER_28_236 VPWR VGND sg13cmos5l_decap_8
X_4069_ _4069_/Q clkload7/A _4069_/D _4069_/RESET_B VPWR VGND sg13cmos5l_dfrbpq_1
XFILLER_40_924 VPWR VGND sg13cmos5l_decap_8
XFILLER_11_103 VPWR VGND sg13cmos5l_decap_8
XFILLER_12_637 VPWR VGND sg13cmos5l_decap_8
XFILLER_24_475 VPWR VGND sg13cmos5l_fill_1
XFILLER_11_147 VPWR VGND sg13cmos5l_fill_2
XFILLER_3_313 VPWR VGND sg13cmos5l_decap_8
XFILLER_3_346 VPWR VGND sg13cmos5l_decap_8
XFILLER_19_203 VPWR VGND sg13cmos5l_decap_4
XFILLER_47_556 VPWR VGND sg13cmos5l_decap_8
XFILLER_47_95 VPWR VGND sg13cmos5l_fill_1
XFILLER_47_84 VPWR VGND sg13cmos5l_fill_2
XFILLER_16_921 VPWR VGND sg13cmos5l_decap_8
XFILLER_30_445 VPWR VGND sg13cmos5l_fill_2
XFILLER_31_957 VPWR VGND sg13cmos5l_decap_8
XFILLER_7_652 VPWR VGND sg13cmos5l_fill_2
Xhold608 _2224_/A _4258_/Q VPWR VGND sg13cmos5l_dlygate4sd3_1
X_3440_ _4294_/D _3615_/A _3440_/B VPWR VGND sg13cmos5l_and2_1
Xhold619 _2914_/B _4175_/Q VPWR VGND sg13cmos5l_dlygate4sd3_1
XFILLER_40_4 VPWR VGND sg13cmos5l_fill_2
X_3371_ _3376_/A _3371_/A _3377_/B _3371_/C VPWR VGND sg13cmos5l_nand3_1
X_2322_ _2322_/Y input3/X input2/X VPWR VGND sg13cmos5l_nand2_1
X_2253_ _3786_/A _3822_/A VPWR VGND sg13cmos5l_inv_1
XFILLER_38_567 VPWR VGND sg13cmos5l_decap_8
X_4288__443 _4288_/RESET_B VPWR VGND sg13cmos5l_tiehi
XFILLER_34_740 VPWR VGND sg13cmos5l_decap_8
XFILLER_22_924 VPWR VGND sg13cmos5l_decap_8
XFILLER_21_467 VPWR VGND sg13cmos5l_fill_2
X_4360__239 _4360_/RESET_B VPWR VGND sg13cmos5l_tiehi
X_3707_ _3733_/A _4341_/Q _3707_/B VPWR VGND sg13cmos5l_xnor2_1
X_3638_ _3638_/Y _3636_/Y _3637_/Y _3635_/Y VPWR VGND sg13cmos5l_a21oi_1
X_4143__182 _4143_/D VPWR VGND sg13cmos5l_tielo
X_3569_ _3625_/B _3356_/X _3565_/B _3568_/Y VPWR VGND sg13cmos5l_a21oi_1
XFILLER_1_817 VPWR VGND sg13cmos5l_decap_8
XFILLER_0_316 VPWR VGND sg13cmos5l_decap_8
XFILLER_0_338 VPWR VGND sg13cmos5l_decap_8
XFILLER_16_239 VPWR VGND sg13cmos5l_decap_8
XFILLER_24_250 VPWR VGND sg13cmos5l_fill_2
XFILLER_24_272 VPWR VGND sg13cmos5l_fill_2
XFILLER_31_209 VPWR VGND sg13cmos5l_decap_4
XFILLER_13_946 VPWR VGND sg13cmos5l_decap_8
XFILLER_33_20 VPWR VGND sg13cmos5l_decap_8
XFILLER_40_765 VPWR VGND sg13cmos5l_decap_8
XFILLER_33_53 VPWR VGND sg13cmos5l_decap_4
XFILLER_32_1023 VPWR VGND sg13cmos5l_decap_4
X_4204__533 _4204_/RESET_B VPWR VGND sg13cmos5l_tiehi
XFILLER_4_688 VPWR VGND sg13cmos5l_fill_1
XFILLER_3_198 VPWR VGND sg13cmos5l_decap_4
XFILLER_48_810 VPWR VGND sg13cmos5l_decap_8
XFILLER_0_872 VPWR VGND sg13cmos5l_decap_8
XFILLER_48_887 VPWR VGND sg13cmos5l_decap_8
XFILLER_47_386 VPWR VGND sg13cmos5l_fill_1
X_4211__526 _4211_/RESET_B VPWR VGND sg13cmos5l_tiehi
XFILLER_43_570 VPWR VGND sg13cmos5l_decap_4
X_2940_ _2940_/Y _2940_/A VPWR VGND sg13cmos5l_inv_1
X_2871_ _2872_/B _2868_/B _2869_/Y _2870_/Y VPWR VGND sg13cmos5l_o21ai_1
XFILLER_31_732 VPWR VGND sg13cmos5l_fill_1
XFILLER_31_743 VPWR VGND sg13cmos5l_decap_8
XFILLER_30_297 VPWR VGND sg13cmos5l_decap_8
XFILLER_8_983 VPWR VGND sg13cmos5l_decap_8
X_3423_ _4283_/D _3442_/B _3423_/B VPWR VGND sg13cmos5l_nor2_1
X_3354_ _3355_/B _3447_/A _3447_/B VPWR VGND sg13cmos5l_or2_1
X_2305_ _2518_/A _2305_/A _4373_/Q VPWR VGND sg13cmos5l_or2_1
X_3285_ _3286_/B _4266_/Q _3296_/B VPWR VGND sg13cmos5l_or2_1
X_4097__287 _4097_/RESET_B VPWR VGND sg13cmos5l_tiehi
X_2236_ _2461_/B input4/X VPWR VGND sg13cmos5l_inv_1
XFILLER_38_353 VPWR VGND sg13cmos5l_fill_2
XFILLER_21_220 VPWR VGND sg13cmos5l_decap_8
XFILLER_22_721 VPWR VGND sg13cmos5l_fill_1
XFILLER_34_581 VPWR VGND sg13cmos5l_decap_8
XFILLER_34_592 VPWR VGND sg13cmos5l_fill_1
XFILLER_10_927 VPWR VGND sg13cmos5l_decap_8
XFILLER_21_264 VPWR VGND sg13cmos5l_decap_4
XFILLER_22_776 VPWR VGND sg13cmos5l_fill_2
Xhold961 _3718_/A _4358_/Q VPWR VGND sg13cmos5l_dlygate4sd3_1
XFILLER_0_102 VPWR VGND sg13cmos5l_decap_8
Xhold972 _3791_/A _4357_/Q VPWR VGND sg13cmos5l_dlygate4sd3_1
Xhold950 hold950/X _3493_/B VPWR VGND sg13cmos5l_dlygate4sd3_1
Xhold994 hold994/X _4333_/Q VPWR VGND sg13cmos5l_dlygate4sd3_1
Xhold983 _3651_/A _4328_/Q VPWR VGND sg13cmos5l_dlygate4sd3_1
XFILLER_49_618 VPWR VGND sg13cmos5l_decap_8
XFILLER_28_31 VPWR VGND sg13cmos5l_fill_2
XFILLER_29_342 VPWR VGND sg13cmos5l_fill_2
XFILLER_28_97 VPWR VGND sg13cmos5l_fill_2
XFILLER_45_868 VPWR VGND sg13cmos5l_decap_8
XFILLER_44_74 VPWR VGND sg13cmos5l_fill_1
XFILLER_44_63 VPWR VGND sg13cmos5l_decap_8
XFILLER_40_540 VPWR VGND sg13cmos5l_fill_1
XFILLER_12_264 VPWR VGND sg13cmos5l_decap_4
XFILLER_12_286 VPWR VGND sg13cmos5l_decap_4
XFILLER_5_975 VPWR VGND sg13cmos5l_decap_8
X_4278__453 _4278_/RESET_B VPWR VGND sg13cmos5l_tiehi
XFILLER_0_680 VPWR VGND sg13cmos5l_fill_2
XFILLER_0_691 VPWR VGND sg13cmos5l_decap_8
X_3070_ _3070_/Y _2227_/Y _3779_/A2 _3069_/Y VPWR VGND sg13cmos5l_a21oi_1
XFILLER_47_194 VPWR VGND sg13cmos5l_fill_2
XFILLER_44_890 VPWR VGND sg13cmos5l_decap_8
X_3972_ _4124_/D _4370_/D _3972_/B VPWR VGND sg13cmos5l_nor2_1
XFILLER_16_581 VPWR VGND sg13cmos5l_decap_8
XFILLER_16_592 VPWR VGND sg13cmos5l_fill_2
X_2923_ _2923_/Y _2854_/B _2877_/B _2922_/Y VPWR VGND sg13cmos5l_a21oi_1
X_4285__446 _4285_/RESET_B VPWR VGND sg13cmos5l_tiehi
X_2854_ _4184_/D _2918_/B _2854_/B VPWR VGND sg13cmos5l_nor2_1
X_2785_ _4173_/D _3066_/A _2785_/B VPWR VGND sg13cmos5l_and2_1
X_4359__241 _4359_/RESET_B VPWR VGND sg13cmos5l_tiehi
X_3406_ _3427_/A _4255_/Q _3403_/Y _3405_/Y VPWR VGND sg13cmos5l_o21ai_1
X_3337_ _3344_/B _4301_/Q _4302_/Q _4303_/Q VPWR VGND sg13cmos5l_nor3_1
XFILLER_39_651 VPWR VGND sg13cmos5l_fill_1
X_3268_ _3270_/B _3264_/X _3265_/Y _3267_/Y VPWR VGND sg13cmos5l_a21oi_1
X_2219_ _3751_/A _2219_/A VPWR VGND sg13cmos5l_inv_1
XFILLER_26_312 VPWR VGND sg13cmos5l_fill_1
X_3199_ _3199_/Y _3199_/A _3205_/B VPWR VGND sg13cmos5l_nor2_1
XFILLER_38_194 VPWR VGND sg13cmos5l_fill_1
XFILLER_41_304 VPWR VGND sg13cmos5l_decap_4
XFILLER_14_518 VPWR VGND sg13cmos5l_fill_1
XFILLER_42_849 VPWR VGND sg13cmos5l_decap_8
X_4366__223 _4366_/RESET_B VPWR VGND sg13cmos5l_tiehi
XFILLER_22_551 VPWR VGND sg13cmos5l_decap_8
XFILLER_6_717 VPWR VGND sg13cmos5l_fill_2
XFILLER_5_205 VPWR VGND sg13cmos5l_fill_1
XFILLER_30_32 VPWR VGND sg13cmos5l_fill_1
XFILLER_5_238 VPWR VGND sg13cmos5l_fill_2
XFILLER_30_87 VPWR VGND sg13cmos5l_fill_2
Xhold780 hold780/X _4080_/Q VPWR VGND sg13cmos5l_dlygate4sd3_1
XFILLER_2_967 VPWR VGND sg13cmos5l_decap_8
Xhold791 _4291_/D _3437_/Y VPWR VGND sg13cmos5l_dlygate4sd3_1
XFILLER_7_1005 VPWR VGND sg13cmos5l_decap_8
XFILLER_39_74 VPWR VGND sg13cmos5l_decap_8
XFILLER_18_868 VPWR VGND sg13cmos5l_decap_8
XFILLER_26_890 VPWR VGND sg13cmos5l_decap_4
XFILLER_13_551 VPWR VGND sg13cmos5l_decap_8
X_4087__297 _4087_/RESET_B VPWR VGND sg13cmos5l_tiehi
X_2570_ _2570_/Y _4146_/Q _2570_/B VPWR VGND sg13cmos5l_nand2b_1
X_4240_ _4240_/Q _4272_/CLK _4240_/D _4240_/RESET_B VPWR VGND sg13cmos5l_dfrbpq_1
XFILLER_45_1022 VPWR VGND sg13cmos5l_decap_8
X_4171_ _4171_/Q _4225_/CLK _4171_/D _4171_/RESET_B VPWR VGND sg13cmos5l_dfrbpq_1
X_3122_ _3123_/B _3108_/Y _3111_/A _3122_/S VPWR VGND sg13cmos5l_mux2_1
X_4317__409 _4317_/RESET_B VPWR VGND sg13cmos5l_tiehi
XFILLER_49_960 VPWR VGND sg13cmos5l_decap_8
X_3053_ _3053_/Y hold920/X _3045_/Y _3052_/Y _3064_/B VPWR VGND sg13cmos5l_a22oi_1
XFILLER_23_315 VPWR VGND sg13cmos5l_decap_8
X_3955_ _4003_/D _2269_/Y _3962_/S _3954_/Y VPWR VGND sg13cmos5l_a21oi_1
X_2906_ _2906_/Y hold811/X _2910_/A2 _3066_/A VPWR VGND sg13cmos5l_o21ai_1
XFILLER_32_882 VPWR VGND sg13cmos5l_fill_1
X_3886_ _3886_/Y _3892_/A _3884_/Y _3885_/Y VPWR VGND sg13cmos5l_a21oi_1
XFILLER_31_392 VPWR VGND sg13cmos5l_fill_2
X_2837_ _2855_/B _3077_/A _4209_/Q VPWR VGND sg13cmos5l_nor2_1
X_2768_ _2768_/Y _2890_/B _2768_/B VPWR VGND sg13cmos5l_nor2_1
X_2699_ _2699_/Y _2708_/S0 _4048_/Q _2698_/Y VPWR VGND sg13cmos5l_a21oi_1
X_4003__376 _4003_/RESET_B VPWR VGND sg13cmos5l_tiehi
X_4369_ _4369_/Q _4378_/CLK _4369_/D _4369_/RESET_B VPWR VGND sg13cmos5l_dfrbpq_1
XFILLER_47_919 VPWR VGND sg13cmos5l_decap_8
XFILLER_27_610 VPWR VGND sg13cmos5l_decap_4
XFILLER_26_120 VPWR VGND sg13cmos5l_decap_8
XFILLER_41_123 VPWR VGND sg13cmos5l_decap_8
XFILLER_41_101 VPWR VGND sg13cmos5l_fill_1
XFILLER_42_668 VPWR VGND sg13cmos5l_decap_8
XFILLER_41_145 VPWR VGND sg13cmos5l_decap_8
XFILLER_41_134 VPWR VGND sg13cmos5l_fill_1
XFILLER_23_882 VPWR VGND sg13cmos5l_decap_8
X_4268__463 _4268_/RESET_B VPWR VGND sg13cmos5l_tiehi
XFILLER_10_521 VPWR VGND sg13cmos5l_decap_8
XFILLER_41_75 VPWR VGND sg13cmos5l_fill_2
XFILLER_41_53 VPWR VGND sg13cmos5l_decap_4
XFILLER_41_42 VPWR VGND sg13cmos5l_fill_1
XFILLER_41_86 VPWR VGND sg13cmos5l_decap_8
XFILLER_2_742 VPWR VGND sg13cmos5l_decap_8
XFILLER_29_1017 VPWR VGND sg13cmos5l_decap_8
XFILLER_29_1028 VPWR VGND sg13cmos5l_fill_1
X_4275__456 _4275_/RESET_B VPWR VGND sg13cmos5l_tiehi
XFILLER_49_234 VPWR VGND sg13cmos5l_decap_8
XFILLER_49_278 VPWR VGND sg13cmos5l_fill_2
XFILLER_18_610 VPWR VGND sg13cmos5l_decap_8
XFILLER_46_985 VPWR VGND sg13cmos5l_decap_8
XFILLER_17_153 VPWR VGND sg13cmos5l_fill_2
XFILLER_33_635 VPWR VGND sg13cmos5l_decap_8
X_3740_ _3740_/Y _4319_/Q _4362_/Q VPWR VGND sg13cmos5l_nand2_1
XFILLER_41_690 VPWR VGND sg13cmos5l_fill_1
X_4282__449 _4282_/RESET_B VPWR VGND sg13cmos5l_tiehi
XFILLER_9_352 VPWR VGND sg13cmos5l_decap_8
X_3671_ _3671_/Y _3661_/X _3679_/A _3670_/Y VPWR VGND sg13cmos5l_o21ai_1
XFILLER_9_363 VPWR VGND sg13cmos5l_fill_2
XFILLER_9_374 VPWR VGND sg13cmos5l_decap_8
X_2622_ _2623_/B _4104_/Q _4087_/Q _4070_/Q _4053_/Q _2665_/A _2658_/S1 VPWR VGND
+ sg13cmos5l_mux4_1
X_2553_ _2554_/B _2553_/A _4142_/Q VPWR VGND sg13cmos5l_nor2b_1
X_2484_ _2486_/C _2484_/A _2484_/B VPWR VGND sg13cmos5l_xnor2_1
X_4223_ _4223_/Q _4272_/CLK _4223_/D _4223_/RESET_B VPWR VGND sg13cmos5l_dfrbpq_1
X_4154_ _4154_/Q _4161_/CLK _4154_/D _4154_/RESET_B VPWR VGND sg13cmos5l_dfrbpq_1
X_3105_ _3111_/A _3115_/B _3105_/B VPWR VGND sg13cmos5l_nor2_1
X_4085_ _4085_/Q clkload2/A _4085_/D _4085_/RESET_B VPWR VGND sg13cmos5l_dfrbpq_1
XFILLER_28_429 VPWR VGND sg13cmos5l_fill_1
X_3036_ _3036_/Y _4240_/Q _3036_/B VPWR VGND sg13cmos5l_nand2_1
XFILLER_37_996 VPWR VGND sg13cmos5l_decap_8
XFILLER_23_134 VPWR VGND sg13cmos5l_decap_4
XFILLER_20_852 VPWR VGND sg13cmos5l_fill_1
X_3938_ _3992_/D _3964_/A0 hold667/X _3948_/S VPWR VGND sg13cmos5l_mux2_1
X_3869_ _3870_/C _3848_/A _3854_/S _3877_/C _3877_/A _3849_/Y VPWR VGND sg13cmos5l_a221oi_1
XFILLER_20_863 VPWR VGND sg13cmos5l_decap_8
XFILLER_3_517 VPWR VGND sg13cmos5l_decap_4
XFILLER_47_727 VPWR VGND sg13cmos5l_decap_8
XFILLER_46_215 VPWR VGND sg13cmos5l_decap_4
XFILLER_4_1019 VPWR VGND sg13cmos5l_decap_8
XFILLER_28_974 VPWR VGND sg13cmos5l_decap_8
XFILLER_36_42 VPWR VGND sg13cmos5l_fill_1
XFILLER_36_64 VPWR VGND sg13cmos5l_decap_8
XFILLER_43_933 VPWR VGND sg13cmos5l_decap_8
XFILLER_14_101 VPWR VGND sg13cmos5l_fill_2
XFILLER_14_145 VPWR VGND sg13cmos5l_decap_8
XFILLER_15_668 VPWR VGND sg13cmos5l_decap_8
XFILLER_42_498 VPWR VGND sg13cmos5l_decap_8
XFILLER_42_476 VPWR VGND sg13cmos5l_fill_2
XFILLER_35_1010 VPWR VGND sg13cmos5l_decap_8
XFILLER_7_801 VPWR VGND sg13cmos5l_decap_8
XFILLER_11_830 VPWR VGND sg13cmos5l_fill_1
XFILLER_23_690 VPWR VGND sg13cmos5l_decap_8
XFILLER_7_867 VPWR VGND sg13cmos5l_decap_8
XFILLER_7_878 VPWR VGND sg13cmos5l_fill_1
XFILLER_42_8 VPWR VGND sg13cmos5l_fill_2
XFILLER_2_550 VPWR VGND sg13cmos5l_decap_4
XFILLER_2_572 VPWR VGND sg13cmos5l_fill_2
XFILLER_42_1003 VPWR VGND sg13cmos5l_decap_8
XFILLER_19_974 VPWR VGND sg13cmos5l_decap_8
XFILLER_46_782 VPWR VGND sg13cmos5l_decap_8
XFILLER_45_270 VPWR VGND sg13cmos5l_fill_2
XFILLER_33_476 VPWR VGND sg13cmos5l_fill_1
XFILLER_33_487 VPWR VGND sg13cmos5l_decap_4
XFILLER_34_999 VPWR VGND sg13cmos5l_decap_8
X_3723_ _3723_/X _3695_/A _3722_/Y _3731_/S VPWR VGND sg13cmos5l_mux2_1
X_3654_ _3656_/C _3567_/B _3654_/B _3654_/C VPWR VGND sg13cmos5l_nand3b_1
XFILLER_9_171 VPWR VGND sg13cmos5l_decap_4
X_2605_ _2606_/A _4098_/Q _4081_/Q _4064_/Q _4047_/Q _2708_/S0 _2708_/S1 VPWR VGND
+ sg13cmos5l_mux4_1
X_3585_ _3585_/Y _3822_/A _3783_/A VPWR VGND sg13cmos5l_nor2b_1
X_2536_ _2538_/A _4225_/Q _4320_/Q _4288_/Q VPWR VGND sg13cmos5l_nor3_1
X_2467_ _4117_/D _2516_/A _2467_/B VPWR VGND sg13cmos5l_nor2_1
X_4206_ _4206_/Q _4234_/CLK _4206_/D _4206_/RESET_B VPWR VGND sg13cmos5l_dfrbpq_1
X_2398_ _4074_/D _2438_/A0 hold773/X _2400_/S VPWR VGND sg13cmos5l_mux2_1
X_4371__539 _4371_/RESET_B VPWR VGND sg13cmos5l_tiehi
X_4137_ _4137_/Q clkload4/A _4137_/D _4137_/RESET_B VPWR VGND sg13cmos5l_dfrbpq_1
XFILLER_29_749 VPWR VGND sg13cmos5l_decap_8
XFILLER_37_760 VPWR VGND sg13cmos5l_decap_8
X_4068_ _4068_/Q clkload2/A _4068_/D _4068_/RESET_B VPWR VGND sg13cmos5l_dfrbpq_1
X_3019_ _3021_/C _3019_/A _3026_/A VPWR VGND sg13cmos5l_xor2_1
X_4265__466 _4265_/RESET_B VPWR VGND sg13cmos5l_tiehi
X_3985__548 _3985_/RESET_B VPWR VGND sg13cmos5l_tiehi
XFILLER_22_66 VPWR VGND sg13cmos5l_fill_2
XFILLER_4_815 VPWR VGND sg13cmos5l_decap_8
XFILLER_47_535 VPWR VGND sg13cmos5l_decap_8
X_4272__459 _4272_/RESET_B VPWR VGND sg13cmos5l_tiehi
XFILLER_16_944 VPWR VGND sg13cmos5l_decap_8
X_4172__582 _4172_/RESET_B VPWR VGND sg13cmos5l_tiehi
XFILLER_15_443 VPWR VGND sg13cmos5l_fill_1
XFILLER_31_914 VPWR VGND sg13cmos5l_fill_2
XFILLER_30_424 VPWR VGND sg13cmos5l_decap_4
XFILLER_30_479 VPWR VGND sg13cmos5l_fill_2
Xhold609 _4290_/D _3435_/Y VPWR VGND sg13cmos5l_dlygate4sd3_1
XFILLER_6_185 VPWR VGND sg13cmos5l_fill_2
X_3370_ _3371_/C _4247_/Q _4246_/Q _4248_/Q VPWR VGND sg13cmos5l_o21ai_1
X_3997__408 _3997_/RESET_B VPWR VGND sg13cmos5l_tiehi
X_2321_ _4376_/D _4374_/D _4375_/D _4373_/D VPWR VGND sg13cmos5l_or3_1
X_2252_ _3785_/A _2252_/A VPWR VGND sg13cmos5l_inv_1
XFILLER_2_391 VPWR VGND sg13cmos5l_decap_8
XFILLER_19_760 VPWR VGND sg13cmos5l_fill_1
XFILLER_25_207 VPWR VGND sg13cmos5l_decap_8
XFILLER_34_796 VPWR VGND sg13cmos5l_decap_8
XFILLER_21_424 VPWR VGND sg13cmos5l_fill_2
XFILLER_21_446 VPWR VGND sg13cmos5l_decap_8
XFILLER_22_947 VPWR VGND sg13cmos5l_decap_8
X_3706_ _3715_/B _4341_/Q _3707_/B VPWR VGND sg13cmos5l_nor2b_1
XFILLER_49_1009 VPWR VGND sg13cmos5l_decap_8
X_3637_ _3637_/Y _4322_/Q _4293_/Q VPWR VGND sg13cmos5l_xnor2_1
X_3568_ _3568_/Y _3556_/B _3549_/C _3565_/B _3356_/B _3547_/X VPWR VGND sg13cmos5l_a221oi_1
X_2519_ _2519_/Y _3881_/A _2291_/Y _4376_/Q VPWR VGND sg13cmos5l_o21ai_1
X_3499_ _4301_/D _3475_/X _3500_/A _3498_/Y VPWR VGND sg13cmos5l_a21oi_1
XFILLER_29_579 VPWR VGND sg13cmos5l_fill_1
XFILLER_29_568 VPWR VGND sg13cmos5l_decap_8
XFILLER_16_218 VPWR VGND sg13cmos5l_decap_8
XFILLER_16_229 VPWR VGND sg13cmos5l_fill_1
XFILLER_17_55 VPWR VGND sg13cmos5l_decap_8
XFILLER_13_914 VPWR VGND sg13cmos5l_fill_2
XFILLER_13_925 VPWR VGND sg13cmos5l_decap_8
XFILLER_40_744 VPWR VGND sg13cmos5l_fill_2
XFILLER_40_722 VPWR VGND sg13cmos5l_decap_4
XFILLER_12_446 VPWR VGND sg13cmos5l_fill_2
XFILLER_33_32 VPWR VGND sg13cmos5l_decap_8
XFILLER_32_1002 VPWR VGND sg13cmos5l_decap_8
XFILLER_4_623 VPWR VGND sg13cmos5l_fill_2
XFILLER_4_612 VPWR VGND sg13cmos5l_decap_8
XFILLER_4_656 VPWR VGND sg13cmos5l_decap_8
XFILLER_3_144 VPWR VGND sg13cmos5l_fill_2
XFILLER_3_166 VPWR VGND sg13cmos5l_decap_8
XFILLER_0_851 VPWR VGND sg13cmos5l_decap_8
XFILLER_48_866 VPWR VGND sg13cmos5l_decap_8
XFILLER_47_354 VPWR VGND sg13cmos5l_fill_2
X_2870_ _2870_/Y _2870_/A _2874_/A VPWR VGND sg13cmos5l_nor2_1
XFILLER_31_766 VPWR VGND sg13cmos5l_fill_2
XFILLER_31_788 VPWR VGND sg13cmos5l_decap_8
XFILLER_31_799 VPWR VGND sg13cmos5l_fill_1
Xclkbuf_leaf_10_clk _4181_/CLK clkload0/A VPWR VGND sg13cmos5l_buf_8
XFILLER_8_962 VPWR VGND sg13cmos5l_decap_8
XFILLER_48_1020 VPWR VGND sg13cmos5l_decap_8
X_3422_ _3423_/B _3588_/B _3413_/Y _3426_/B VPWR VGND sg13cmos5l_mux2_1
X_3353_ _3447_/B _3357_/B _3357_/D _3565_/A VPWR VGND sg13cmos5l_a21oi_1
X_2304_ _3882_/B _2305_/A _2304_/B VPWR VGND sg13cmos5l_nor2_1
X_3284_ _3307_/A _4265_/Q _3296_/B _3300_/A VPWR VGND sg13cmos5l_a21o_1
X_2235_ _2235_/Y _2235_/A VPWR VGND sg13cmos5l_inv_1
XFILLER_22_711 VPWR VGND sg13cmos5l_fill_1
X_2999_ _3113_/A _2977_/X _3205_/A _2999_/S VPWR VGND sg13cmos5l_mux2_1
X_4145__212 _4145_/RESET_B VPWR VGND sg13cmos5l_tiehi
X_4262__469 _4262_/RESET_B VPWR VGND sg13cmos5l_tiehi
Xhold940 _2249_/A _4304_/Q VPWR VGND sg13cmos5l_dlygate4sd3_1
Xhold951 _2561_/B _4142_/Q VPWR VGND sg13cmos5l_dlygate4sd3_1
Xhold962 _3720_/B _3719_/X VPWR VGND sg13cmos5l_dlygate4sd3_1
XFILLER_1_626 VPWR VGND sg13cmos5l_decap_8
Xhold973 hold973/X _3806_/B VPWR VGND sg13cmos5l_dlygate4sd3_1
Xhold995 _4354_/D _3783_/X VPWR VGND sg13cmos5l_dlygate4sd3_1
Xhold984 _3652_/B _3651_/Y VPWR VGND sg13cmos5l_dlygate4sd3_1
XFILLER_0_158 VPWR VGND sg13cmos5l_decap_8
XFILLER_28_21 VPWR VGND sg13cmos5l_fill_1
XFILLER_45_847 VPWR VGND sg13cmos5l_decap_8
XFILLER_44_324 VPWR VGND sg13cmos5l_decap_8
XFILLER_29_398 VPWR VGND sg13cmos5l_decap_8
XFILLER_13_700 VPWR VGND sg13cmos5l_decap_8
XFILLER_32_508 VPWR VGND sg13cmos5l_decap_8
XFILLER_32_519 VPWR VGND sg13cmos5l_decap_8
XFILLER_44_86 VPWR VGND sg13cmos5l_decap_4
XFILLER_12_210 VPWR VGND sg13cmos5l_decap_8
XFILLER_12_221 VPWR VGND sg13cmos5l_fill_2
XFILLER_8_203 VPWR VGND sg13cmos5l_fill_2
XFILLER_9_715 VPWR VGND sg13cmos5l_fill_2
XFILLER_40_585 VPWR VGND sg13cmos5l_decap_8
XFILLER_8_214 VPWR VGND sg13cmos5l_decap_8
XFILLER_9_759 VPWR VGND sg13cmos5l_fill_2
XFILLER_8_247 VPWR VGND sg13cmos5l_fill_2
XFILLER_5_954 VPWR VGND sg13cmos5l_decap_8
XFILLER_5_36 VPWR VGND sg13cmos5l_fill_1
XFILLER_4_453 VPWR VGND sg13cmos5l_decap_8
XFILLER_35_302 VPWR VGND sg13cmos5l_decap_4
XFILLER_39_1019 VPWR VGND sg13cmos5l_decap_8
X_3971_ _4016_/D _3971_/A0 hold774/X _3971_/S VPWR VGND sg13cmos5l_mux2_1
X_2922_ _2922_/Y _2941_/B _2941_/A VPWR VGND sg13cmos5l_nor2b_1
XFILLER_16_571 VPWR VGND sg13cmos5l_decap_4
X_2853_ _2853_/X _2831_/Y _2845_/B _2851_/Y VPWR VGND sg13cmos5l_a21o_1
X_2784_ _2784_/Y _2231_/Y _2784_/A2 _2783_/Y VPWR VGND sg13cmos5l_a21oi_1
XFILLER_8_781 VPWR VGND sg13cmos5l_fill_1
XFILLER_8_770 VPWR VGND sg13cmos5l_decap_8
XFILLER_7_291 VPWR VGND sg13cmos5l_decap_4
X_3405_ _3405_/Y _4302_/Q _3621_/A _3405_/C VPWR VGND sg13cmos5l_nand3_1
X_3336_ _3336_/Y _3336_/A _3336_/B _3336_/C VPWR VGND sg13cmos5l_nor3_1
XFILLER_39_663 VPWR VGND sg13cmos5l_decap_8
XFILLER_39_641 VPWR VGND sg13cmos5l_decap_4
X_3267_ _3267_/Y _3167_/B _3208_/B _3266_/Y VPWR VGND sg13cmos5l_o21ai_1
X_2218_ _2218_/Y _2218_/A VPWR VGND sg13cmos5l_inv_1
X_3198_ _4246_/D _3272_/A _3272_/B _3258_/B VPWR VGND sg13cmos5l_a21oi_1
XFILLER_26_302 VPWR VGND sg13cmos5l_fill_1
XFILLER_27_847 VPWR VGND sg13cmos5l_decap_8
XFILLER_26_368 VPWR VGND sg13cmos5l_fill_1
XFILLER_22_574 VPWR VGND sg13cmos5l_decap_8
XFILLER_22_585 VPWR VGND sg13cmos5l_decap_8
XFILLER_6_729 VPWR VGND sg13cmos5l_decap_8
XFILLER_5_228 VPWR VGND sg13cmos5l_fill_1
XFILLER_30_99 VPWR VGND sg13cmos5l_decap_8
XFILLER_2_946 VPWR VGND sg13cmos5l_decap_8
XFILLER_1_423 VPWR VGND sg13cmos5l_decap_8
Xhold770 hold770/X _4103_/Q VPWR VGND sg13cmos5l_dlygate4sd3_1
Xhold781 hold781/X _4090_/Q VPWR VGND sg13cmos5l_dlygate4sd3_1
XFILLER_49_405 VPWR VGND sg13cmos5l_fill_2
XFILLER_39_42 VPWR VGND sg13cmos5l_decap_4
Xhold792 hold792/X _4057_/Q VPWR VGND sg13cmos5l_dlygate4sd3_1
XFILLER_7_1028 VPWR VGND sg13cmos5l_fill_1
XFILLER_45_1001 VPWR VGND sg13cmos5l_decap_8
XFILLER_4_272 VPWR VGND sg13cmos5l_decap_8
X_4170_ _4170_/Q _4378_/CLK _4170_/D _4170_/RESET_B VPWR VGND sg13cmos5l_dfrbpq_1
X_3121_ _4236_/D _3094_/Y _3122_/S _3120_/Y VPWR VGND sg13cmos5l_a21oi_1
X_3052_ _3052_/Y _4240_/Q _3259_/A VPWR VGND sg13cmos5l_nand2b_1
X_3954_ _3954_/Y _3954_/A _3962_/S VPWR VGND sg13cmos5l_nor2_1
X_3885_ _3885_/Y _2210_/A _3892_/A _3890_/B1 VPWR VGND sg13cmos5l_o21ai_1
X_2905_ _4195_/D _2905_/A _2905_/B VPWR VGND sg13cmos5l_and2_1
X_2836_ _2851_/B _2821_/Y _2822_/X _2828_/X _2832_/Y _2833_/X VPWR VGND sg13cmos5l_a221oi_1
X_2767_ _2767_/Y _2890_/B _2768_/B _2764_/X VPWR VGND sg13cmos5l_a21oi_1
X_2698_ _2698_/Y _2698_/A _4065_/Q VPWR VGND sg13cmos5l_nor2b_1
XFILLER_2_209 VPWR VGND sg13cmos5l_fill_1
X_4368_ _4368_/Q _4378_/CLK _4368_/D _4368_/RESET_B VPWR VGND sg13cmos5l_dfrbpq_1
X_4299_ _4299_/Q _4302_/CLK _4299_/D _4299_/RESET_B VPWR VGND sg13cmos5l_dfrbpq_1
X_3319_ _3320_/C _3319_/A _3318_/A VPWR VGND sg13cmos5l_nor2b_1
XFILLER_27_655 VPWR VGND sg13cmos5l_decap_8
XFILLER_42_625 VPWR VGND sg13cmos5l_decap_8
XFILLER_26_198 VPWR VGND sg13cmos5l_fill_2
XFILLER_27_699 VPWR VGND sg13cmos5l_fill_2
XFILLER_23_850 VPWR VGND sg13cmos5l_decap_4
XFILLER_25_77 VPWR VGND sg13cmos5l_fill_2
XFILLER_25_88 VPWR VGND sg13cmos5l_decap_4
XFILLER_10_544 VPWR VGND sg13cmos5l_fill_1
XFILLER_6_526 VPWR VGND sg13cmos5l_decap_4
XFILLER_10_555 VPWR VGND sg13cmos5l_decap_8
XFILLER_10_577 VPWR VGND sg13cmos5l_fill_1
X_4199__547 _4199_/RESET_B VPWR VGND sg13cmos5l_tiehi
XFILLER_49_213 VPWR VGND sg13cmos5l_decap_8
XFILLER_2_48 VPWR VGND sg13cmos5l_fill_2
XFILLER_46_964 VPWR VGND sg13cmos5l_decap_8
X_4093__291 _4093_/RESET_B VPWR VGND sg13cmos5l_tiehi
XFILLER_18_688 VPWR VGND sg13cmos5l_fill_1
XFILLER_14_850 VPWR VGND sg13cmos5l_decap_8
XFILLER_9_342 VPWR VGND sg13cmos5l_decap_4
X_3670_ _3670_/Y _3672_/A _3672_/B VPWR VGND sg13cmos5l_nand2_1
X_2621_ _2621_/Y _2657_/A1 _2618_/X _2300_/A VPWR VGND sg13cmos5l_o21ai_1
X_2552_ _2552_/Y _2567_/A VPWR VGND sg13cmos5l_inv_1
X_2483_ _4121_/D _2516_/A _2483_/B VPWR VGND sg13cmos5l_nor2_1
X_4222_ _4222_/Q _4272_/CLK _4222_/D _4222_/RESET_B VPWR VGND sg13cmos5l_dfrbpq_1
X_4153_ _4153_/Q _4225_/CLK _4153_/D _4153_/RESET_B VPWR VGND sg13cmos5l_dfrbpq_1
X_4084_ _4084_/Q clkload8/A _4084_/D _4084_/RESET_B VPWR VGND sg13cmos5l_dfrbpq_1
X_3104_ _3105_/B _4233_/Q _3104_/B VPWR VGND sg13cmos5l_xnor2_1
X_3035_ _3036_/B _4194_/Q _4239_/Q VPWR VGND sg13cmos5l_nand2_1
XFILLER_37_975 VPWR VGND sg13cmos5l_decap_8
X_3937_ _3946_/B _3937_/A _3949_/B VPWR VGND sg13cmos5l_nand2_1
X_3868_ _3870_/B _3868_/A _3877_/A _3877_/C VPWR VGND sg13cmos5l_and3_1
XFILLER_20_886 VPWR VGND sg13cmos5l_fill_2
XFILLER_31_190 VPWR VGND sg13cmos5l_decap_8
X_2819_ _4181_/D _2789_/B _2803_/B _4159_/D VPWR VGND sg13cmos5l_a21o_1
X_3799_ _3860_/B _4356_/Q _3802_/B VPWR VGND sg13cmos5l_nand2_1
X_4146__181 _4146_/D VPWR VGND sg13cmos5l_tielo
XFILLER_3_507 VPWR VGND sg13cmos5l_decap_4
XFILLER_2_8 VPWR VGND sg13cmos5l_decap_4
XFILLER_46_205 VPWR VGND sg13cmos5l_decap_4
XFILLER_46_238 VPWR VGND sg13cmos5l_fill_2
XFILLER_43_912 VPWR VGND sg13cmos5l_decap_8
XFILLER_42_411 VPWR VGND sg13cmos5l_fill_2
XFILLER_42_400 VPWR VGND sg13cmos5l_decap_8
XFILLER_27_496 VPWR VGND sg13cmos5l_decap_8
XFILLER_43_989 VPWR VGND sg13cmos5l_decap_8
XFILLER_23_680 VPWR VGND sg13cmos5l_decap_4
XFILLER_7_824 VPWR VGND sg13cmos5l_fill_1
XFILLER_10_341 VPWR VGND sg13cmos5l_decap_8
XFILLER_22_190 VPWR VGND sg13cmos5l_fill_1
X_4281__450 _4281_/RESET_B VPWR VGND sg13cmos5l_tiehi
XFILLER_6_378 VPWR VGND sg13cmos5l_decap_8
XFILLER_6_356 VPWR VGND sg13cmos5l_fill_1
XFILLER_6_345 VPWR VGND sg13cmos5l_decap_8
XFILLER_46_761 VPWR VGND sg13cmos5l_decap_8
XFILLER_34_912 VPWR VGND sg13cmos5l_fill_2
XFILLER_34_934 VPWR VGND sg13cmos5l_decap_4
XFILLER_34_945 VPWR VGND sg13cmos5l_decap_4
XFILLER_33_433 VPWR VGND sg13cmos5l_decap_4
XFILLER_34_978 VPWR VGND sg13cmos5l_decap_8
XFILLER_21_606 VPWR VGND sg13cmos5l_fill_1
X_3722_ _3722_/Y _3722_/A VPWR VGND sg13cmos5l_inv_1
X_3653_ _3656_/B _3654_/B _3654_/C _3626_/A VPWR VGND sg13cmos5l_a21o_1
XFILLER_9_194 VPWR VGND sg13cmos5l_decap_8
X_2604_ _2604_/X _4030_/Q _4013_/Q _3996_/Q _3979_/Q _2701_/S _2704_/A1 VPWR VGND
+ sg13cmos5l_mux4_1
X_3584_ _3584_/Y _4287_/Q _4284_/Q VPWR VGND sg13cmos5l_nor2b_1
X_2535_ _2535_/Y _2535_/A _2535_/B _2535_/C _2535_/D VPWR VGND sg13cmos5l_nand4_1
X_2466_ _2466_/Y _2461_/B _4117_/Q _2456_/B hold664/X VPWR VGND sg13cmos5l_a22oi_1
X_4205_ _4205_/Q _4234_/CLK _4205_/D _4205_/RESET_B VPWR VGND sg13cmos5l_dfrbpq_1
X_4136_ _4136_/Q _4136_/CLK _4136_/D _4136_/RESET_B VPWR VGND sg13cmos5l_dfrbpq_1
X_2397_ _4073_/D _2437_/A0 hold698/X _2400_/S VPWR VGND sg13cmos5l_mux2_1
XFILLER_29_728 VPWR VGND sg13cmos5l_decap_8
XFILLER_3_1020 VPWR VGND sg13cmos5l_decap_8
X_4067_ _4067_/Q clkload8/A _4067_/D _4067_/RESET_B VPWR VGND sg13cmos5l_dfrbpq_1
XFILLER_25_901 VPWR VGND sg13cmos5l_decap_8
X_3018_ _3018_/Y _3019_/A _3026_/A VPWR VGND sg13cmos5l_xnor2_1
XFILLER_25_912 VPWR VGND sg13cmos5l_fill_1
XFILLER_24_444 VPWR VGND sg13cmos5l_decap_4
XFILLER_40_915 VPWR VGND sg13cmos5l_decap_4
X_4287__158 _4287_/D VPWR VGND sg13cmos5l_tielo
XFILLER_19_1028 VPWR VGND sg13cmos5l_fill_1
XFILLER_40_959 VPWR VGND sg13cmos5l_decap_8
XFILLER_7_109 VPWR VGND sg13cmos5l_decap_8
XFILLER_22_23 VPWR VGND sg13cmos5l_decap_4
XFILLER_20_683 VPWR VGND sg13cmos5l_fill_2
XFILLER_47_514 VPWR VGND sg13cmos5l_decap_8
XFILLER_47_64 VPWR VGND sg13cmos5l_fill_2
XFILLER_19_216 VPWR VGND sg13cmos5l_fill_1
XFILLER_47_75 VPWR VGND sg13cmos5l_fill_1
XFILLER_27_271 VPWR VGND sg13cmos5l_fill_1
XFILLER_34_208 VPWR VGND sg13cmos5l_decap_8
XFILLER_34_219 VPWR VGND sg13cmos5l_decap_4
XFILLER_42_230 VPWR VGND sg13cmos5l_fill_1
X_4090__294 _4090_/RESET_B VPWR VGND sg13cmos5l_tiehi
XFILLER_42_241 VPWR VGND sg13cmos5l_fill_1
X_4012__229 _4012_/RESET_B VPWR VGND sg13cmos5l_tiehi
XFILLER_30_447 VPWR VGND sg13cmos5l_fill_1
XFILLER_8_36 VPWR VGND sg13cmos5l_decap_4
XFILLER_11_661 VPWR VGND sg13cmos5l_fill_2
XFILLER_11_683 VPWR VGND sg13cmos5l_decap_8
XFILLER_11_694 VPWR VGND sg13cmos5l_fill_1
XFILLER_6_197 VPWR VGND sg13cmos5l_decap_4
X_2320_ _4373_/D _2318_/Y _2319_/Y _3916_/A VPWR VGND sg13cmos5l_a21oi_1
X_2251_ _3532_/A _3783_/A VPWR VGND sg13cmos5l_inv_1
XFILLER_26_4 VPWR VGND sg13cmos5l_fill_2
XFILLER_38_514 VPWR VGND sg13cmos5l_fill_2
XFILLER_19_772 VPWR VGND sg13cmos5l_decap_8
XFILLER_46_580 VPWR VGND sg13cmos5l_decap_8
XFILLER_34_775 VPWR VGND sg13cmos5l_fill_2
X_3705_ _3712_/A _4362_/Q _3705_/B VPWR VGND sg13cmos5l_xor2_1
X_3636_ _3636_/Y _4321_/Q _4292_/Q VPWR VGND sg13cmos5l_xnor2_1
X_3567_ _4311_/D _3619_/B _3567_/B VPWR VGND sg13cmos5l_nor2_1
X_2518_ _2518_/Y _2518_/A _2539_/A VPWR VGND sg13cmos5l_nand2_1
X_3498_ _3498_/Y _3476_/A _3500_/A _3444_/B VPWR VGND sg13cmos5l_o21ai_1
X_2449_ _3973_/B _2449_/A _2449_/B VPWR VGND sg13cmos5l_nand2_1
X_4119_ _4119_/Q _4363_/CLK _4119_/D _4119_/RESET_B VPWR VGND sg13cmos5l_dfrbpq_1
XFILLER_17_709 VPWR VGND sg13cmos5l_decap_8
X_4271__460 _4271_/RESET_B VPWR VGND sg13cmos5l_tiehi
XFILLER_37_591 VPWR VGND sg13cmos5l_fill_2
XFILLER_25_731 VPWR VGND sg13cmos5l_decap_8
XFILLER_40_701 VPWR VGND sg13cmos5l_decap_8
XFILLER_24_252 VPWR VGND sg13cmos5l_fill_1
XFILLER_12_425 VPWR VGND sg13cmos5l_decap_8
XFILLER_8_429 VPWR VGND sg13cmos5l_decap_8
XFILLER_20_491 VPWR VGND sg13cmos5l_fill_2
XFILLER_3_112 VPWR VGND sg13cmos5l_decap_4
XFILLER_0_830 VPWR VGND sg13cmos5l_decap_8
XFILLER_48_845 VPWR VGND sg13cmos5l_decap_8
XFILLER_35_539 VPWR VGND sg13cmos5l_decap_8
XFILLER_16_720 VPWR VGND sg13cmos5l_fill_2
XFILLER_31_723 VPWR VGND sg13cmos5l_decap_8
XFILLER_8_941 VPWR VGND sg13cmos5l_decap_8
XFILLER_12_992 VPWR VGND sg13cmos5l_decap_8
XFILLER_11_491 VPWR VGND sg13cmos5l_decap_8
X_3421_ _3426_/B _3420_/Y _3421_/B VPWR VGND sg13cmos5l_nand2b_1
X_3352_ _3447_/A _3357_/B _3352_/B _3357_/D VPWR VGND sg13cmos5l_and3_1
X_2303_ _3907_/A _3911_/B VPWR VGND sg13cmos5l_inv_1
X_3283_ _3300_/A _3299_/A _3299_/B _3299_/C VPWR VGND sg13cmos5l_a21oi_1
X_2234_ _2234_/Y _4145_/Q VPWR VGND sg13cmos5l_inv_1
XFILLER_39_823 VPWR VGND sg13cmos5l_decap_8
XFILLER_38_355 VPWR VGND sg13cmos5l_fill_1
XFILLER_17_0 VPWR VGND sg13cmos5l_fill_1
XFILLER_0_70 VPWR VGND sg13cmos5l_decap_8
XFILLER_0_1012 VPWR VGND sg13cmos5l_decap_8
XFILLER_21_200 VPWR VGND sg13cmos5l_fill_2
XFILLER_22_778 VPWR VGND sg13cmos5l_fill_1
XFILLER_9_90 VPWR VGND sg13cmos5l_fill_1
X_2998_ _3205_/A _2998_/A _3175_/A VPWR VGND sg13cmos5l_nand2_1
Xhold930 _2813_/A _2801_/Y VPWR VGND sg13cmos5l_dlygate4sd3_1
X_3619_ _4329_/D _3619_/A _3619_/B VPWR VGND sg13cmos5l_nor2_1
Xhold952 _2566_/C _2561_/Y VPWR VGND sg13cmos5l_dlygate4sd3_1
Xhold941 _2934_/A _4205_/Q VPWR VGND sg13cmos5l_dlygate4sd3_1
Xhold963 _2794_/A _4178_/Q VPWR VGND sg13cmos5l_dlygate4sd3_1
Xhold996 hold996/X _4190_/Q VPWR VGND sg13cmos5l_dlygate4sd3_1
Xhold985 _3477_/A _4295_/Q VPWR VGND sg13cmos5l_dlygate4sd3_1
Xhold974 _3306_/A _4266_/Q VPWR VGND sg13cmos5l_dlygate4sd3_1
XFILLER_0_137 VPWR VGND sg13cmos5l_decap_8
XFILLER_29_344 VPWR VGND sg13cmos5l_fill_1
XFILLER_45_826 VPWR VGND sg13cmos5l_decap_8
XFILLER_40_520 VPWR VGND sg13cmos5l_fill_1
XFILLER_13_767 VPWR VGND sg13cmos5l_fill_2
XFILLER_5_933 VPWR VGND sg13cmos5l_decap_8
XFILLER_5_15 VPWR VGND sg13cmos5l_decap_8
XFILLER_0_682 VPWR VGND sg13cmos5l_fill_1
XFILLER_48_653 VPWR VGND sg13cmos5l_decap_8
XFILLER_36_848 VPWR VGND sg13cmos5l_decap_8
XFILLER_16_550 VPWR VGND sg13cmos5l_decap_8
XFILLER_23_509 VPWR VGND sg13cmos5l_fill_2
XFILLER_35_369 VPWR VGND sg13cmos5l_fill_2
X_3970_ _4015_/D input12/X hold808/X _3971_/S VPWR VGND sg13cmos5l_mux2_1
X_2921_ _2921_/Y _2854_/B _2877_/B _2920_/Y VPWR VGND sg13cmos5l_o21ai_1
X_2852_ _2854_/B _2831_/Y _2845_/B _2851_/Y VPWR VGND sg13cmos5l_a21oi_1
X_2783_ _2783_/Y _4172_/Q _2784_/A2 _2718_/A VPWR VGND sg13cmos5l_o21ai_1
X_4261__470 _4261_/RESET_B VPWR VGND sg13cmos5l_tiehi
X_3404_ _3405_/C _4304_/Q _3244_/A _3411_/B VPWR VGND sg13cmos5l_o21ai_1
X_3335_ _3336_/C _3618_/A _3334_/B _3352_/B VPWR VGND sg13cmos5l_a21oi_1
X_3266_ _3266_/Y _3266_/A _3305_/B VPWR VGND sg13cmos5l_nand2_1
X_2217_ _2217_/Y _2217_/A VPWR VGND sg13cmos5l_inv_1
XFILLER_27_815 VPWR VGND sg13cmos5l_fill_2
X_3197_ _3272_/B _3197_/A _3197_/B VPWR VGND sg13cmos5l_nand2_1
XFILLER_10_704 VPWR VGND sg13cmos5l_decap_8
XFILLER_10_748 VPWR VGND sg13cmos5l_decap_4
XFILLER_6_719 VPWR VGND sg13cmos5l_fill_1
XFILLER_2_925 VPWR VGND sg13cmos5l_decap_8
XFILLER_30_89 VPWR VGND sg13cmos5l_fill_1
Xhold771 hold771/X _4061_/Q VPWR VGND sg13cmos5l_dlygate4sd3_1
Xhold782 hold782/X _4013_/Q VPWR VGND sg13cmos5l_dlygate4sd3_1
Xhold760 _3444_/A _4271_/Q VPWR VGND sg13cmos5l_dlygate4sd3_1
Xhold793 hold793/X _4056_/Q VPWR VGND sg13cmos5l_dlygate4sd3_1
XFILLER_44_199 VPWR VGND sg13cmos5l_fill_1
XFILLER_9_502 VPWR VGND sg13cmos5l_decap_8
XFILLER_13_586 VPWR VGND sg13cmos5l_fill_2
XFILLER_5_774 VPWR VGND sg13cmos5l_decap_8
XFILLER_5_785 VPWR VGND sg13cmos5l_fill_2
X_3120_ _3120_/Y _3102_/X _3122_/S _3123_/A VPWR VGND sg13cmos5l_o21ai_1
XFILLER_49_995 VPWR VGND sg13cmos5l_decap_8
X_3051_ _3051_/Y _4221_/Q _3059_/A _3046_/Y VPWR VGND sg13cmos5l_o21ai_1
XFILLER_35_144 VPWR VGND sg13cmos5l_decap_8
XFILLER_23_306 VPWR VGND sg13cmos5l_decap_4
X_3953_ _4002_/D _2264_/Y _3962_/S _3952_/Y VPWR VGND sg13cmos5l_a21oi_1
XFILLER_16_380 VPWR VGND sg13cmos5l_decap_8
XFILLER_32_851 VPWR VGND sg13cmos5l_fill_2
X_3884_ _3884_/Y _2210_/Y _3881_/A _3896_/B VPWR VGND sg13cmos5l_a21oi_1
X_2904_ _2904_/Y _2894_/Y hold898/X _2960_/A VPWR VGND sg13cmos5l_a21oi_1
X_2835_ _2835_/X _2828_/X _2832_/Y _2833_/X VPWR VGND sg13cmos5l_a21o_1
XFILLER_31_372 VPWR VGND sg13cmos5l_decap_4
XFILLER_31_394 VPWR VGND sg13cmos5l_fill_1
X_4142__216 _4142_/RESET_B VPWR VGND sg13cmos5l_tiehi
X_2766_ _2768_/B _2570_/Y _2765_/C _2765_/Y VPWR VGND sg13cmos5l_o21ai_1
X_2697_ _2697_/Y _2698_/A _4082_/Q _2700_/B2 VPWR VGND sg13cmos5l_a21oi_1
X_4367_ _4367_/Q _4377_/CLK _4367_/D _4367_/RESET_B VPWR VGND sg13cmos5l_dfrbpq_1
X_3318_ _3320_/B _3318_/A _3300_/X VPWR VGND sg13cmos5l_nor2b_1
X_4298_ _4298_/Q _4302_/CLK _4298_/D _4298_/RESET_B VPWR VGND sg13cmos5l_dfrbpq_1
XFILLER_39_450 VPWR VGND sg13cmos5l_fill_2
X_3249_ _3249_/Y hold653/X _3251_/A2 _3254_/A VPWR VGND sg13cmos5l_o21ai_1
XFILLER_39_472 VPWR VGND sg13cmos5l_decap_8
XFILLER_27_645 VPWR VGND sg13cmos5l_decap_4
XFILLER_15_829 VPWR VGND sg13cmos5l_fill_1
XFILLER_22_361 VPWR VGND sg13cmos5l_fill_2
XFILLER_6_505 VPWR VGND sg13cmos5l_decap_8
X_4344__375 _4344_/RESET_B VPWR VGND sg13cmos5l_tiehi
Xhold590 _3073_/B _4199_/Q VPWR VGND sg13cmos5l_dlygate4sd3_1
XFILLER_2_799 VPWR VGND sg13cmos5l_decap_8
X_4316__411 _4316_/RESET_B VPWR VGND sg13cmos5l_tiehi
XFILLER_49_258 VPWR VGND sg13cmos5l_decap_8
XFILLER_46_943 VPWR VGND sg13cmos5l_decap_8
XFILLER_45_442 VPWR VGND sg13cmos5l_decap_4
XFILLER_17_133 VPWR VGND sg13cmos5l_decap_8
XFILLER_33_626 VPWR VGND sg13cmos5l_decap_4
XFILLER_32_169 VPWR VGND sg13cmos5l_fill_2
XFILLER_13_394 VPWR VGND sg13cmos5l_decap_4
X_2620_ _2620_/Y _2632_/S _3985_/Q _2619_/Y VPWR VGND sg13cmos5l_a21oi_1
X_2551_ _2567_/A _2778_/B _3066_/A VPWR VGND sg13cmos5l_nand2b_1
X_2482_ _2483_/B _2478_/A _2481_/A _2481_/Y VPWR VGND sg13cmos5l_o21ai_1
X_4221_ _4221_/Q _4262_/CLK _4221_/D _4221_/RESET_B VPWR VGND sg13cmos5l_dfrbpq_1
X_4152_ _4152_/Q _4225_/CLK _4152_/D _4152_/RESET_B VPWR VGND sg13cmos5l_dfrbpq_1
X_4083_ _4083_/Q clkload9/A _4083_/D _4083_/RESET_B VPWR VGND sg13cmos5l_dfrbpq_1
XFILLER_28_409 VPWR VGND sg13cmos5l_fill_2
X_3103_ _3104_/B _4232_/Q _3092_/B _3080_/Y VPWR VGND sg13cmos5l_a21oi_1
XFILLER_49_792 VPWR VGND sg13cmos5l_decap_8
X_3034_ _3034_/Y _4192_/Q _3257_/A _3258_/A _4193_/Q _3033_/Y VPWR VGND sg13cmos5l_a221oi_1
XFILLER_37_954 VPWR VGND sg13cmos5l_decap_8
XFILLER_36_453 VPWR VGND sg13cmos5l_fill_2
XFILLER_23_103 VPWR VGND sg13cmos5l_decap_4
XFILLER_24_604 VPWR VGND sg13cmos5l_decap_8
X_3936_ _3949_/B _4127_/Q _3936_/B VPWR VGND sg13cmos5l_nor2_1
X_3867_ _3877_/C _3857_/Y _3864_/Y _3866_/Y VPWR VGND sg13cmos5l_o21ai_1
X_2818_ _4180_/D _2818_/A _2818_/B _2818_/C VPWR VGND sg13cmos5l_nor3_1
X_3798_ _3798_/Y _3861_/A _3860_/A VPWR VGND sg13cmos5l_nand2_1
X_2749_ _2749_/Y _2749_/A _2749_/B VPWR VGND sg13cmos5l_nor2_1
X_4118__262 _4118_/RESET_B VPWR VGND sg13cmos5l_tiehi
XFILLER_27_453 VPWR VGND sg13cmos5l_fill_1
XFILLER_36_33 VPWR VGND sg13cmos5l_decap_8
XFILLER_15_626 VPWR VGND sg13cmos5l_decap_8
XFILLER_43_968 VPWR VGND sg13cmos5l_decap_8
XFILLER_42_434 VPWR VGND sg13cmos5l_decap_8
XFILLER_11_821 VPWR VGND sg13cmos5l_decap_4
X_4160__179 _4160_/D VPWR VGND sg13cmos5l_tielo
XFILLER_2_585 VPWR VGND sg13cmos5l_decap_8
XFILLER_38_718 VPWR VGND sg13cmos5l_fill_2
XFILLER_19_943 VPWR VGND sg13cmos5l_decap_8
XFILLER_46_740 VPWR VGND sg13cmos5l_decap_8
XFILLER_18_420 VPWR VGND sg13cmos5l_fill_1
XFILLER_19_954 VPWR VGND sg13cmos5l_fill_1
XFILLER_33_412 VPWR VGND sg13cmos5l_decap_8
XFILLER_33_467 VPWR VGND sg13cmos5l_fill_1
XFILLER_20_139 VPWR VGND sg13cmos5l_decap_8
X_3721_ _3722_/A _3721_/A _3721_/B VPWR VGND sg13cmos5l_nor2_1
XFILLER_9_184 VPWR VGND sg13cmos5l_decap_4
X_3652_ _3656_/A _3669_/A _3652_/B VPWR VGND sg13cmos5l_nor2_1
X_3583_ _3583_/Y _3583_/A VPWR VGND sg13cmos5l_inv_1
X_2603_ _2610_/B _2603_/A _2603_/B VPWR VGND sg13cmos5l_nor2_1
X_2534_ _2724_/B _2576_/A _2576_/B VPWR VGND sg13cmos5l_nor2b_1
XFILLER_47_0 VPWR VGND sg13cmos5l_decap_8
X_2465_ _4116_/D _2463_/Y hold853/X _2516_/A VPWR VGND sg13cmos5l_a21oi_1
X_4204_ _4204_/Q _4234_/CLK _4204_/D _4204_/RESET_B VPWR VGND sg13cmos5l_dfrbpq_1
X_2396_ _4072_/D _2436_/A0 hold656/X _2400_/S VPWR VGND sg13cmos5l_mux2_1
X_4135_ _4135_/Q _4363_/CLK _4135_/D _4135_/RESET_B VPWR VGND sg13cmos5l_dfrbpq_1
XFILLER_3_81 VPWR VGND sg13cmos5l_decap_4
X_4258__475 _4258_/RESET_B VPWR VGND sg13cmos5l_tiehi
XFILLER_28_206 VPWR VGND sg13cmos5l_fill_2
X_4066_ _4066_/Q _4128_/CLK _4066_/D _4066_/RESET_B VPWR VGND sg13cmos5l_dfrbpq_1
X_3017_ _3021_/B _3009_/A _3009_/B _3011_/X _3015_/Y _3016_/X VPWR VGND sg13cmos5l_a221oi_1
XFILLER_24_412 VPWR VGND sg13cmos5l_decap_4
XFILLER_19_1007 VPWR VGND sg13cmos5l_decap_8
XFILLER_24_423 VPWR VGND sg13cmos5l_decap_8
XFILLER_25_946 VPWR VGND sg13cmos5l_decap_8
XFILLER_25_957 VPWR VGND sg13cmos5l_decap_4
XFILLER_12_607 VPWR VGND sg13cmos5l_decap_8
XFILLER_40_938 VPWR VGND sg13cmos5l_decap_8
XFILLER_11_117 VPWR VGND sg13cmos5l_fill_1
X_3919_ _3976_/D input7/X hold704/X _3925_/S VPWR VGND sg13cmos5l_mux2_1
XFILLER_20_651 VPWR VGND sg13cmos5l_decap_4
XFILLER_4_839 VPWR VGND sg13cmos5l_decap_8
XFILLER_3_327 VPWR VGND sg13cmos5l_fill_1
XFILLER_3_338 VPWR VGND sg13cmos5l_fill_1
X_4079__305 _4079_/RESET_B VPWR VGND sg13cmos5l_tiehi
Xfanout130 _3254_/A _3255_/A VPWR VGND sg13cmos5l_buf_1
XFILLER_47_43 VPWR VGND sg13cmos5l_decap_8
XFILLER_47_32 VPWR VGND sg13cmos5l_decap_8
XFILLER_16_957 VPWR VGND sg13cmos5l_fill_2
XFILLER_43_776 VPWR VGND sg13cmos5l_decap_8
XFILLER_15_478 VPWR VGND sg13cmos5l_fill_2
XFILLER_31_927 VPWR VGND sg13cmos5l_decap_8
XFILLER_42_286 VPWR VGND sg13cmos5l_fill_2
XFILLER_7_622 VPWR VGND sg13cmos5l_decap_8
XFILLER_7_666 VPWR VGND sg13cmos5l_decap_8
XFILLER_7_677 VPWR VGND sg13cmos5l_fill_2
XFILLER_6_176 VPWR VGND sg13cmos5l_fill_1
XFILLER_6_165 VPWR VGND sg13cmos5l_decap_8
X_2250_ _3784_/A _2250_/A VPWR VGND sg13cmos5l_inv_1
XFILLER_3_894 VPWR VGND sg13cmos5l_decap_8
XFILLER_38_548 VPWR VGND sg13cmos5l_decap_8
XFILLER_34_710 VPWR VGND sg13cmos5l_fill_2
XFILLER_18_272 VPWR VGND sg13cmos5l_fill_1
XFILLER_34_721 VPWR VGND sg13cmos5l_fill_1
XFILLER_34_754 VPWR VGND sg13cmos5l_decap_8
XFILLER_21_426 VPWR VGND sg13cmos5l_fill_1
X_3704_ _3710_/B _4362_/Q _4361_/Q _4360_/Q _4359_/Q VPWR VGND sg13cmos5l_nor4_1
XFILLER_30_982 VPWR VGND sg13cmos5l_decap_8
X_3984__550 _3984_/RESET_B VPWR VGND sg13cmos5l_tiehi
X_3635_ _3635_/Y _3635_/A _4294_/Q VPWR VGND sg13cmos5l_nand2_1
X_3566_ _3567_/B _3626_/B _3626_/C VPWR VGND sg13cmos5l_nor2_1
X_3497_ _4300_/D _3454_/X _3500_/A _3496_/Y VPWR VGND sg13cmos5l_a21oi_1
X_2517_ _2517_/Y _2289_/B _3882_/B VPWR VGND sg13cmos5l_nand2b_1
X_2448_ _2449_/B _2448_/A _2448_/B _2474_/B VPWR VGND sg13cmos5l_nand3_1
XFILLER_25_1011 VPWR VGND sg13cmos5l_decap_8
XFILLER_29_504 VPWR VGND sg13cmos5l_decap_4
X_2379_ _2379_/X _2439_/A0 hold678/X _2379_/S VPWR VGND sg13cmos5l_mux2_1
X_4118_ _4118_/Q _4363_/CLK _4118_/D _4118_/RESET_B VPWR VGND sg13cmos5l_dfrbpq_1
XFILLER_44_507 VPWR VGND sg13cmos5l_fill_2
X_4049_ _4049_/Q _4128_/CLK _4049_/D _4049_/RESET_B VPWR VGND sg13cmos5l_dfrbpq_1
XFILLER_25_743 VPWR VGND sg13cmos5l_decap_4
XFILLER_40_746 VPWR VGND sg13cmos5l_fill_1
XFILLER_9_909 VPWR VGND sg13cmos5l_decap_8
XFILLER_12_404 VPWR VGND sg13cmos5l_decap_8
XFILLER_40_779 VPWR VGND sg13cmos5l_decap_8
XFILLER_12_448 VPWR VGND sg13cmos5l_fill_1
XFILLER_33_89 VPWR VGND sg13cmos5l_decap_8
XFILLER_4_636 VPWR VGND sg13cmos5l_fill_1
XFILLER_3_146 VPWR VGND sg13cmos5l_fill_1
X_3996__410 _3996_/RESET_B VPWR VGND sg13cmos5l_tiehi
XFILLER_48_824 VPWR VGND sg13cmos5l_decap_8
XFILLER_47_312 VPWR VGND sg13cmos5l_decap_4
XFILLER_0_886 VPWR VGND sg13cmos5l_decap_8
XFILLER_47_356 VPWR VGND sg13cmos5l_fill_1
XFILLER_15_220 VPWR VGND sg13cmos5l_decap_4
XFILLER_43_595 VPWR VGND sg13cmos5l_decap_8
XFILLER_30_201 VPWR VGND sg13cmos5l_decap_8
XFILLER_30_212 VPWR VGND sg13cmos5l_fill_2
XFILLER_31_757 VPWR VGND sg13cmos5l_decap_4
XFILLER_8_920 VPWR VGND sg13cmos5l_decap_8
XFILLER_12_971 VPWR VGND sg13cmos5l_decap_8
XFILLER_8_997 VPWR VGND sg13cmos5l_decap_8
XFILLER_7_485 VPWR VGND sg13cmos5l_decap_8
XFILLER_7_496 VPWR VGND sg13cmos5l_decap_8
X_3420_ _3420_/Y _3429_/B _3416_/Y _3429_/A VPWR VGND sg13cmos5l_o21ai_1
X_3351_ _3565_/A _4301_/Q _3360_/B VPWR VGND sg13cmos5l_nor2_1
X_2302_ _3911_/B _2473_/A _2315_/A VPWR VGND sg13cmos5l_nor2_1
X_3282_ _3299_/C _4265_/Q _3296_/B VPWR VGND sg13cmos5l_xnor2_1
XFILLER_38_312 VPWR VGND sg13cmos5l_decap_8
X_2233_ _2723_/A _2233_/A VPWR VGND sg13cmos5l_inv_1
XFILLER_39_857 VPWR VGND sg13cmos5l_fill_2
XFILLER_38_334 VPWR VGND sg13cmos5l_decap_8
XFILLER_26_507 VPWR VGND sg13cmos5l_fill_1
XFILLER_21_234 VPWR VGND sg13cmos5l_fill_2
XFILLER_22_757 VPWR VGND sg13cmos5l_decap_8
X_4069__315 _4069_/RESET_B VPWR VGND sg13cmos5l_tiehi
X_2997_ _4211_/D _3123_/A _2997_/B VPWR VGND sg13cmos5l_and2_1
XFILLER_21_278 VPWR VGND sg13cmos5l_fill_1
Xhold931 _3092_/A _4232_/Q VPWR VGND sg13cmos5l_dlygate4sd3_1
X_3618_ _4328_/D _3618_/A _3619_/B VPWR VGND sg13cmos5l_nor2_1
Xhold920 hold920/X _4222_/Q VPWR VGND sg13cmos5l_dlygate4sd3_1
Xhold942 hold942/X _4157_/Q VPWR VGND sg13cmos5l_dlygate4sd3_1
Xhold964 _2240_/A _4209_/Q VPWR VGND sg13cmos5l_dlygate4sd3_1
Xhold953 _2725_/A _2566_/Y VPWR VGND sg13cmos5l_dlygate4sd3_1
Xhold986 hold986/X _4180_/Q VPWR VGND sg13cmos5l_dlygate4sd3_1
Xhold997 _3031_/B _3112_/B VPWR VGND sg13cmos5l_dlygate4sd3_1
Xhold975 _2944_/A _4203_/Q VPWR VGND sg13cmos5l_dlygate4sd3_1
X_3549_ _3554_/A _3549_/A _3556_/B _3549_/C VPWR VGND sg13cmos5l_nand3_1
XFILLER_0_116 VPWR VGND sg13cmos5l_decap_8
X_4076__308 _4076_/RESET_B VPWR VGND sg13cmos5l_tiehi
XFILLER_45_805 VPWR VGND sg13cmos5l_decap_8
XFILLER_17_518 VPWR VGND sg13cmos5l_fill_2
XFILLER_25_573 VPWR VGND sg13cmos5l_fill_2
XFILLER_9_717 VPWR VGND sg13cmos5l_fill_1
XFILLER_40_598 VPWR VGND sg13cmos5l_decap_8
XFILLER_5_912 VPWR VGND sg13cmos5l_decap_8
XFILLER_4_400 VPWR VGND sg13cmos5l_decap_4
XFILLER_5_989 VPWR VGND sg13cmos5l_decap_8
XFILLER_4_488 VPWR VGND sg13cmos5l_fill_2
XFILLER_48_687 VPWR VGND sg13cmos5l_decap_4
XFILLER_47_164 VPWR VGND sg13cmos5l_decap_8
XFILLER_47_153 VPWR VGND sg13cmos5l_fill_2
XFILLER_47_142 VPWR VGND sg13cmos5l_decap_8
XFILLER_36_816 VPWR VGND sg13cmos5l_decap_8
Xclkbuf_2_3__f_clk clkload1/A clkbuf_0_clk/X VPWR VGND sg13cmos5l_buf_8
XFILLER_47_175 VPWR VGND sg13cmos5l_fill_1
XFILLER_35_348 VPWR VGND sg13cmos5l_decap_8
X_2920_ _2920_/Y _3076_/A _2846_/B _2872_/A _2872_/B _2844_/Y VPWR VGND sg13cmos5l_a221oi_1
XFILLER_31_543 VPWR VGND sg13cmos5l_decap_8
X_2851_ _2851_/Y _2851_/A _2851_/B _3009_/A VPWR VGND sg13cmos5l_nor3_1
XFILLER_15_1010 VPWR VGND sg13cmos5l_decap_8
XFILLER_31_576 VPWR VGND sg13cmos5l_decap_8
X_2782_ _4171_/D _2232_/Y _3072_/A2 _2781_/Y VPWR VGND sg13cmos5l_a21oi_1
X_3403_ _3403_/Y _4253_/Q _3411_/B VPWR VGND sg13cmos5l_nand2_1
X_3334_ _3336_/B _3618_/A _3334_/B VPWR VGND sg13cmos5l_nor2_1
X_3265_ _3265_/Y _3162_/X _3204_/B _3208_/B _3167_/B VPWR VGND sg13cmos5l_a22oi_1
X_2216_ _2216_/Y _2216_/A VPWR VGND sg13cmos5l_inv_1
XFILLER_22_1014 VPWR VGND sg13cmos5l_decap_8
X_3196_ _3272_/A _3205_/B _3194_/B _3195_/Y VPWR VGND sg13cmos5l_o21ai_1
XFILLER_14_47 VPWR VGND sg13cmos5l_decap_8
XFILLER_22_565 VPWR VGND sg13cmos5l_decap_4
XFILLER_2_904 VPWR VGND sg13cmos5l_decap_8
XFILLER_30_68 VPWR VGND sg13cmos5l_fill_2
Xhold772 hold772/X _4044_/Q VPWR VGND sg13cmos5l_dlygate4sd3_1
Xhold750 hold750/X _4050_/Q VPWR VGND sg13cmos5l_dlygate4sd3_1
Xhold761 hold761/X _4010_/Q VPWR VGND sg13cmos5l_dlygate4sd3_1
Xhold794 hold794/X _4047_/Q VPWR VGND sg13cmos5l_dlygate4sd3_1
Xhold783 hold783/X _4104_/Q VPWR VGND sg13cmos5l_dlygate4sd3_1
XFILLER_49_418 VPWR VGND sg13cmos5l_decap_8
XFILLER_7_1019 VPWR VGND sg13cmos5l_decap_8
XFILLER_39_99 VPWR VGND sg13cmos5l_fill_1
XFILLER_39_88 VPWR VGND sg13cmos5l_fill_1
XFILLER_18_827 VPWR VGND sg13cmos5l_fill_2
XFILLER_29_164 VPWR VGND sg13cmos5l_fill_1
XFILLER_29_186 VPWR VGND sg13cmos5l_fill_2
XFILLER_45_679 VPWR VGND sg13cmos5l_decap_4
XFILLER_44_167 VPWR VGND sg13cmos5l_decap_8
XFILLER_38_1021 VPWR VGND sg13cmos5l_decap_8
XFILLER_25_370 VPWR VGND sg13cmos5l_fill_1
XFILLER_25_392 VPWR VGND sg13cmos5l_fill_1
XFILLER_40_351 VPWR VGND sg13cmos5l_decap_8
XFILLER_13_576 VPWR VGND sg13cmos5l_fill_1
XFILLER_9_558 VPWR VGND sg13cmos5l_decap_4
X_4128__242 _4128_/RESET_B VPWR VGND sg13cmos5l_tiehi
X_4163__177 _4163_/D VPWR VGND sg13cmos5l_tielo
XFILLER_5_753 VPWR VGND sg13cmos5l_decap_8
XFILLER_4_241 VPWR VGND sg13cmos5l_decap_8
X_4059__325 _4059_/RESET_B VPWR VGND sg13cmos5l_tiehi
XFILLER_1_992 VPWR VGND sg13cmos5l_decap_8
X_3050_ _3050_/Y _2285_/A _3042_/Y _3059_/A _2284_/A VPWR VGND sg13cmos5l_a22oi_1
XFILLER_49_974 VPWR VGND sg13cmos5l_decap_8
XFILLER_48_440 VPWR VGND sg13cmos5l_decap_8
XFILLER_36_602 VPWR VGND sg13cmos5l_fill_2
XFILLER_17_871 VPWR VGND sg13cmos5l_fill_1
XFILLER_23_329 VPWR VGND sg13cmos5l_fill_1
XFILLER_35_189 VPWR VGND sg13cmos5l_fill_1
XFILLER_44_690 VPWR VGND sg13cmos5l_fill_1
X_3952_ _3952_/Y _3952_/A _3962_/S VPWR VGND sg13cmos5l_nor2_1
X_3883_ _3892_/A _3897_/B _3882_/Y _2522_/C VPWR VGND sg13cmos5l_a21oi_1
X_2903_ _2903_/Y _4194_/Q _2903_/B VPWR VGND sg13cmos5l_nand2b_1
XFILLER_31_351 VPWR VGND sg13cmos5l_decap_4
XFILLER_32_863 VPWR VGND sg13cmos5l_decap_4
X_2834_ _2834_/Y _2833_/A _2833_/B _2823_/Y VPWR VGND sg13cmos5l_a21oi_1
X_4066__318 _4066_/RESET_B VPWR VGND sg13cmos5l_tiehi
XFILLER_31_384 VPWR VGND sg13cmos5l_decap_4
X_2765_ _2765_/Y _2918_/A _2765_/B _2765_/C VPWR VGND sg13cmos5l_nand3_1
XFILLER_8_591 VPWR VGND sg13cmos5l_fill_2
X_2696_ _2696_/Y _2698_/A _4099_/Q VPWR VGND sg13cmos5l_nand2b_1
X_4366_ _4366_/Q _4377_/CLK _4366_/D _4366_/RESET_B VPWR VGND sg13cmos5l_dfrbpq_1
X_3317_ _4269_/D _3294_/X _3318_/A _3316_/Y VPWR VGND sg13cmos5l_a21oi_1
X_4297_ _4297_/Q _4302_/CLK _4297_/D _4297_/RESET_B VPWR VGND sg13cmos5l_dfrbpq_1
X_4337__383 _4337_/RESET_B VPWR VGND sg13cmos5l_tiehi
X_3248_ _4257_/D _2225_/Y _3251_/A2 _3247_/Y VPWR VGND sg13cmos5l_a21oi_1
XFILLER_27_624 VPWR VGND sg13cmos5l_decap_8
X_3179_ _3180_/B _3257_/A _3177_/X _3200_/A _3176_/X VPWR VGND sg13cmos5l_a22oi_1
XFILLER_15_808 VPWR VGND sg13cmos5l_decap_8
XFILLER_14_307 VPWR VGND sg13cmos5l_fill_2
XFILLER_26_167 VPWR VGND sg13cmos5l_decap_4
XFILLER_41_115 VPWR VGND sg13cmos5l_fill_2
XFILLER_25_46 VPWR VGND sg13cmos5l_decap_8
XFILLER_10_502 VPWR VGND sg13cmos5l_fill_1
XFILLER_22_340 VPWR VGND sg13cmos5l_decap_8
XFILLER_10_535 VPWR VGND sg13cmos5l_decap_8
XFILLER_22_373 VPWR VGND sg13cmos5l_fill_2
XFILLER_22_384 VPWR VGND sg13cmos5l_decap_8
XFILLER_6_539 VPWR VGND sg13cmos5l_decap_8
XFILLER_2_723 VPWR VGND sg13cmos5l_fill_2
XFILLER_2_756 VPWR VGND sg13cmos5l_fill_2
Xhold591 _3614_/B _4292_/Q VPWR VGND sg13cmos5l_dlygate4sd3_1
XFILLER_49_248 VPWR VGND sg13cmos5l_decap_4
XFILLER_46_922 VPWR VGND sg13cmos5l_decap_8
XFILLER_18_624 VPWR VGND sg13cmos5l_decap_4
XFILLER_45_454 VPWR VGND sg13cmos5l_decap_8
XFILLER_46_999 VPWR VGND sg13cmos5l_decap_8
XFILLER_45_465 VPWR VGND sg13cmos5l_fill_1
XFILLER_32_137 VPWR VGND sg13cmos5l_fill_2
XFILLER_33_649 VPWR VGND sg13cmos5l_decap_8
XFILLER_9_300 VPWR VGND sg13cmos5l_decap_8
XFILLER_13_373 VPWR VGND sg13cmos5l_decap_8
XFILLER_14_896 VPWR VGND sg13cmos5l_decap_8
XFILLER_9_388 VPWR VGND sg13cmos5l_decap_4
XFILLER_9_399 VPWR VGND sg13cmos5l_decap_4
XFILLER_12_1013 VPWR VGND sg13cmos5l_decap_8
X_2550_ _4140_/D _2550_/A _2541_/Y VPWR VGND sg13cmos5l_nor2b_1
X_2481_ _2481_/Y _2481_/A _2481_/B VPWR VGND sg13cmos5l_nand2_1
XFILLER_49_4 VPWR VGND sg13cmos5l_decap_8
X_4220_ _4220_/Q _4262_/CLK _4220_/D _4220_/RESET_B VPWR VGND sg13cmos5l_dfrbpq_1
X_4356__247 _4356_/RESET_B VPWR VGND sg13cmos5l_tiehi
X_4151_ _4151_/Q _4225_/CLK _4151_/D _4151_/RESET_B VPWR VGND sg13cmos5l_dfrbpq_1
X_4082_ _4082_/Q clkload9/A _4082_/D _4082_/RESET_B VPWR VGND sg13cmos5l_dfrbpq_1
X_3102_ _3102_/X _2992_/B _3024_/Y _3102_/S VPWR VGND sg13cmos5l_mux2_1
XFILLER_49_771 VPWR VGND sg13cmos5l_decap_8
XFILLER_37_933 VPWR VGND sg13cmos5l_decap_8
X_3033_ _3033_/Y _3047_/B _4237_/Q _4236_/Q _3040_/B VPWR VGND sg13cmos5l_a22oi_1
XFILLER_36_432 VPWR VGND sg13cmos5l_decap_8
XFILLER_36_476 VPWR VGND sg13cmos5l_fill_2
X_3935_ _3991_/D input5/X hold731/X _3935_/S VPWR VGND sg13cmos5l_mux2_1
X_3866_ _3866_/Y _3858_/A _3805_/Y _3865_/Y VPWR VGND sg13cmos5l_a21oi_1
X_2817_ _2818_/C _2817_/A _2816_/A VPWR VGND sg13cmos5l_nor2b_1
X_3797_ _3860_/A _4356_/Q _3802_/B VPWR VGND sg13cmos5l_or2_1
X_2748_ _4157_/D _2818_/A _2748_/B VPWR VGND sg13cmos5l_nor2_1
X_2679_ _2679_/Y _2679_/A _2679_/B _2679_/C _2679_/D VPWR VGND sg13cmos5l_nand4_1
X_4349_ _4349_/Q clkload6/A _4349_/D _4349_/RESET_B VPWR VGND sg13cmos5l_dfrbpq_1
XFILLER_28_922 VPWR VGND sg13cmos5l_decap_8
XFILLER_28_988 VPWR VGND sg13cmos5l_decap_8
XFILLER_36_78 VPWR VGND sg13cmos5l_decap_8
XFILLER_43_947 VPWR VGND sg13cmos5l_decap_8
XFILLER_14_137 VPWR VGND sg13cmos5l_decap_4
XFILLER_14_159 VPWR VGND sg13cmos5l_decap_4
XFILLER_35_1024 VPWR VGND sg13cmos5l_decap_4
X_4049__335 _4049_/RESET_B VPWR VGND sg13cmos5l_tiehi
XFILLER_7_815 VPWR VGND sg13cmos5l_decap_8
XFILLER_22_181 VPWR VGND sg13cmos5l_decap_8
XFILLER_7_848 VPWR VGND sg13cmos5l_fill_2
XFILLER_7_837 VPWR VGND sg13cmos5l_decap_8
XFILLER_42_1017 VPWR VGND sg13cmos5l_decap_8
XFILLER_42_1028 VPWR VGND sg13cmos5l_fill_1
X_4056__328 _4056_/RESET_B VPWR VGND sg13cmos5l_tiehi
XFILLER_18_432 VPWR VGND sg13cmos5l_decap_8
XFILLER_46_796 VPWR VGND sg13cmos5l_decap_8
XFILLER_34_914 VPWR VGND sg13cmos5l_fill_1
XFILLER_34_958 VPWR VGND sg13cmos5l_decap_8
X_3720_ _4337_/D _3879_/A _3720_/B VPWR VGND sg13cmos5l_nor2_1
XFILLER_13_170 VPWR VGND sg13cmos5l_decap_4
XFILLER_13_192 VPWR VGND sg13cmos5l_fill_1
X_4169__183 _4169_/RESET_B VPWR VGND sg13cmos5l_tiehi
X_4327__393 _4327_/RESET_B VPWR VGND sg13cmos5l_tiehi
X_3651_ _3651_/Y _3651_/A _3651_/B VPWR VGND sg13cmos5l_xnor2_1
X_3582_ _3583_/A _3586_/S _3581_/Y _3580_/Y VPWR VGND sg13cmos5l_a21o_1
X_2602_ _2603_/B _2600_/Y _2601_/Y _2710_/A VPWR VGND sg13cmos5l_o21ai_1
X_2533_ _2576_/B _2535_/C _2535_/D VPWR VGND sg13cmos5l_nor2_1
XFILLER_5_380 VPWR VGND sg13cmos5l_fill_1
X_2464_ _2464_/Y _2461_/B _4116_/Q _2456_/B hold852/X VPWR VGND sg13cmos5l_a22oi_1
X_4203_ _4203_/Q _4234_/CLK _4203_/D _4203_/RESET_B VPWR VGND sg13cmos5l_dfrbpq_1
X_2395_ _4071_/D _2435_/A0 hold673/X _2400_/S VPWR VGND sg13cmos5l_mux2_1
X_4134_ _4134_/Q _4363_/CLK _4134_/D _4134_/RESET_B VPWR VGND sg13cmos5l_dfrbpq_1
XFILLER_28_229 VPWR VGND sg13cmos5l_decap_8
X_4065_ _4065_/Q _4128_/CLK _4065_/D _4065_/RESET_B VPWR VGND sg13cmos5l_dfrbpq_1
X_4334__386 _4334_/RESET_B VPWR VGND sg13cmos5l_tiehi
X_3016_ _3016_/X _3016_/A _3016_/B _3016_/C VPWR VGND sg13cmos5l_and3_1
XFILLER_37_774 VPWR VGND sg13cmos5l_decap_4
XFILLER_36_295 VPWR VGND sg13cmos5l_decap_4
X_3918_ _3975_/D _3964_/A0 hold807/X _3925_/S VPWR VGND sg13cmos5l_mux2_1
X_3849_ _3849_/Y _3848_/B _3848_/C _3720_/B VPWR VGND sg13cmos5l_a21oi_1
X_4306__422 _4306_/RESET_B VPWR VGND sg13cmos5l_tiehi
XFILLER_20_685 VPWR VGND sg13cmos5l_fill_1
XFILLER_3_306 VPWR VGND sg13cmos5l_decap_8
X_4341__379 _4341_/RESET_B VPWR VGND sg13cmos5l_tiehi
X_4224__166 _4224_/D VPWR VGND sg13cmos5l_tielo
XFILLER_0_7 VPWR VGND sg13cmos5l_decap_8
Xfanout120 _2501_/A _3775_/A VPWR VGND sg13cmos5l_buf_1
Xfanout131 _3255_/A fanout132/X VPWR VGND sg13cmos5l_buf_1
XFILLER_47_549 VPWR VGND sg13cmos5l_decap_8
XFILLER_47_66 VPWR VGND sg13cmos5l_fill_1
X_4313__415 _4313_/RESET_B VPWR VGND sg13cmos5l_tiehi
XFILLER_16_914 VPWR VGND sg13cmos5l_decap_8
XFILLER_15_424 VPWR VGND sg13cmos5l_fill_2
XFILLER_27_284 VPWR VGND sg13cmos5l_decap_4
XFILLER_42_265 VPWR VGND sg13cmos5l_decap_8
XFILLER_30_438 VPWR VGND sg13cmos5l_decap_8
Xclkbuf_leaf_22_clk _4377_/CLK clkbuf_leaf_3_clk/A VPWR VGND sg13cmos5l_buf_8
XFILLER_7_601 VPWR VGND sg13cmos5l_fill_1
XFILLER_11_663 VPWR VGND sg13cmos5l_fill_1
XFILLER_7_689 VPWR VGND sg13cmos5l_fill_1
XFILLER_2_361 VPWR VGND sg13cmos5l_decap_4
XFILLER_33_7 VPWR VGND sg13cmos5l_fill_2
XFILLER_19_752 VPWR VGND sg13cmos5l_decap_4
XFILLER_46_571 VPWR VGND sg13cmos5l_fill_1
XFILLER_34_733 VPWR VGND sg13cmos5l_decap_8
XFILLER_22_917 VPWR VGND sg13cmos5l_decap_8
XFILLER_33_254 VPWR VGND sg13cmos5l_fill_1
XFILLER_34_777 VPWR VGND sg13cmos5l_fill_1
XFILLER_33_276 VPWR VGND sg13cmos5l_fill_1
Xclkbuf_leaf_13_clk _4209_/CLK clkload1/A VPWR VGND sg13cmos5l_buf_8
X_3703_ _3703_/Y _3730_/A _3701_/X _3702_/X VPWR VGND sg13cmos5l_o21ai_1
XFILLER_30_961 VPWR VGND sg13cmos5l_decap_8
X_3634_ _3634_/X _3634_/A _3634_/B VPWR VGND sg13cmos5l_and2_1
X_3565_ _3626_/C _3565_/A _3565_/B VPWR VGND sg13cmos5l_and2_1
X_2516_ _4136_/D _2516_/A _2516_/B VPWR VGND sg13cmos5l_nor2_1
XFILLER_0_309 VPWR VGND sg13cmos5l_decap_8
X_3496_ _3496_/Y _3478_/Y _3500_/A _3444_/B VPWR VGND sg13cmos5l_o21ai_1
X_2447_ _2447_/Y _4124_/Q _2474_/B _2448_/A VPWR VGND sg13cmos5l_a21oi_1
X_2378_ _4057_/D _2438_/A0 hold792/X _2380_/S VPWR VGND sg13cmos5l_mux2_1
X_4117_ _4117_/Q _4363_/CLK _4117_/D _4117_/RESET_B VPWR VGND sg13cmos5l_dfrbpq_1
X_4039__345 _4039_/RESET_B VPWR VGND sg13cmos5l_tiehi
X_4048_ _4048_/Q clkload8/A _4048_/D _4048_/RESET_B VPWR VGND sg13cmos5l_dfrbpq_1
XFILLER_37_593 VPWR VGND sg13cmos5l_fill_1
XFILLER_25_766 VPWR VGND sg13cmos5l_fill_2
XFILLER_13_939 VPWR VGND sg13cmos5l_decap_8
XFILLER_33_13 VPWR VGND sg13cmos5l_decap_8
XFILLER_33_46 VPWR VGND sg13cmos5l_decap_8
XFILLER_33_57 VPWR VGND sg13cmos5l_fill_1
XFILLER_32_1016 VPWR VGND sg13cmos5l_decap_8
XFILLER_32_1027 VPWR VGND sg13cmos5l_fill_2
XFILLER_20_493 VPWR VGND sg13cmos5l_fill_1
X_4046__338 _4046_/RESET_B VPWR VGND sg13cmos5l_tiehi
XFILLER_48_803 VPWR VGND sg13cmos5l_decap_8
XFILLER_0_865 VPWR VGND sg13cmos5l_decap_8
XFILLER_47_335 VPWR VGND sg13cmos5l_decap_4
X_4159__193 _4159_/RESET_B VPWR VGND sg13cmos5l_tiehi
XFILLER_47_379 VPWR VGND sg13cmos5l_decap_8
XFILLER_35_508 VPWR VGND sg13cmos5l_fill_2
XFILLER_15_210 VPWR VGND sg13cmos5l_fill_1
XFILLER_16_722 VPWR VGND sg13cmos5l_fill_1
XFILLER_28_571 VPWR VGND sg13cmos5l_fill_2
XFILLER_16_755 VPWR VGND sg13cmos5l_fill_2
XFILLER_43_574 VPWR VGND sg13cmos5l_fill_1
XFILLER_43_563 VPWR VGND sg13cmos5l_decap_8
XFILLER_12_950 VPWR VGND sg13cmos5l_decap_8
X_4248__486 _4248_/RESET_B VPWR VGND sg13cmos5l_tiehi
X_4166__186 _4166_/RESET_B VPWR VGND sg13cmos5l_tiehi
XFILLER_8_976 VPWR VGND sg13cmos5l_decap_8
XFILLER_7_475 VPWR VGND sg13cmos5l_decap_4
X_4324__396 _4324_/RESET_B VPWR VGND sg13cmos5l_tiehi
X_3350_ _4273_/D _3442_/B _3350_/B VPWR VGND sg13cmos5l_nor2_1
X_2301_ _2315_/A _2296_/Y _2298_/Y _2300_/Y VPWR VGND sg13cmos5l_a21oi_1
XFILLER_39_803 VPWR VGND sg13cmos5l_fill_1
X_3281_ _3299_/B _4259_/Q _4231_/Q _4264_/Q VPWR VGND sg13cmos5l_nand3_1
XFILLER_31_4 VPWR VGND sg13cmos5l_fill_1
XFILLER_38_302 VPWR VGND sg13cmos5l_fill_1
Xclkbuf_leaf_2_clk clkload3/A clkbuf_leaf_4_clk/A VPWR VGND sg13cmos5l_buf_8
X_4138__222 _4138_/RESET_B VPWR VGND sg13cmos5l_tiehi
X_2232_ _2232_/Y _2722_/A VPWR VGND sg13cmos5l_inv_1
X_4255__479 _4255_/RESET_B VPWR VGND sg13cmos5l_tiehi
XFILLER_47_891 VPWR VGND sg13cmos5l_decap_8
X_4331__389 _4331_/RESET_B VPWR VGND sg13cmos5l_tiehi
XFILLER_34_530 VPWR VGND sg13cmos5l_decap_8
XFILLER_34_541 VPWR VGND sg13cmos5l_decap_8
XFILLER_34_552 VPWR VGND sg13cmos5l_fill_2
XFILLER_21_213 VPWR VGND sg13cmos5l_decap_8
XFILLER_22_769 VPWR VGND sg13cmos5l_decap_8
X_2996_ _2997_/B _3096_/A _3096_/B VPWR VGND sg13cmos5l_and2_1
XFILLER_21_268 VPWR VGND sg13cmos5l_fill_1
XFILLER_30_780 VPWR VGND sg13cmos5l_decap_8
Xhold910 hold910/X _2776_/Y VPWR VGND sg13cmos5l_dlygate4sd3_1
X_3617_ _4327_/D _3617_/A _3620_/B VPWR VGND sg13cmos5l_and2_1
X_4303__425 _4303_/RESET_B VPWR VGND sg13cmos5l_tiehi
Xhold921 _4222_/D _3063_/Y VPWR VGND sg13cmos5l_dlygate4sd3_1
Xhold954 _2737_/B _4158_/Q VPWR VGND sg13cmos5l_dlygate4sd3_1
Xhold943 _2748_/B _2805_/A VPWR VGND sg13cmos5l_dlygate4sd3_1
Xhold932 _3114_/B _3086_/Y VPWR VGND sg13cmos5l_dlygate4sd3_1
X_3548_ _3549_/C _4279_/Q _4278_/Q _4280_/Q VPWR VGND sg13cmos5l_o21ai_1
Xhold965 _2744_/A _4160_/Q VPWR VGND sg13cmos5l_dlygate4sd3_1
Xhold987 _3471_/A _4296_/Q VPWR VGND sg13cmos5l_dlygate4sd3_1
Xhold998 _2256_/A _4269_/Q VPWR VGND sg13cmos5l_dlygate4sd3_1
Xhold976 _2945_/B _2944_/X VPWR VGND sg13cmos5l_dlygate4sd3_1
X_3479_ _3479_/Y _3454_/A _3454_/B _3478_/Y VPWR VGND sg13cmos5l_a21oi_1
X_4310__418 _4310_/RESET_B VPWR VGND sg13cmos5l_tiehi
XFILLER_13_714 VPWR VGND sg13cmos5l_decap_8
XFILLER_13_725 VPWR VGND sg13cmos5l_decap_4
XFILLER_40_533 VPWR VGND sg13cmos5l_decap_8
XFILLER_13_769 VPWR VGND sg13cmos5l_fill_1
XFILLER_12_257 VPWR VGND sg13cmos5l_decap_8
XFILLER_12_268 VPWR VGND sg13cmos5l_fill_2
XFILLER_8_228 VPWR VGND sg13cmos5l_fill_2
XFILLER_4_423 VPWR VGND sg13cmos5l_decap_4
XFILLER_5_968 VPWR VGND sg13cmos5l_decap_8
XFILLER_0_673 VPWR VGND sg13cmos5l_decap_8
XFILLER_47_121 VPWR VGND sg13cmos5l_decap_8
XFILLER_18_90 VPWR VGND sg13cmos5l_decap_8
XFILLER_44_883 VPWR VGND sg13cmos5l_decap_8
X_2850_ _4183_/D hold959/X _2847_/B _2918_/B VPWR VGND sg13cmos5l_a21oi_1
XFILLER_31_566 VPWR VGND sg13cmos5l_fill_1
X_2781_ _2781_/Y hold660/X _2784_/A2 _3066_/A VPWR VGND sg13cmos5l_o21ai_1
X_4029__355 _4029_/RESET_B VPWR VGND sg13cmos5l_tiehi
XFILLER_7_283 VPWR VGND sg13cmos5l_decap_4
X_3402_ _3411_/B _4303_/Q _2281_/Y _3401_/Y VPWR VGND sg13cmos5l_o21ai_1
X_3333_ _3352_/B _4274_/Q _4273_/Q VPWR VGND sg13cmos5l_xor2_1
X_3264_ _3264_/X _3163_/B _3293_/A _3263_/Y VPWR VGND sg13cmos5l_a21o_1
X_2215_ _2215_/Y _3773_/B VPWR VGND sg13cmos5l_inv_1
XFILLER_27_817 VPWR VGND sg13cmos5l_fill_1
X_3195_ _3195_/Y _3195_/A _3200_/B VPWR VGND sg13cmos5l_nor2_1
X_4036__348 _4036_/RESET_B VPWR VGND sg13cmos5l_tiehi
XFILLER_22_522 VPWR VGND sg13cmos5l_fill_1
X_2979_ _2980_/B _4210_/Q _4236_/Q VPWR VGND sg13cmos5l_nand2_1
X_4082__302 _4082_/RESET_B VPWR VGND sg13cmos5l_tiehi
Xhold773 hold773/X _4074_/Q VPWR VGND sg13cmos5l_dlygate4sd3_1
Xhold751 hold751/X _4107_/Q VPWR VGND sg13cmos5l_dlygate4sd3_1
Xhold762 hold762/X _3987_/Q VPWR VGND sg13cmos5l_dlygate4sd3_1
Xhold740 hold740/X _4043_/Q VPWR VGND sg13cmos5l_dlygate4sd3_1
XFILLER_1_437 VPWR VGND sg13cmos5l_fill_1
Xhold784 hold784/X _4350_/Q VPWR VGND sg13cmos5l_dlygate4sd3_1
Xhold795 hold795/X _3986_/Q VPWR VGND sg13cmos5l_dlygate4sd3_1
XFILLER_39_67 VPWR VGND sg13cmos5l_decap_8
X_4238__496 _4238_/RESET_B VPWR VGND sg13cmos5l_tiehi
X_4156__196 _4156_/RESET_B VPWR VGND sg13cmos5l_tiehi
XFILLER_38_1000 VPWR VGND sg13cmos5l_decap_8
XFILLER_41_831 VPWR VGND sg13cmos5l_fill_2
XFILLER_26_894 VPWR VGND sg13cmos5l_fill_2
XFILLER_41_886 VPWR VGND sg13cmos5l_decap_4
XFILLER_40_385 VPWR VGND sg13cmos5l_decap_4
X_4245__489 _4245_/RESET_B VPWR VGND sg13cmos5l_tiehi
X_4163__189 _4163_/RESET_B VPWR VGND sg13cmos5l_tiehi
XFILLER_4_220 VPWR VGND sg13cmos5l_decap_8
XFILLER_45_1015 VPWR VGND sg13cmos5l_decap_8
XFILLER_4_286 VPWR VGND sg13cmos5l_fill_2
XFILLER_1_971 VPWR VGND sg13cmos5l_decap_8
XFILLER_49_953 VPWR VGND sg13cmos5l_decap_8
X_3951_ _4001_/D _3951_/A0 hold666/X _3962_/S VPWR VGND sg13cmos5l_mux2_1
X_2902_ _4192_/D _2960_/A _2902_/B VPWR VGND sg13cmos5l_nor2_1
X_3882_ _3882_/Y _3896_/B _3882_/B VPWR VGND sg13cmos5l_nand2b_1
X_2833_ _2833_/X _2833_/A _2833_/B _3016_/A VPWR VGND sg13cmos5l_and3_1
X_2764_ _2764_/X _2568_/Y _2763_/Y _2765_/C VPWR VGND sg13cmos5l_mux2_1
X_2695_ _2712_/B _2607_/A _2686_/Y _2694_/Y VPWR VGND sg13cmos5l_o21ai_1
X_4300__428 _4300_/RESET_B VPWR VGND sg13cmos5l_tiehi
X_4365_ _4365_/Q _4377_/CLK _4365_/D _4365_/RESET_B VPWR VGND sg13cmos5l_dfrbpq_1
X_3316_ _3316_/Y _3295_/A _3318_/A _3154_/Y VPWR VGND sg13cmos5l_o21ai_1
X_4296_ _4296_/Q _4302_/CLK _4296_/D _4296_/RESET_B VPWR VGND sg13cmos5l_dfrbpq_1
X_3247_ _3247_/Y hold657/X _3251_/A2 _3607_/A VPWR VGND sg13cmos5l_o21ai_1
XFILLER_27_614 VPWR VGND sg13cmos5l_fill_1
X_3178_ _3200_/A _4215_/Q _4216_/Q VPWR VGND sg13cmos5l_xor2_1
XFILLER_27_669 VPWR VGND sg13cmos5l_decap_4
XFILLER_35_691 VPWR VGND sg13cmos5l_decap_8
XFILLER_10_514 VPWR VGND sg13cmos5l_decap_8
XFILLER_41_57 VPWR VGND sg13cmos5l_fill_2
XFILLER_2_702 VPWR VGND sg13cmos5l_decap_8
X_4008__269 _4008_/RESET_B VPWR VGND sg13cmos5l_tiehi
XFILLER_2_735 VPWR VGND sg13cmos5l_decap_8
Xhold592 _2785_/B _4151_/Q VPWR VGND sg13cmos5l_dlygate4sd3_1
XFILLER_49_227 VPWR VGND sg13cmos5l_fill_2
XFILLER_46_901 VPWR VGND sg13cmos5l_decap_8
XFILLER_46_978 VPWR VGND sg13cmos5l_decap_8
XFILLER_45_422 VPWR VGND sg13cmos5l_fill_2
X_4019__365 _4019_/RESET_B VPWR VGND sg13cmos5l_tiehi
XFILLER_18_647 VPWR VGND sg13cmos5l_decap_4
XFILLER_40_193 VPWR VGND sg13cmos5l_decap_8
X_2480_ _2481_/B _2480_/A _2480_/B VPWR VGND sg13cmos5l_xnor2_1
XFILLER_31_90 VPWR VGND sg13cmos5l_decap_4
X_4026__358 _4026_/RESET_B VPWR VGND sg13cmos5l_tiehi
X_4150_ _4150_/Q _4225_/CLK _4150_/D _4150_/RESET_B VPWR VGND sg13cmos5l_dfrbpq_1
X_3101_ _3102_/S _3107_/B _3107_/C VPWR VGND sg13cmos5l_nor2_1
XFILLER_49_750 VPWR VGND sg13cmos5l_decap_8
X_4081_ _4081_/Q _4128_/CLK _4081_/D _4081_/RESET_B VPWR VGND sg13cmos5l_dfrbpq_1
XFILLER_37_901 VPWR VGND sg13cmos5l_decap_8
X_4072__312 _4072_/RESET_B VPWR VGND sg13cmos5l_tiehi
X_3032_ _3032_/Y _4193_/Q _3258_/A VPWR VGND sg13cmos5l_nor2_1
XFILLER_36_400 VPWR VGND sg13cmos5l_fill_1
XFILLER_37_989 VPWR VGND sg13cmos5l_decap_8
XFILLER_36_455 VPWR VGND sg13cmos5l_fill_1
XFILLER_36_466 VPWR VGND sg13cmos5l_fill_2
X_3934_ _3990_/D _3971_/A0 hold785/X _3934_/S VPWR VGND sg13cmos5l_mux2_1
X_3865_ _3865_/Y _3865_/A _3877_/B VPWR VGND sg13cmos5l_nor2_1
X_2816_ _2818_/B _2816_/A _2804_/C VPWR VGND sg13cmos5l_nor2b_1
X_3796_ _3861_/A _4355_/Q _3802_/B _3852_/A VPWR VGND sg13cmos5l_a21o_1
X_2747_ _2805_/A hold942/X _2868_/A _2749_/B VPWR VGND sg13cmos5l_mux2_1
X_2678_ _2679_/D _2710_/A _2678_/B _2678_/C VPWR VGND sg13cmos5l_nand3_1
X_4348_ _4348_/Q _4363_/CLK _4348_/D _4348_/RESET_B VPWR VGND sg13cmos5l_dfrbpq_1
X_4279_ _4279_/Q _4303_/CLK _4279_/D _4279_/RESET_B VPWR VGND sg13cmos5l_dfrbpq_1
XFILLER_28_901 VPWR VGND sg13cmos5l_decap_8
XFILLER_28_967 VPWR VGND sg13cmos5l_decap_8
XFILLER_43_926 VPWR VGND sg13cmos5l_decap_8
X_4235__499 _4235_/RESET_B VPWR VGND sg13cmos5l_tiehi
X_4153__199 _4153_/RESET_B VPWR VGND sg13cmos5l_tiehi
XFILLER_35_1003 VPWR VGND sg13cmos5l_decap_8
XFILLER_10_322 VPWR VGND sg13cmos5l_decap_8
XFILLER_10_355 VPWR VGND sg13cmos5l_decap_8
XFILLER_2_543 VPWR VGND sg13cmos5l_decap_8
XFILLER_2_565 VPWR VGND sg13cmos5l_decap_8
XFILLER_19_901 VPWR VGND sg13cmos5l_decap_8
XFILLER_46_775 VPWR VGND sg13cmos5l_decap_8
XFILLER_9_142 VPWR VGND sg13cmos5l_decap_8
X_3650_ _3651_/B _4327_/Q _3638_/Y _3635_/Y VPWR VGND sg13cmos5l_a21oi_1
X_3581_ _3581_/Y _3784_/A _3822_/A VPWR VGND sg13cmos5l_nor2_1
X_2601_ _2601_/Y _2704_/A1 _2598_/X _2675_/A VPWR VGND sg13cmos5l_o21ai_1
X_2532_ _2535_/D _2532_/A _2532_/B VPWR VGND sg13cmos5l_nand2_1
XFILLER_5_392 VPWR VGND sg13cmos5l_decap_4
X_2463_ _2463_/Y _2473_/A _2463_/B VPWR VGND sg13cmos5l_nand2_1
X_4202_ _4202_/Q _4234_/CLK _4202_/D _4202_/RESET_B VPWR VGND sg13cmos5l_dfrbpq_1
X_2394_ _4070_/D _2434_/A0 hold690/X _2400_/S VPWR VGND sg13cmos5l_mux2_1
X_4133_ _4133_/Q _4363_/CLK _4133_/D _4133_/RESET_B VPWR VGND sg13cmos5l_dfrbpq_1
X_4064_ _4064_/Q _4128_/CLK _4064_/D _4064_/RESET_B VPWR VGND sg13cmos5l_dfrbpq_1
XFILLER_49_580 VPWR VGND sg13cmos5l_decap_8
X_3015_ _3015_/Y _4207_/Q _3026_/B _3014_/Y _3012_/Y VPWR VGND sg13cmos5l_a22oi_1
XFILLER_37_753 VPWR VGND sg13cmos5l_decap_8
XFILLER_36_263 VPWR VGND sg13cmos5l_decap_4
XFILLER_33_992 VPWR VGND sg13cmos5l_decap_8
XFILLER_32_480 VPWR VGND sg13cmos5l_fill_2
X_3917_ _3925_/S _4129_/Q _4128_/Q _3963_/B VPWR VGND sg13cmos5l_nand3_1
X_3848_ _3848_/X _3848_/A _3848_/B _3848_/C VPWR VGND sg13cmos5l_and3_1
XFILLER_4_808 VPWR VGND sg13cmos5l_decap_8
X_3779_ _3779_/Y _2212_/Y _3779_/A2 _3778_/Y VPWR VGND sg13cmos5l_a21oi_1
Xfanout110 _2439_/A0 input13/X VPWR VGND sg13cmos5l_buf_1
Xfanout121 _3775_/A input1/X VPWR VGND sg13cmos5l_buf_1
Xfanout132 fanout132/X input1/X VPWR VGND sg13cmos5l_buf_1
XFILLER_47_528 VPWR VGND sg13cmos5l_decap_8
XFILLER_27_241 VPWR VGND sg13cmos5l_fill_1
XFILLER_15_436 VPWR VGND sg13cmos5l_decap_8
XFILLER_16_937 VPWR VGND sg13cmos5l_decap_8
XFILLER_27_296 VPWR VGND sg13cmos5l_decap_4
XFILLER_15_458 VPWR VGND sg13cmos5l_fill_1
XFILLER_31_907 VPWR VGND sg13cmos5l_decap_8
XFILLER_30_417 VPWR VGND sg13cmos5l_decap_8
XFILLER_30_428 VPWR VGND sg13cmos5l_fill_2
XFILLER_6_123 VPWR VGND sg13cmos5l_fill_1
XFILLER_6_112 VPWR VGND sg13cmos5l_decap_8
XFILLER_10_196 VPWR VGND sg13cmos5l_decap_4
X_4062__322 _4062_/RESET_B VPWR VGND sg13cmos5l_tiehi
XFILLER_2_384 VPWR VGND sg13cmos5l_decap_8
XFILLER_46_594 VPWR VGND sg13cmos5l_decap_8
XFILLER_19_786 VPWR VGND sg13cmos5l_fill_1
XFILLER_33_211 VPWR VGND sg13cmos5l_decap_4
XFILLER_21_417 VPWR VGND sg13cmos5l_decap_8
XFILLER_33_266 VPWR VGND sg13cmos5l_fill_1
XFILLER_34_789 VPWR VGND sg13cmos5l_decap_8
XFILLER_21_439 VPWR VGND sg13cmos5l_decap_8
X_3702_ _3702_/X _3701_/B _3690_/B _3726_/A VPWR VGND sg13cmos5l_a21o_1
X_3633_ _3634_/B _3654_/B _3654_/C _3531_/B VPWR VGND sg13cmos5l_a21o_1
X_3564_ _3626_/B _3545_/X _3546_/Y _3565_/B _3356_/B _3552_/A VPWR VGND sg13cmos5l_a221oi_1
X_2515_ _2515_/Y hold639/X _2454_/Y _2515_/B1 VPWR VGND sg13cmos5l_a21oi_1
X_4340__380 _4340_/RESET_B VPWR VGND sg13cmos5l_tiehi
X_3495_ _3500_/A _3486_/Y _3492_/Y _3494_/Y VPWR VGND sg13cmos5l_o21ai_1
X_2446_ _4111_/D _2516_/A _3972_/B VPWR VGND sg13cmos5l_nor2_1
X_4116_ _4116_/Q _4363_/CLK _4116_/D _4116_/RESET_B VPWR VGND sg13cmos5l_dfrbpq_1
X_2377_ _4056_/D _2437_/A0 hold793/X _2380_/S VPWR VGND sg13cmos5l_mux2_1
XFILLER_29_517 VPWR VGND sg13cmos5l_decap_8
X_4047_ _4047_/Q clkload8/A _4047_/D _4047_/RESET_B VPWR VGND sg13cmos5l_dfrbpq_1
XFILLER_40_726 VPWR VGND sg13cmos5l_fill_2
XFILLER_40_715 VPWR VGND sg13cmos5l_decap_8
XFILLER_25_778 VPWR VGND sg13cmos5l_fill_1
XFILLER_12_439 VPWR VGND sg13cmos5l_decap_8
XFILLER_21_951 VPWR VGND sg13cmos5l_decap_4
XFILLER_4_605 VPWR VGND sg13cmos5l_decap_8
XFILLER_4_649 VPWR VGND sg13cmos5l_decap_8
XFILLER_0_844 VPWR VGND sg13cmos5l_decap_8
XFILLER_48_859 VPWR VGND sg13cmos5l_decap_8
XFILLER_43_542 VPWR VGND sg13cmos5l_decap_8
XFILLER_16_789 VPWR VGND sg13cmos5l_decap_4
XFILLER_31_704 VPWR VGND sg13cmos5l_fill_1
XFILLER_8_955 VPWR VGND sg13cmos5l_decap_8
XFILLER_7_432 VPWR VGND sg13cmos5l_decap_8
XFILLER_11_472 VPWR VGND sg13cmos5l_decap_4
XFILLER_48_1013 VPWR VGND sg13cmos5l_decap_8
XFILLER_3_660 VPWR VGND sg13cmos5l_decap_8
X_2300_ _2300_/Y _2300_/A _2300_/B VPWR VGND sg13cmos5l_nor2_1
X_3280_ _3299_/A _4263_/Q _3296_/B VPWR VGND sg13cmos5l_nand2_1
XFILLER_3_693 VPWR VGND sg13cmos5l_decap_8
X_2231_ _2231_/Y _2724_/A VPWR VGND sg13cmos5l_inv_1
XFILLER_24_4 VPWR VGND sg13cmos5l_decap_8
XFILLER_47_870 VPWR VGND sg13cmos5l_decap_8
XFILLER_0_1026 VPWR VGND sg13cmos5l_fill_2
XFILLER_0_95 VPWR VGND sg13cmos5l_decap_8
XFILLER_0_84 VPWR VGND sg13cmos5l_decap_8
X_2995_ _3096_/B _2995_/A _2995_/B _2995_/C VPWR VGND sg13cmos5l_or3_1
XFILLER_9_82 VPWR VGND sg13cmos5l_fill_2
XFILLER_30_792 VPWR VGND sg13cmos5l_fill_2
Xhold900 _2568_/A _4146_/Q VPWR VGND sg13cmos5l_dlygate4sd3_1
X_3616_ _4326_/D _3616_/A _3616_/B VPWR VGND sg13cmos5l_and2_1
Xhold911 _2210_/A _4364_/Q VPWR VGND sg13cmos5l_dlygate4sd3_1
Xhold922 hold922/X _4252_/Q VPWR VGND sg13cmos5l_dlygate4sd3_1
Xhold955 _3529_/A _4332_/Q VPWR VGND sg13cmos5l_dlygate4sd3_1
Xhold933 _2250_/A _4334_/Q VPWR VGND sg13cmos5l_dlygate4sd3_1
X_3547_ _3547_/X _4282_/Q _3547_/B VPWR VGND sg13cmos5l_xor2_1
Xhold944 _2948_/A _4202_/Q VPWR VGND sg13cmos5l_dlygate4sd3_1
Xhold988 _3472_/B _3471_/Y VPWR VGND sg13cmos5l_dlygate4sd3_1
Xhold977 _3290_/A _4264_/Q VPWR VGND sg13cmos5l_dlygate4sd3_1
Xhold966 hold966/X _4128_/Q VPWR VGND sg13cmos5l_dlygate4sd3_1
Xhold999 _2990_/A _4210_/Q VPWR VGND sg13cmos5l_dlygate4sd3_1
X_3478_ _3478_/Y _3490_/A _3478_/B VPWR VGND sg13cmos5l_nor2_1
X_2429_ _4100_/D _2438_/A0 hold741/X _2430_/S VPWR VGND sg13cmos5l_mux2_1
XFILLER_44_317 VPWR VGND sg13cmos5l_decap_8
XFILLER_38_892 VPWR VGND sg13cmos5l_decap_4
X_4052__332 _4052_/RESET_B VPWR VGND sg13cmos5l_tiehi
XFILLER_25_531 VPWR VGND sg13cmos5l_fill_2
XFILLER_40_501 VPWR VGND sg13cmos5l_decap_8
XFILLER_12_203 VPWR VGND sg13cmos5l_fill_2
XFILLER_44_79 VPWR VGND sg13cmos5l_decap_8
XFILLER_21_781 VPWR VGND sg13cmos5l_decap_8
XFILLER_5_947 VPWR VGND sg13cmos5l_decap_8
XFILLER_47_111 VPWR VGND sg13cmos5l_fill_1
X_4254__480 _4254_/RESET_B VPWR VGND sg13cmos5l_tiehi
XFILLER_29_892 VPWR VGND sg13cmos5l_decap_4
XFILLER_44_862 VPWR VGND sg13cmos5l_decap_8
X_4330__390 _4330_/RESET_B VPWR VGND sg13cmos5l_tiehi
XFILLER_16_564 VPWR VGND sg13cmos5l_decap_8
XFILLER_16_575 VPWR VGND sg13cmos5l_fill_1
XFILLER_43_372 VPWR VGND sg13cmos5l_decap_8
XFILLER_31_523 VPWR VGND sg13cmos5l_fill_2
XFILLER_34_90 VPWR VGND sg13cmos5l_decap_8
XFILLER_8_741 VPWR VGND sg13cmos5l_fill_2
XFILLER_12_781 VPWR VGND sg13cmos5l_decap_8
X_2780_ _2780_/Y _2723_/A _2784_/A2 _2779_/Y VPWR VGND sg13cmos5l_a21oi_1
XFILLER_8_763 VPWR VGND sg13cmos5l_decap_8
XFILLER_7_240 VPWR VGND sg13cmos5l_decap_8
X_3401_ _3401_/Y _4304_/Q _3244_/A _3400_/Y VPWR VGND sg13cmos5l_a21oi_1
X_3332_ _3334_/B _4300_/Q _4273_/Q VPWR VGND sg13cmos5l_and2_1
XFILLER_4_991 VPWR VGND sg13cmos5l_decap_8
X_3263_ _3263_/Y _3148_/Y _3151_/X _3272_/A _3272_/B _3150_/Y VPWR VGND sg13cmos5l_a221oi_1
XFILLER_39_645 VPWR VGND sg13cmos5l_fill_2
XFILLER_39_634 VPWR VGND sg13cmos5l_decap_8
X_2214_ _3773_/A _2214_/A VPWR VGND sg13cmos5l_inv_1
X_3194_ _3194_/X _3205_/B _3194_/B VPWR VGND sg13cmos5l_or2_1
XFILLER_39_656 VPWR VGND sg13cmos5l_decap_8
XFILLER_35_851 VPWR VGND sg13cmos5l_fill_2
XFILLER_10_718 VPWR VGND sg13cmos5l_decap_8
X_2978_ _2983_/A _2977_/A _2977_/B _3175_/A VPWR VGND sg13cmos5l_a21o_1
Xhold730 hold730/X _4082_/Q VPWR VGND sg13cmos5l_dlygate4sd3_1
Xhold741 hold741/X _4100_/Q VPWR VGND sg13cmos5l_dlygate4sd3_1
XFILLER_2_939 VPWR VGND sg13cmos5l_decap_8
Xhold752 hold752/X _4052_/Q VPWR VGND sg13cmos5l_dlygate4sd3_1
Xhold763 hold763/X _4109_/Q VPWR VGND sg13cmos5l_dlygate4sd3_1
Xhold774 hold774/X _4016_/Q VPWR VGND sg13cmos5l_dlygate4sd3_1
Xhold796 hold796/X _4008_/Q VPWR VGND sg13cmos5l_dlygate4sd3_1
Xhold785 hold785/X _3990_/Q VPWR VGND sg13cmos5l_dlygate4sd3_1
XFILLER_39_35 VPWR VGND sg13cmos5l_decap_8
XFILLER_18_829 VPWR VGND sg13cmos5l_fill_1
XFILLER_26_851 VPWR VGND sg13cmos5l_decap_8
XFILLER_26_862 VPWR VGND sg13cmos5l_fill_1
XFILLER_13_512 VPWR VGND sg13cmos5l_fill_2
XFILLER_13_523 VPWR VGND sg13cmos5l_fill_1
XFILLER_5_722 VPWR VGND sg13cmos5l_decap_8
XFILLER_4_265 VPWR VGND sg13cmos5l_decap_8
XFILLER_20_70 VPWR VGND sg13cmos5l_fill_1
XFILLER_1_950 VPWR VGND sg13cmos5l_decap_8
XFILLER_49_932 VPWR VGND sg13cmos5l_decap_8
XFILLER_0_460 VPWR VGND sg13cmos5l_fill_2
X_4250__163 _4250_/D VPWR VGND sg13cmos5l_tielo
X_3950_ _4000_/D _3950_/A0 hold709/X _3962_/S VPWR VGND sg13cmos5l_mux2_1
XFILLER_16_350 VPWR VGND sg13cmos5l_decap_8
XFILLER_17_862 VPWR VGND sg13cmos5l_decap_8
XFILLER_17_895 VPWR VGND sg13cmos5l_decap_4
X_2901_ _2901_/X _2892_/B _3047_/B _2901_/S VPWR VGND sg13cmos5l_mux2_1
X_3881_ _3896_/B _3881_/A _3901_/B VPWR VGND sg13cmos5l_nor2_1
X_2832_ _2832_/Y _2851_/A _2830_/Y _2831_/Y _2829_/Y VPWR VGND sg13cmos5l_a22oi_1
XFILLER_32_887 VPWR VGND sg13cmos5l_decap_8
X_2763_ _2763_/Y _4182_/Q _4179_/Q VPWR VGND sg13cmos5l_nor2b_1
XFILLER_8_571 VPWR VGND sg13cmos5l_fill_2
X_2694_ _2694_/Y _2607_/A _2693_/Y _4138_/Q VPWR VGND sg13cmos5l_a21oi_1
X_4042__342 _4042_/RESET_B VPWR VGND sg13cmos5l_tiehi
X_4364_ _4364_/Q _4377_/CLK _4364_/D _4364_/RESET_B VPWR VGND sg13cmos5l_dfrbpq_1
X_4295_ _4295_/Q _4302_/CLK _4295_/D _4295_/RESET_B VPWR VGND sg13cmos5l_dfrbpq_1
X_3315_ _4268_/D _3273_/X _3318_/A _3314_/Y VPWR VGND sg13cmos5l_a21oi_1
XFILLER_6_1021 VPWR VGND sg13cmos5l_decap_8
X_3246_ _4256_/D _3607_/A _3246_/B VPWR VGND sg13cmos5l_and2_1
XFILLER_39_486 VPWR VGND sg13cmos5l_decap_8
X_3177_ _3177_/X _4236_/Q _4215_/Q _4216_/Q VPWR VGND sg13cmos5l_or3_1
XFILLER_39_497 VPWR VGND sg13cmos5l_decap_8
XFILLER_42_618 VPWR VGND sg13cmos5l_decap_8
XFILLER_41_117 VPWR VGND sg13cmos5l_fill_1
XFILLER_23_843 VPWR VGND sg13cmos5l_decap_8
XFILLER_23_854 VPWR VGND sg13cmos5l_fill_1
X_3988__506 _3988_/RESET_B VPWR VGND sg13cmos5l_tiehi
XFILLER_10_548 VPWR VGND sg13cmos5l_decap_8
XFILLER_41_69 VPWR VGND sg13cmos5l_fill_2
XFILLER_6_519 VPWR VGND sg13cmos5l_decap_8
X_4244__490 _4244_/RESET_B VPWR VGND sg13cmos5l_tiehi
X_4162__190 _4162_/RESET_B VPWR VGND sg13cmos5l_tiehi
XFILLER_2_758 VPWR VGND sg13cmos5l_fill_1
XFILLER_2_725 VPWR VGND sg13cmos5l_fill_1
Xhold593 _2912_/B _4173_/Q VPWR VGND sg13cmos5l_dlygate4sd3_1
XFILLER_49_206 VPWR VGND sg13cmos5l_decap_8
XFILLER_18_604 VPWR VGND sg13cmos5l_fill_1
XFILLER_46_957 VPWR VGND sg13cmos5l_decap_8
X_4251__483 _4251_/RESET_B VPWR VGND sg13cmos5l_tiehi
X_4349__267 _4349_/RESET_B VPWR VGND sg13cmos5l_tiehi
XFILLER_13_331 VPWR VGND sg13cmos5l_fill_2
XFILLER_14_843 VPWR VGND sg13cmos5l_fill_2
XFILLER_41_695 VPWR VGND sg13cmos5l_decap_4
XFILLER_40_172 VPWR VGND sg13cmos5l_decap_8
XFILLER_9_335 VPWR VGND sg13cmos5l_decap_8
XFILLER_9_346 VPWR VGND sg13cmos5l_fill_2
XFILLER_5_552 VPWR VGND sg13cmos5l_fill_1
XFILLER_5_585 VPWR VGND sg13cmos5l_decap_8
X_3100_ _3107_/C _3113_/A _3112_/B _3112_/A VPWR VGND sg13cmos5l_o21ai_1
X_4373__541 _4373_/RESET_B VPWR VGND sg13cmos5l_tiehi
X_4080_ _4080_/Q clkload8/A _4080_/D _4080_/RESET_B VPWR VGND sg13cmos5l_dfrbpq_1
XFILLER_37_924 VPWR VGND sg13cmos5l_decap_4
X_3031_ _4217_/D _3123_/A _3031_/B VPWR VGND sg13cmos5l_and2_1
XFILLER_37_968 VPWR VGND sg13cmos5l_decap_8
XFILLER_24_618 VPWR VGND sg13cmos5l_fill_2
X_3933_ _3989_/D _3946_/A hold734/X _3935_/S VPWR VGND sg13cmos5l_mux2_1
X_3864_ _3864_/Y _3853_/A _3855_/A _3863_/Y VPWR VGND sg13cmos5l_o21ai_1
XFILLER_31_150 VPWR VGND sg13cmos5l_decap_4
XFILLER_32_684 VPWR VGND sg13cmos5l_decap_8
X_2815_ _4179_/D _2815_/A _2815_/B VPWR VGND sg13cmos5l_nor2_1
X_3795_ _3852_/A _3851_/A _3851_/B _3851_/C VPWR VGND sg13cmos5l_a21oi_1
XFILLER_20_879 VPWR VGND sg13cmos5l_decap_8
X_2746_ _2868_/A _2915_/A _2869_/A VPWR VGND sg13cmos5l_nand2_1
X_2677_ _2678_/C _2709_/A _2677_/B VPWR VGND sg13cmos5l_nand2_1
X_4347_ _4347_/Q _4363_/CLK _4347_/D _4347_/RESET_B VPWR VGND sg13cmos5l_dfrbpq_1
X_4278_ _4278_/Q _4333_/CLK _4278_/D _4278_/RESET_B VPWR VGND sg13cmos5l_dfrbpq_1
XFILLER_46_209 VPWR VGND sg13cmos5l_fill_1
XFILLER_39_261 VPWR VGND sg13cmos5l_fill_1
X_3229_ _3229_/Y _2282_/Y _3241_/A _3227_/Y VPWR VGND sg13cmos5l_a21oi_1
XFILLER_43_905 VPWR VGND sg13cmos5l_decap_8
XFILLER_27_489 VPWR VGND sg13cmos5l_decap_8
XFILLER_22_150 VPWR VGND sg13cmos5l_decap_4
XFILLER_23_684 VPWR VGND sg13cmos5l_fill_2
XFILLER_6_338 VPWR VGND sg13cmos5l_decap_8
XFILLER_19_968 VPWR VGND sg13cmos5l_fill_1
XFILLER_46_754 VPWR VGND sg13cmos5l_decap_8
XFILLER_18_456 VPWR VGND sg13cmos5l_fill_2
XFILLER_34_905 VPWR VGND sg13cmos5l_decap_8
XFILLER_34_927 VPWR VGND sg13cmos5l_decap_8
XFILLER_33_426 VPWR VGND sg13cmos5l_decap_8
XFILLER_33_437 VPWR VGND sg13cmos5l_fill_1
XFILLER_34_938 VPWR VGND sg13cmos5l_fill_2
XFILLER_34_949 VPWR VGND sg13cmos5l_fill_1
X_4032__352 _4032_/RESET_B VPWR VGND sg13cmos5l_tiehi
XFILLER_42_982 VPWR VGND sg13cmos5l_decap_8
XFILLER_9_121 VPWR VGND sg13cmos5l_decap_8
XFILLER_9_165 VPWR VGND sg13cmos5l_fill_2
X_3580_ _3580_/Y _4287_/Q _3580_/B _3586_/S VPWR VGND sg13cmos5l_nor3_1
X_2600_ _2600_/Y _2701_/S _3981_/Q _2599_/Y VPWR VGND sg13cmos5l_a21oi_1
X_2531_ _2532_/B _2289_/B _2535_/A _2522_/A VPWR VGND sg13cmos5l_a21oi_1
X_2462_ _2462_/Y _2462_/A _2462_/B _2462_/C VPWR VGND sg13cmos5l_nor3_1
X_4201_ _4201_/Q _4234_/CLK _4201_/D _4201_/RESET_B VPWR VGND sg13cmos5l_dfrbpq_1
X_2393_ _4069_/D _3965_/A0 hold682/X _2400_/S VPWR VGND sg13cmos5l_mux2_1
X_4132_ _4132_/Q _4363_/CLK _4132_/D _4132_/RESET_B VPWR VGND sg13cmos5l_dfrbpq_1
X_4063_ _4063_/Q clkload8/A _4063_/D _4063_/RESET_B VPWR VGND sg13cmos5l_dfrbpq_1
X_3014_ _3014_/Y _2851_/A _4188_/Q VPWR VGND sg13cmos5l_nand2b_1
XFILLER_3_1013 VPWR VGND sg13cmos5l_decap_8
XFILLER_36_253 VPWR VGND sg13cmos5l_fill_1
XFILLER_40_919 VPWR VGND sg13cmos5l_fill_1
XFILLER_40_908 VPWR VGND sg13cmos5l_decap_8
XFILLER_24_437 VPWR VGND sg13cmos5l_decap_8
X_3916_ _4369_/D _3916_/A _3916_/B VPWR VGND sg13cmos5l_nor2_1
XFILLER_33_960 VPWR VGND sg13cmos5l_fill_1
XFILLER_22_16 VPWR VGND sg13cmos5l_decap_8
X_3847_ _3847_/Y _3856_/B _3856_/C _3872_/B VPWR VGND sg13cmos5l_o21ai_1
XFILLER_20_676 VPWR VGND sg13cmos5l_decap_8
XFILLER_22_27 VPWR VGND sg13cmos5l_fill_2
X_3778_ _3778_/Y _4351_/Q _3779_/A2 _3616_/A VPWR VGND sg13cmos5l_o21ai_1
X_2729_ _2818_/A _2905_/B _3066_/A VPWR VGND sg13cmos5l_nand2b_1
X_4241__493 _4241_/RESET_B VPWR VGND sg13cmos5l_tiehi
Xfanout111 _3971_/A0 input13/X VPWR VGND sg13cmos5l_buf_1
Xfanout122 _3066_/A _3890_/B1 VPWR VGND sg13cmos5l_buf_1
Xfanout100 _3916_/A _2260_/Y VPWR VGND sg13cmos5l_buf_1
XFILLER_47_57 VPWR VGND sg13cmos5l_decap_8
XFILLER_43_702 VPWR VGND sg13cmos5l_decap_8
XFILLER_16_905 VPWR VGND sg13cmos5l_decap_4
XFILLER_15_426 VPWR VGND sg13cmos5l_fill_1
XFILLER_43_757 VPWR VGND sg13cmos5l_decap_4
XFILLER_8_29 VPWR VGND sg13cmos5l_decap_8
XFILLER_11_610 VPWR VGND sg13cmos5l_decap_8
XFILLER_23_492 VPWR VGND sg13cmos5l_decap_4
XFILLER_11_654 VPWR VGND sg13cmos5l_decap_8
XFILLER_11_676 VPWR VGND sg13cmos5l_decap_8
XFILLER_7_636 VPWR VGND sg13cmos5l_decap_8
XFILLER_12_71 VPWR VGND sg13cmos5l_decap_4
XFILLER_3_853 VPWR VGND sg13cmos5l_fill_2
XFILLER_19_765 VPWR VGND sg13cmos5l_decap_8
XFILLER_19_798 VPWR VGND sg13cmos5l_decap_8
XFILLER_34_768 VPWR VGND sg13cmos5l_decap_8
X_3701_ _3701_/X _4340_/Q _3701_/B VPWR VGND sg13cmos5l_xor2_1
X_3632_ _3634_/A _3563_/B _3654_/B _3654_/C VPWR VGND sg13cmos5l_nand3b_1
XFILLER_30_996 VPWR VGND sg13cmos5l_decap_8
X_3563_ _4310_/D _3619_/B _3563_/B VPWR VGND sg13cmos5l_nor2_1
X_2514_ _2514_/Y _3773_/A _2515_/B1 _2513_/Y VPWR VGND sg13cmos5l_a21oi_1
X_3494_ _3494_/Y _3459_/Y _3467_/X _3493_/Y VPWR VGND sg13cmos5l_a21oi_1
X_2445_ _3972_/B _2448_/B _2474_/B VPWR VGND sg13cmos5l_xnor2_1
XFILLER_25_1025 VPWR VGND sg13cmos5l_decap_4
X_4195__554 _4195_/RESET_B VPWR VGND sg13cmos5l_tiehi
X_4115_ _4115_/Q _4136_/CLK _4115_/D _4115_/RESET_B VPWR VGND sg13cmos5l_dfrbpq_1
X_2376_ _4055_/D _2436_/A0 hold786/X _2380_/S VPWR VGND sg13cmos5l_mux2_1
X_4046_ _4046_/Q clkload8/A _4046_/D _4046_/RESET_B VPWR VGND sg13cmos5l_dfrbpq_1
XFILLER_37_540 VPWR VGND sg13cmos5l_fill_2
XFILLER_24_201 VPWR VGND sg13cmos5l_fill_2
XFILLER_25_702 VPWR VGND sg13cmos5l_fill_2
X_4115__268 _4115_/RESET_B VPWR VGND sg13cmos5l_tiehi
XFILLER_24_223 VPWR VGND sg13cmos5l_decap_4
XFILLER_24_234 VPWR VGND sg13cmos5l_fill_1
XFILLER_25_768 VPWR VGND sg13cmos5l_fill_1
XFILLER_12_418 VPWR VGND sg13cmos5l_decap_8
X_4011__255 _4011_/RESET_B VPWR VGND sg13cmos5l_tiehi
XFILLER_20_484 VPWR VGND sg13cmos5l_decap_8
XFILLER_3_116 VPWR VGND sg13cmos5l_fill_1
XFILLER_0_823 VPWR VGND sg13cmos5l_decap_8
X_4022__362 _4022_/RESET_B VPWR VGND sg13cmos5l_tiehi
XFILLER_48_838 VPWR VGND sg13cmos5l_decap_8
XFILLER_28_540 VPWR VGND sg13cmos5l_decap_8
XFILLER_28_573 VPWR VGND sg13cmos5l_fill_1
XFILLER_8_934 VPWR VGND sg13cmos5l_decap_8
XFILLER_12_985 VPWR VGND sg13cmos5l_decap_8
XFILLER_2_182 VPWR VGND sg13cmos5l_fill_2
X_2230_ _3040_/B _2893_/A VPWR VGND sg13cmos5l_inv_1
XFILLER_46_370 VPWR VGND sg13cmos5l_decap_8
XFILLER_0_1005 VPWR VGND sg13cmos5l_decap_8
XFILLER_0_63 VPWR VGND sg13cmos5l_decap_8
X_2994_ _3096_/A _2995_/B _2995_/C _3199_/A VPWR VGND sg13cmos5l_o21ai_1
XFILLER_22_738 VPWR VGND sg13cmos5l_fill_2
XFILLER_9_61 VPWR VGND sg13cmos5l_decap_8
XFILLER_21_248 VPWR VGND sg13cmos5l_fill_1
XFILLER_21_259 VPWR VGND sg13cmos5l_fill_1
Xhold901 hold901/X _2568_/Y VPWR VGND sg13cmos5l_dlygate4sd3_1
X_3615_ _4325_/D _3615_/A _3615_/B VPWR VGND sg13cmos5l_and2_1
Xhold912 _4364_/D _3886_/Y VPWR VGND sg13cmos5l_dlygate4sd3_1
X_3546_ _3546_/Y _4282_/Q _3547_/B VPWR VGND sg13cmos5l_nand2_1
Xhold945 hold945/X _4375_/Q VPWR VGND sg13cmos5l_dlygate4sd3_1
Xhold923 hold923/X _3239_/Y VPWR VGND sg13cmos5l_dlygate4sd3_1
Xhold934 hold934/X _4378_/Q VPWR VGND sg13cmos5l_dlygate4sd3_1
Xhold989 _3721_/A _4359_/Q VPWR VGND sg13cmos5l_dlygate4sd3_1
Xhold978 _2247_/A _4301_/Q VPWR VGND sg13cmos5l_dlygate4sd3_1
Xhold967 _3460_/A _4299_/Q VPWR VGND sg13cmos5l_dlygate4sd3_1
Xhold956 _2229_/A _4192_/Q VPWR VGND sg13cmos5l_dlygate4sd3_1
X_3477_ _3478_/B _3477_/A _3477_/B VPWR VGND sg13cmos5l_xnor2_1
X_2428_ _4099_/D _2437_/A0 hold789/X _2430_/S VPWR VGND sg13cmos5l_mux2_1
X_2359_ _4042_/D input5/X hold777/X _2359_/S VPWR VGND sg13cmos5l_mux2_1
XFILLER_28_37 VPWR VGND sg13cmos5l_decap_8
XFILLER_29_304 VPWR VGND sg13cmos5l_fill_1
XFILLER_45_819 VPWR VGND sg13cmos5l_decap_8
X_4029_ _4029_/Q clkload9/A _4029_/D _4029_/RESET_B VPWR VGND sg13cmos5l_dfrbpq_1
XFILLER_40_579 VPWR VGND sg13cmos5l_fill_2
XFILLER_5_926 VPWR VGND sg13cmos5l_decap_8
XFILLER_0_631 VPWR VGND sg13cmos5l_decap_8
XFILLER_18_70 VPWR VGND sg13cmos5l_fill_1
XFILLER_44_841 VPWR VGND sg13cmos5l_decap_8
XFILLER_16_543 VPWR VGND sg13cmos5l_fill_2
XFILLER_43_351 VPWR VGND sg13cmos5l_decap_8
XFILLER_31_557 VPWR VGND sg13cmos5l_decap_4
XFILLER_15_1024 VPWR VGND sg13cmos5l_decap_4
XFILLER_11_281 VPWR VGND sg13cmos5l_fill_1
XFILLER_7_263 VPWR VGND sg13cmos5l_decap_8
X_3400_ _3400_/Y _4303_/Q _2281_/Y _2282_/Y _4302_/Q _3399_/Y VPWR VGND sg13cmos5l_a221oi_1
X_3331_ _3336_/A _3357_/A _3357_/C _3549_/A VPWR VGND sg13cmos5l_a21oi_1
XFILLER_4_970 VPWR VGND sg13cmos5l_decap_8
X_3262_ _3293_/B _3266_/A _3305_/B VPWR VGND sg13cmos5l_or2_1
X_2213_ _2213_/Y _2213_/A VPWR VGND sg13cmos5l_inv_1
X_3193_ _3194_/B _3193_/A _3200_/B VPWR VGND sg13cmos5l_nor2_1
XFILLER_22_1028 VPWR VGND sg13cmos5l_fill_1
XFILLER_26_329 VPWR VGND sg13cmos5l_fill_1
XFILLER_35_874 VPWR VGND sg13cmos5l_decap_4
XFILLER_35_896 VPWR VGND sg13cmos5l_decap_8
X_2977_ _2977_/X _2977_/A _2977_/B VPWR VGND sg13cmos5l_and2_1
XFILLER_30_16 VPWR VGND sg13cmos5l_decap_4
Xhold720 hold720/X _4029_/Q VPWR VGND sg13cmos5l_dlygate4sd3_1
XFILLER_2_918 VPWR VGND sg13cmos5l_decap_8
Xhold753 _2214_/A _4348_/Q VPWR VGND sg13cmos5l_dlygate4sd3_1
Xhold731 hold731/X _3991_/Q VPWR VGND sg13cmos5l_dlygate4sd3_1
Xhold764 _4109_/D _2439_/X VPWR VGND sg13cmos5l_dlygate4sd3_1
Xhold742 hold742/X _4094_/Q VPWR VGND sg13cmos5l_dlygate4sd3_1
Xhold797 hold797/X _4077_/Q VPWR VGND sg13cmos5l_dlygate4sd3_1
Xhold775 hold775/X _4083_/Q VPWR VGND sg13cmos5l_dlygate4sd3_1
X_3529_ _3529_/Y _3529_/A _3536_/B VPWR VGND sg13cmos5l_nand2_1
Xhold786 hold786/X _4055_/Q VPWR VGND sg13cmos5l_dlygate4sd3_1
XFILLER_45_627 VPWR VGND sg13cmos5l_fill_1
XFILLER_5_767 VPWR VGND sg13cmos5l_decap_8
XFILLER_4_255 VPWR VGND sg13cmos5l_decap_4
XFILLER_49_911 VPWR VGND sg13cmos5l_decap_8
XFILLER_49_988 VPWR VGND sg13cmos5l_decap_8
XFILLER_36_627 VPWR VGND sg13cmos5l_fill_2
XFILLER_35_137 VPWR VGND sg13cmos5l_decap_8
XFILLER_45_90 VPWR VGND sg13cmos5l_fill_1
XFILLER_16_373 VPWR VGND sg13cmos5l_decap_8
X_2900_ _4191_/D _2918_/B _2900_/B VPWR VGND sg13cmos5l_nor2_1
X_3880_ _4362_/D _3858_/A hold973/X _3772_/A VPWR VGND sg13cmos5l_a21oi_1
XFILLER_32_844 VPWR VGND sg13cmos5l_decap_8
X_2831_ _2831_/Y _2831_/A _2831_/B VPWR VGND sg13cmos5l_xnor2_1
XFILLER_31_365 VPWR VGND sg13cmos5l_decap_8
XFILLER_31_376 VPWR VGND sg13cmos5l_fill_1
X_2762_ _2765_/C _4182_/Q _2758_/Y _2761_/Y _2740_/Y VPWR VGND sg13cmos5l_a22oi_1
X_2693_ _2693_/Y _2689_/Y _2690_/Y _2692_/Y VPWR VGND sg13cmos5l_o21ai_1
XFILLER_6_51 VPWR VGND sg13cmos5l_fill_2
XFILLER_6_40 VPWR VGND sg13cmos5l_fill_2
XFILLER_6_62 VPWR VGND sg13cmos5l_decap_8
X_4363_ _4363_/Q _4363_/CLK _4363_/D _4363_/RESET_B VPWR VGND sg13cmos5l_dfrbpq_1
X_4294_ _4294_/Q _4323_/CLK _4294_/D _4294_/RESET_B VPWR VGND sg13cmos5l_dfrbpq_1
X_3314_ _3314_/Y _3298_/C _3318_/A _3154_/Y VPWR VGND sg13cmos5l_o21ai_1
XFILLER_6_1000 VPWR VGND sg13cmos5l_decap_8
X_3245_ _3245_/Y _3234_/B hold858/X _3258_/B VPWR VGND sg13cmos5l_a21oi_1
XFILLER_39_443 VPWR VGND sg13cmos5l_decap_8
XFILLER_39_421 VPWR VGND sg13cmos5l_fill_2
X_3176_ _3176_/X _4236_/Q _4215_/Q VPWR VGND sg13cmos5l_or2_1
XFILLER_27_638 VPWR VGND sg13cmos5l_decap_8
XFILLER_27_649 VPWR VGND sg13cmos5l_fill_2
XFILLER_35_660 VPWR VGND sg13cmos5l_decap_4
XFILLER_23_822 VPWR VGND sg13cmos5l_decap_8
XFILLER_34_181 VPWR VGND sg13cmos5l_decap_8
XFILLER_22_354 VPWR VGND sg13cmos5l_decap_8
XFILLER_22_398 VPWR VGND sg13cmos5l_decap_4
Xhold594 _3439_/B _4261_/Q VPWR VGND sg13cmos5l_dlygate4sd3_1
XFILLER_49_229 VPWR VGND sg13cmos5l_fill_1
XFILLER_46_936 VPWR VGND sg13cmos5l_decap_8
XFILLER_17_126 VPWR VGND sg13cmos5l_decap_8
XFILLER_13_343 VPWR VGND sg13cmos5l_fill_2
XFILLER_25_170 VPWR VGND sg13cmos5l_fill_2
XFILLER_9_314 VPWR VGND sg13cmos5l_decap_4
XFILLER_13_387 VPWR VGND sg13cmos5l_decap_8
XFILLER_13_398 VPWR VGND sg13cmos5l_fill_2
XFILLER_12_1027 VPWR VGND sg13cmos5l_fill_2
XFILLER_5_531 VPWR VGND sg13cmos5l_decap_8
XFILLER_31_81 VPWR VGND sg13cmos5l_decap_4
XFILLER_0_280 VPWR VGND sg13cmos5l_decap_8
XFILLER_49_785 VPWR VGND sg13cmos5l_decap_8
X_3030_ _3112_/B hold996/X _3016_/C _2855_/Y VPWR VGND sg13cmos5l_o21ai_1
XFILLER_37_947 VPWR VGND sg13cmos5l_decap_8
XFILLER_45_980 VPWR VGND sg13cmos5l_decap_8
X_3932_ _3988_/D _3958_/A hold724/X _3935_/S VPWR VGND sg13cmos5l_mux2_1
X_3863_ _3863_/Y _3865_/A _3877_/B VPWR VGND sg13cmos5l_nand2_1
X_2814_ _2815_/B _2805_/Y _2816_/A _2789_/B VPWR VGND sg13cmos5l_o21ai_1
X_3794_ _3851_/C _4355_/Q _3802_/B VPWR VGND sg13cmos5l_xnor2_1
X_2745_ _2749_/B _2739_/Y _2743_/Y _2744_/Y VPWR VGND sg13cmos5l_o21ai_1
XFILLER_8_391 VPWR VGND sg13cmos5l_fill_1
X_2676_ _2677_/B _4109_/Q _4092_/Q _4075_/Q _4058_/Q _2708_/S0 _2708_/S1 VPWR VGND
+ sg13cmos5l_mux4_1
X_4346_ _4346_/Q _4363_/CLK _4346_/D _4346_/RESET_B VPWR VGND sg13cmos5l_dfrbpq_1
XFILLER_28_1023 VPWR VGND sg13cmos5l_decap_4
X_4277_ _4277_/Q _4303_/CLK _4277_/D _4277_/RESET_B VPWR VGND sg13cmos5l_dfrbpq_1
X_3228_ _3230_/A _4251_/Q _3220_/Y _3227_/B _4252_/Q VPWR VGND sg13cmos5l_a22oi_1
X_3159_ _3159_/Y _3133_/Y _3148_/Y _3158_/Y VPWR VGND sg13cmos5l_a21oi_1
XFILLER_28_936 VPWR VGND sg13cmos5l_decap_4
XFILLER_27_446 VPWR VGND sg13cmos5l_decap_8
XFILLER_42_427 VPWR VGND sg13cmos5l_decap_8
XFILLER_15_619 VPWR VGND sg13cmos5l_fill_2
XFILLER_11_803 VPWR VGND sg13cmos5l_fill_1
XFILLER_11_814 VPWR VGND sg13cmos5l_decap_8
XFILLER_6_317 VPWR VGND sg13cmos5l_fill_2
X_4125__248 _4125_/RESET_B VPWR VGND sg13cmos5l_tiehi
XFILLER_2_523 VPWR VGND sg13cmos5l_fill_2
XFILLER_2_578 VPWR VGND sg13cmos5l_decap_8
XFILLER_46_733 VPWR VGND sg13cmos5l_decap_8
XFILLER_27_980 VPWR VGND sg13cmos5l_decap_8
Xclkbuf_leaf_25_clk _4363_/CLK clkbuf_leaf_4_clk/A VPWR VGND sg13cmos5l_buf_8
XFILLER_42_961 VPWR VGND sg13cmos5l_decap_8
XFILLER_14_674 VPWR VGND sg13cmos5l_fill_2
XFILLER_9_188 VPWR VGND sg13cmos5l_fill_2
XFILLER_6_873 VPWR VGND sg13cmos5l_fill_2
X_2530_ _2532_/A _2289_/B _2529_/Y hold934/X VPWR VGND sg13cmos5l_o21ai_1
X_2461_ _2462_/C _4131_/Q _2461_/B input2/X VPWR VGND sg13cmos5l_nor3_1
X_4200_ _4200_/Q _4234_/CLK _4200_/D _4200_/RESET_B VPWR VGND sg13cmos5l_dfrbpq_1
X_2392_ _4068_/D _3950_/A0 hold809/X _2400_/S VPWR VGND sg13cmos5l_mux2_1
X_4131_ _4131_/Q clkload6/A _4131_/D _4131_/RESET_B VPWR VGND sg13cmos5l_dfrbpq_1
XFILLER_3_74 VPWR VGND sg13cmos5l_decap_8
X_4062_ _4062_/Q _4128_/CLK _4062_/D _4062_/RESET_B VPWR VGND sg13cmos5l_dfrbpq_1
X_3013_ _3026_/B _4187_/Q _4188_/Q VPWR VGND sg13cmos5l_xnor2_1
XFILLER_24_416 VPWR VGND sg13cmos5l_fill_2
Xclkbuf_leaf_16_clk _4262_/CLK clkload1/A VPWR VGND sg13cmos5l_buf_8
X_3915_ _3915_/Y _3911_/A _3897_/Y _3909_/A _3914_/Y VPWR VGND sg13cmos5l_a22oi_1
X_3846_ _3856_/C _3848_/B _3848_/C _3723_/X VPWR VGND sg13cmos5l_a21oi_1
X_3777_ _4350_/D _2213_/Y _3781_/A2 _3776_/Y VPWR VGND sg13cmos5l_a21oi_1
X_2728_ _2789_/B _3916_/A _2905_/B VPWR VGND sg13cmos5l_nor2_1
X_2659_ _2659_/Y _2659_/A _2659_/B VPWR VGND sg13cmos5l_nand2_1
Xfanout112 _3946_/A _2438_/A0 VPWR VGND sg13cmos5l_buf_1
Xfanout101 _3323_/A _2260_/Y VPWR VGND sg13cmos5l_buf_1
X_4329_ _4329_/Q _4353_/CLK _4329_/D _4329_/RESET_B VPWR VGND sg13cmos5l_dfrbpq_1
Xfanout123 _2905_/A _3890_/B1 VPWR VGND sg13cmos5l_buf_1
XFILLER_47_25 VPWR VGND sg13cmos5l_decap_8
XFILLER_27_210 VPWR VGND sg13cmos5l_fill_2
XFILLER_28_744 VPWR VGND sg13cmos5l_fill_1
XFILLER_28_755 VPWR VGND sg13cmos5l_fill_1
XFILLER_16_928 VPWR VGND sg13cmos5l_decap_4
XFILLER_24_972 VPWR VGND sg13cmos5l_decap_4
XFILLER_30_408 VPWR VGND sg13cmos5l_fill_1
XFILLER_23_482 VPWR VGND sg13cmos5l_fill_1
XFILLER_7_615 VPWR VGND sg13cmos5l_decap_8
XFILLER_7_648 VPWR VGND sg13cmos5l_decap_4
XFILLER_7_659 VPWR VGND sg13cmos5l_decap_8
XFILLER_3_887 VPWR VGND sg13cmos5l_decap_8
XFILLER_19_700 VPWR VGND sg13cmos5l_fill_2
XFILLER_19_8 VPWR VGND sg13cmos5l_decap_8
X_3977__583 _3977_/RESET_B VPWR VGND sg13cmos5l_tiehi
XFILLER_34_703 VPWR VGND sg13cmos5l_decap_8
XFILLER_34_747 VPWR VGND sg13cmos5l_decap_8
X_3700_ _3707_/B _4340_/Q _4339_/Q _4337_/Q _4338_/Q VPWR VGND sg13cmos5l_nor4_1
XFILLER_30_975 VPWR VGND sg13cmos5l_decap_8
X_3631_ _3631_/X _3654_/B _3654_/C VPWR VGND sg13cmos5l_and2_1
X_3562_ _3563_/B _3562_/A _3562_/B VPWR VGND sg13cmos5l_nor2_1
X_2513_ _2513_/Y _2515_/B1 hold648/X _2449_/A VPWR VGND sg13cmos5l_o21ai_1
X_4108__276 _4108_/RESET_B VPWR VGND sg13cmos5l_tiehi
X_3493_ _3493_/Y _3493_/A _3493_/B VPWR VGND sg13cmos5l_nor2_1
X_2444_ _2474_/B _2473_/A _2547_/B VPWR VGND sg13cmos5l_nor2_1
Xclkbuf_leaf_5_clk clkload7/A clkload0/A VPWR VGND sg13cmos5l_buf_8
X_2375_ _4054_/D _2435_/A0 hold711/X _2380_/S VPWR VGND sg13cmos5l_mux2_1
XFILLER_25_1004 VPWR VGND sg13cmos5l_decap_8
X_4114_ _4114_/Q _4363_/CLK _4114_/D _4114_/RESET_B VPWR VGND sg13cmos5l_dfrbpq_1
XFILLER_29_508 VPWR VGND sg13cmos5l_fill_1
XFILLER_49_390 VPWR VGND sg13cmos5l_fill_2
X_4045_ _4045_/Q _4128_/CLK _4045_/D _4045_/RESET_B VPWR VGND sg13cmos5l_dfrbpq_1
XFILLER_25_747 VPWR VGND sg13cmos5l_fill_2
XFILLER_24_257 VPWR VGND sg13cmos5l_fill_2
XFILLER_24_268 VPWR VGND sg13cmos5l_decap_4
XFILLER_33_27 VPWR VGND sg13cmos5l_fill_1
X_3989__476 _3989_/RESET_B VPWR VGND sg13cmos5l_tiehi
XFILLER_21_975 VPWR VGND sg13cmos5l_decap_8
X_3829_ _3829_/Y _4310_/Q _3826_/A VPWR VGND sg13cmos5l_nor2b_1
XFILLER_4_629 VPWR VGND sg13cmos5l_decap_8
XFILLER_0_802 VPWR VGND sg13cmos5l_decap_8
XFILLER_48_817 VPWR VGND sg13cmos5l_decap_8
XFILLER_0_879 VPWR VGND sg13cmos5l_decap_8
XFILLER_47_316 VPWR VGND sg13cmos5l_fill_2
XFILLER_47_305 VPWR VGND sg13cmos5l_decap_8
XFILLER_28_585 VPWR VGND sg13cmos5l_decap_8
XFILLER_43_588 VPWR VGND sg13cmos5l_decap_8
XFILLER_12_964 VPWR VGND sg13cmos5l_decap_8
XFILLER_11_485 VPWR VGND sg13cmos5l_fill_2
XFILLER_2_161 VPWR VGND sg13cmos5l_fill_2
XFILLER_38_327 VPWR VGND sg13cmos5l_decap_8
XFILLER_46_360 VPWR VGND sg13cmos5l_fill_1
XFILLER_0_42 VPWR VGND sg13cmos5l_decap_8
XFILLER_0_1028 VPWR VGND sg13cmos5l_fill_1
XFILLER_15_780 VPWR VGND sg13cmos5l_decap_8
XFILLER_21_227 VPWR VGND sg13cmos5l_decap_8
X_2993_ _3199_/A _3257_/A _2998_/A VPWR VGND sg13cmos5l_nand2_1
XFILLER_34_588 VPWR VGND sg13cmos5l_decap_4
XFILLER_9_84 VPWR VGND sg13cmos5l_fill_1
X_3614_ _4324_/D _3615_/A _3614_/B VPWR VGND sg13cmos5l_and2_1
XFILLER_30_794 VPWR VGND sg13cmos5l_fill_1
Xhold913 _2252_/A _4335_/Q VPWR VGND sg13cmos5l_dlygate4sd3_1
Xhold902 _3887_/A _4365_/Q VPWR VGND sg13cmos5l_dlygate4sd3_1
Xhold946 _2865_/A _4164_/Q VPWR VGND sg13cmos5l_dlygate4sd3_1
X_3545_ _3545_/X _4282_/Q _3547_/B VPWR VGND sg13cmos5l_or2_1
Xhold924 _4252_/D _3240_/Y VPWR VGND sg13cmos5l_dlygate4sd3_1
Xhold935 _2574_/B _2535_/Y VPWR VGND sg13cmos5l_dlygate4sd3_1
XFILLER_0_109 VPWR VGND sg13cmos5l_decap_8
Xhold968 _2220_/A _4317_/Q VPWR VGND sg13cmos5l_dlygate4sd3_1
X_3476_ _3476_/Y _3476_/A _3476_/B _3476_/C VPWR VGND sg13cmos5l_nand3_1
Xhold979 _2304_/B _4373_/Q VPWR VGND sg13cmos5l_dlygate4sd3_1
Xhold957 _2902_/B _2901_/X VPWR VGND sg13cmos5l_dlygate4sd3_1
X_2427_ _4098_/D _2436_/A0 hold805/X _2430_/S VPWR VGND sg13cmos5l_mux2_1
X_2358_ _4041_/D _3971_/A0 hold739/X _2359_/S VPWR VGND sg13cmos5l_mux2_1
XFILLER_38_850 VPWR VGND sg13cmos5l_fill_1
X_2289_ _4371_/D _2718_/A _2289_/B _2535_/A VPWR VGND sg13cmos5l_and3_1
X_4028_ _4028_/Q clkload9/A _4028_/D _4028_/RESET_B VPWR VGND sg13cmos5l_dfrbpq_1
XFILLER_37_360 VPWR VGND sg13cmos5l_fill_1
XFILLER_25_533 VPWR VGND sg13cmos5l_fill_1
XFILLER_44_37 VPWR VGND sg13cmos5l_fill_1
XFILLER_5_905 VPWR VGND sg13cmos5l_decap_8
XFILLER_0_610 VPWR VGND sg13cmos5l_decap_8
XFILLER_0_698 VPWR VGND sg13cmos5l_fill_2
XFILLER_47_135 VPWR VGND sg13cmos5l_decap_8
XFILLER_36_809 VPWR VGND sg13cmos5l_decap_8
XFILLER_29_872 VPWR VGND sg13cmos5l_decap_8
XFILLER_44_820 VPWR VGND sg13cmos5l_decap_8
XFILLER_28_382 VPWR VGND sg13cmos5l_fill_1
XFILLER_44_897 VPWR VGND sg13cmos5l_decap_8
XFILLER_16_588 VPWR VGND sg13cmos5l_decap_4
XFILLER_15_1003 VPWR VGND sg13cmos5l_decap_8
XFILLER_8_721 VPWR VGND sg13cmos5l_fill_2
XFILLER_12_761 VPWR VGND sg13cmos5l_decap_8
XFILLER_11_271 VPWR VGND sg13cmos5l_fill_1
X_3330_ _3549_/A _4301_/Q _4302_/Q VPWR VGND sg13cmos5l_xnor2_1
X_3981__557 _3981_/RESET_B VPWR VGND sg13cmos5l_tiehi
X_4105__279 _4105_/RESET_B VPWR VGND sg13cmos5l_tiehi
X_3261_ _3270_/A _3266_/A _3305_/B VPWR VGND sg13cmos5l_nor2_1
X_2212_ _2212_/Y _2212_/A VPWR VGND sg13cmos5l_inv_1
XFILLER_22_1007 VPWR VGND sg13cmos5l_decap_8
X_3192_ _3197_/B _3180_/X _3186_/Y _3190_/Y VPWR VGND sg13cmos5l_o21ai_1
XFILLER_38_135 VPWR VGND sg13cmos5l_fill_2
XFILLER_38_113 VPWR VGND sg13cmos5l_decap_8
XFILLER_34_341 VPWR VGND sg13cmos5l_fill_1
XFILLER_22_536 VPWR VGND sg13cmos5l_fill_1
XFILLER_22_558 VPWR VGND sg13cmos5l_decap_8
XFILLER_34_396 VPWR VGND sg13cmos5l_decap_8
X_2976_ _2977_/B _4210_/Q _4211_/Q _4212_/Q VPWR VGND sg13cmos5l_o21ai_1
Xhold710 hold710/X _4028_/Q VPWR VGND sg13cmos5l_dlygate4sd3_1
Xhold721 hold721/X _4079_/Q VPWR VGND sg13cmos5l_dlygate4sd3_1
Xhold754 _4135_/D _2514_/Y VPWR VGND sg13cmos5l_dlygate4sd3_1
Xhold743 hold743/X _4102_/Q VPWR VGND sg13cmos5l_dlygate4sd3_1
Xhold732 hold732/X _4096_/Q VPWR VGND sg13cmos5l_dlygate4sd3_1
Xhold765 hold765/X _4101_/Q VPWR VGND sg13cmos5l_dlygate4sd3_1
X_3528_ _3536_/C _3524_/Y _3527_/Y _3510_/Y VPWR VGND sg13cmos5l_o21ai_1
Xhold776 hold776/X _4006_/Q VPWR VGND sg13cmos5l_dlygate4sd3_1
Xhold787 hold787/X _4037_/Q VPWR VGND sg13cmos5l_dlygate4sd3_1
Xhold798 hold798/X _3999_/Q VPWR VGND sg13cmos5l_dlygate4sd3_1
X_3459_ _3459_/Y _4299_/Q _3477_/B VPWR VGND sg13cmos5l_nor2_1
X_3993__439 _3993_/RESET_B VPWR VGND sg13cmos5l_tiehi
XFILLER_29_179 VPWR VGND sg13cmos5l_decap_8
XFILLER_38_1014 VPWR VGND sg13cmos5l_decap_8
XFILLER_25_352 VPWR VGND sg13cmos5l_decap_8
XFILLER_13_514 VPWR VGND sg13cmos5l_fill_1
XFILLER_40_399 VPWR VGND sg13cmos5l_decap_8
XFILLER_4_234 VPWR VGND sg13cmos5l_decap_8
XFILLER_1_985 VPWR VGND sg13cmos5l_decap_8
XFILLER_49_967 VPWR VGND sg13cmos5l_decap_8
XFILLER_48_433 VPWR VGND sg13cmos5l_decap_8
X_4135__228 _4135_/RESET_B VPWR VGND sg13cmos5l_tiehi
XFILLER_35_116 VPWR VGND sg13cmos5l_decap_8
XFILLER_35_127 VPWR VGND sg13cmos5l_fill_1
XFILLER_44_650 VPWR VGND sg13cmos5l_fill_2
XFILLER_31_300 VPWR VGND sg13cmos5l_decap_8
X_2830_ _2830_/Y _4184_/Q _4183_/Q _3076_/A VPWR VGND sg13cmos5l_nand3b_1
XFILLER_43_182 VPWR VGND sg13cmos5l_decap_8
XFILLER_31_344 VPWR VGND sg13cmos5l_decap_8
XFILLER_31_355 VPWR VGND sg13cmos5l_fill_1
X_2761_ _2761_/Y _4146_/Q _2918_/A _2765_/B _2234_/Y _2760_/Y VPWR VGND sg13cmos5l_a221oi_1
XFILLER_31_388 VPWR VGND sg13cmos5l_fill_1
X_2692_ _2692_/Y _2709_/A _2692_/B VPWR VGND sg13cmos5l_nand2_1
XFILLER_8_573 VPWR VGND sg13cmos5l_fill_1
XFILLER_6_30 VPWR VGND sg13cmos5l_fill_1
X_4362_ _4362_/Q clkload6/A _4362_/D _4362_/RESET_B VPWR VGND sg13cmos5l_dfrbpq_1
X_4293_ _4293_/Q _4323_/CLK _4293_/D _4293_/RESET_B VPWR VGND sg13cmos5l_dfrbpq_1
X_3313_ _3318_/A _3304_/Y _3310_/Y _3312_/Y VPWR VGND sg13cmos5l_o21ai_1
XFILLER_39_411 VPWR VGND sg13cmos5l_fill_1
X_3244_ _3244_/Y _3244_/A _3244_/B VPWR VGND sg13cmos5l_nand2_1
X_3175_ _3180_/A _3175_/A _3182_/B _3175_/C VPWR VGND sg13cmos5l_nand3_1
XFILLER_26_127 VPWR VGND sg13cmos5l_fill_1
XFILLER_35_650 VPWR VGND sg13cmos5l_decap_4
XFILLER_23_801 VPWR VGND sg13cmos5l_decap_8
XFILLER_34_160 VPWR VGND sg13cmos5l_fill_2
XFILLER_35_683 VPWR VGND sg13cmos5l_decap_4
XFILLER_22_333 VPWR VGND sg13cmos5l_decap_8
XFILLER_23_889 VPWR VGND sg13cmos5l_decap_8
X_2959_ _2960_/C _2959_/A _2958_/A VPWR VGND sg13cmos5l_nor2b_1
XFILLER_10_528 VPWR VGND sg13cmos5l_decap_8
XFILLER_2_749 VPWR VGND sg13cmos5l_decap_8
XFILLER_2_716 VPWR VGND sg13cmos5l_decap_8
Xhold595 _2913_/B _4174_/Q VPWR VGND sg13cmos5l_dlygate4sd3_1
XFILLER_46_915 VPWR VGND sg13cmos5l_decap_8
XFILLER_18_617 VPWR VGND sg13cmos5l_decap_8
XFILLER_18_628 VPWR VGND sg13cmos5l_fill_2
XFILLER_17_149 VPWR VGND sg13cmos5l_decap_4
XFILLER_14_845 VPWR VGND sg13cmos5l_fill_1
XFILLER_15_50 VPWR VGND sg13cmos5l_fill_2
XFILLER_25_182 VPWR VGND sg13cmos5l_decap_4
XFILLER_13_366 VPWR VGND sg13cmos5l_decap_8
XFILLER_14_889 VPWR VGND sg13cmos5l_decap_8
XFILLER_9_359 VPWR VGND sg13cmos5l_decap_4
XFILLER_12_1006 VPWR VGND sg13cmos5l_decap_8
XFILLER_31_71 VPWR VGND sg13cmos5l_fill_1
XFILLER_49_764 VPWR VGND sg13cmos5l_decap_8
XFILLER_37_915 VPWR VGND sg13cmos5l_decap_4
XFILLER_36_425 VPWR VGND sg13cmos5l_decap_8
X_3931_ _3987_/D _3956_/A hold762/X _3935_/S VPWR VGND sg13cmos5l_mux2_1
X_3862_ _3877_/B _3804_/A _3801_/B _3861_/Y VPWR VGND sg13cmos5l_o21ai_1
XFILLER_32_653 VPWR VGND sg13cmos5l_decap_4
X_2813_ _2815_/A _2813_/A _2816_/A VPWR VGND sg13cmos5l_nor2b_1
X_3793_ _3851_/B _4352_/Q _4326_/Q _4354_/Q VPWR VGND sg13cmos5l_nand3_1
X_2744_ _2744_/Y _2744_/A _2744_/B VPWR VGND sg13cmos5l_xnor2_1
X_2675_ _2678_/B _2675_/A _2675_/B VPWR VGND sg13cmos5l_nand2_1
X_4345_ _4345_/Q _4363_/CLK _4345_/D _4345_/RESET_B VPWR VGND sg13cmos5l_dfrbpq_1
XFILLER_28_1002 VPWR VGND sg13cmos5l_decap_8
X_4276_ _4276_/Q _4303_/CLK _4276_/D _4276_/RESET_B VPWR VGND sg13cmos5l_dfrbpq_1
XFILLER_39_252 VPWR VGND sg13cmos5l_decap_8
X_3227_ _3227_/Y _4252_/Q _3227_/B VPWR VGND sg13cmos5l_nor2_1
XFILLER_28_915 VPWR VGND sg13cmos5l_decap_8
X_3158_ _3158_/Y _3158_/A VPWR VGND sg13cmos5l_inv_1
X_4014__221 _4014_/RESET_B VPWR VGND sg13cmos5l_tiehi
X_3089_ _3095_/B _3089_/A _3092_/B VPWR VGND sg13cmos5l_nor2_1
XFILLER_35_480 VPWR VGND sg13cmos5l_fill_2
XFILLER_35_1017 VPWR VGND sg13cmos5l_decap_8
XFILLER_35_1028 VPWR VGND sg13cmos5l_fill_1
XFILLER_23_697 VPWR VGND sg13cmos5l_decap_8
XFILLER_7_808 VPWR VGND sg13cmos5l_decap_8
XFILLER_10_336 VPWR VGND sg13cmos5l_fill_1
XFILLER_7_4 VPWR VGND sg13cmos5l_decap_4
XFILLER_19_915 VPWR VGND sg13cmos5l_fill_1
XFILLER_46_723 VPWR VGND sg13cmos5l_decap_4
XFILLER_18_425 VPWR VGND sg13cmos5l_decap_8
XFILLER_18_458 VPWR VGND sg13cmos5l_fill_1
XFILLER_46_789 VPWR VGND sg13cmos5l_decap_8
XFILLER_45_299 VPWR VGND sg13cmos5l_decap_8
XFILLER_42_940 VPWR VGND sg13cmos5l_decap_8
XFILLER_41_483 VPWR VGND sg13cmos5l_fill_2
XFILLER_13_163 VPWR VGND sg13cmos5l_decap_8
XFILLER_13_174 VPWR VGND sg13cmos5l_fill_1
XFILLER_13_185 VPWR VGND sg13cmos5l_decap_8
X_2460_ _2462_/B input4/X hold840/X _2449_/A VPWR VGND sg13cmos5l_o21ai_1
XFILLER_5_362 VPWR VGND sg13cmos5l_decap_4
X_4130_ _4130_/Q _4363_/CLK _4130_/D _4130_/RESET_B VPWR VGND sg13cmos5l_dfrbpq_1
X_2391_ _2399_/S _3949_/A _2391_/B VPWR VGND sg13cmos5l_nand2_1
X_4061_ _4061_/Q clkload8/A _4061_/D _4061_/RESET_B VPWR VGND sg13cmos5l_dfrbpq_1
XFILLER_49_594 VPWR VGND sg13cmos5l_fill_2
X_3012_ _3012_/Y _3076_/A _4187_/Q VPWR VGND sg13cmos5l_nor2_1
XFILLER_37_767 VPWR VGND sg13cmos5l_decap_8
XFILLER_36_233 VPWR VGND sg13cmos5l_fill_1
XFILLER_36_244 VPWR VGND sg13cmos5l_decap_4
XFILLER_37_778 VPWR VGND sg13cmos5l_fill_1
XFILLER_25_918 VPWR VGND sg13cmos5l_fill_2
XFILLER_36_288 VPWR VGND sg13cmos5l_decap_8
XFILLER_36_299 VPWR VGND sg13cmos5l_fill_2
X_3914_ _3914_/Y _3909_/B _3911_/Y _3913_/Y VPWR VGND sg13cmos5l_o21ai_1
X_3845_ _3856_/B _3845_/A _3848_/B _3848_/C VPWR VGND sg13cmos5l_and3_1
XFILLER_32_494 VPWR VGND sg13cmos5l_decap_8
X_3776_ _3776_/Y hold784/X _3781_/A2 _3615_/A VPWR VGND sg13cmos5l_o21ai_1
X_2727_ _4155_/D _2552_/Y _2725_/B _4142_/D VPWR VGND sg13cmos5l_a21o_1
X_2658_ _2659_/B _4105_/Q _4088_/Q _4071_/Q _4054_/Q _2665_/A _2658_/S1 VPWR VGND
+ sg13cmos5l_mux4_1
Xfanout102 _2435_/A0 input9/X VPWR VGND sg13cmos5l_buf_1
X_2589_ _2589_/Y _2709_/A _2589_/B VPWR VGND sg13cmos5l_nand2_1
Xfanout113 _2438_/A0 input12/X VPWR VGND sg13cmos5l_buf_1
X_4328_ _4328_/Q _4353_/CLK _4328_/D _4328_/RESET_B VPWR VGND sg13cmos5l_dfrbpq_1
Xfanout124 _2718_/A _3890_/B1 VPWR VGND sg13cmos5l_buf_1
X_4259_ _4259_/Q _4262_/CLK _4259_/D _4259_/RESET_B VPWR VGND sg13cmos5l_dfrbpq_1
XFILLER_15_417 VPWR VGND sg13cmos5l_decap_8
XFILLER_27_277 VPWR VGND sg13cmos5l_decap_8
XFILLER_28_778 VPWR VGND sg13cmos5l_fill_2
XFILLER_27_288 VPWR VGND sg13cmos5l_fill_2
XFILLER_24_962 VPWR VGND sg13cmos5l_decap_4
XFILLER_3_855 VPWR VGND sg13cmos5l_fill_1
XFILLER_2_354 VPWR VGND sg13cmos5l_decap_8
XFILLER_2_398 VPWR VGND sg13cmos5l_fill_2
XFILLER_18_211 VPWR VGND sg13cmos5l_fill_2
XFILLER_19_745 VPWR VGND sg13cmos5l_decap_8
XFILLER_46_564 VPWR VGND sg13cmos5l_decap_8
XFILLER_18_244 VPWR VGND sg13cmos5l_fill_1
XFILLER_34_726 VPWR VGND sg13cmos5l_decap_8
XFILLER_15_962 VPWR VGND sg13cmos5l_fill_2
XFILLER_18_1012 VPWR VGND sg13cmos5l_decap_8
XFILLER_21_409 VPWR VGND sg13cmos5l_fill_2
XFILLER_33_247 VPWR VGND sg13cmos5l_decap_8
XFILLER_14_472 VPWR VGND sg13cmos5l_decap_8
XFILLER_30_954 VPWR VGND sg13cmos5l_decap_8
X_3630_ _3654_/C _3625_/Y _3627_/Y _3629_/Y VPWR VGND sg13cmos5l_a21o_1
X_3561_ _3562_/B _3561_/A _3565_/B VPWR VGND sg13cmos5l_nor2b_1
XFILLER_6_671 VPWR VGND sg13cmos5l_decap_8
X_2512_ _4134_/D _2215_/Y _2515_/B1 _2511_/Y VPWR VGND sg13cmos5l_a21oi_1
X_3492_ _3492_/Y _3481_/X _3501_/A _3491_/Y VPWR VGND sg13cmos5l_o21ai_1
X_2443_ _2547_/B _2679_/A _2546_/B VPWR VGND sg13cmos5l_nand2_1
X_2374_ _4053_/D _2434_/A0 hold778/X _2380_/S VPWR VGND sg13cmos5l_mux2_1
X_4113_ _4113_/Q _4136_/CLK _4113_/D _4113_/RESET_B VPWR VGND sg13cmos5l_dfrbpq_1
X_4044_ _4044_/Q clkload8/A _4044_/D _4044_/RESET_B VPWR VGND sg13cmos5l_dfrbpq_1
XFILLER_25_759 VPWR VGND sg13cmos5l_decap_8
XFILLER_33_39 VPWR VGND sg13cmos5l_decap_8
XFILLER_32_1009 VPWR VGND sg13cmos5l_decap_8
X_3828_ _3845_/A _3828_/A VPWR VGND sg13cmos5l_inv_1
XFILLER_4_619 VPWR VGND sg13cmos5l_decap_4
X_3759_ _3759_/Y _4346_/Q _3759_/B VPWR VGND sg13cmos5l_nor2_1
XFILLER_0_858 VPWR VGND sg13cmos5l_decap_8
XFILLER_47_328 VPWR VGND sg13cmos5l_decap_8
XFILLER_47_339 VPWR VGND sg13cmos5l_fill_2
XFILLER_43_512 VPWR VGND sg13cmos5l_decap_8
XFILLER_43_556 VPWR VGND sg13cmos5l_fill_2
XFILLER_11_431 VPWR VGND sg13cmos5l_decap_8
XFILLER_11_442 VPWR VGND sg13cmos5l_fill_2
XFILLER_12_943 VPWR VGND sg13cmos5l_decap_8
XFILLER_7_402 VPWR VGND sg13cmos5l_decap_8
XFILLER_8_969 VPWR VGND sg13cmos5l_decap_8
XFILLER_7_446 VPWR VGND sg13cmos5l_fill_2
XFILLER_7_479 VPWR VGND sg13cmos5l_fill_2
XFILLER_48_1027 VPWR VGND sg13cmos5l_fill_2
XFILLER_3_630 VPWR VGND sg13cmos5l_fill_2
XFILLER_3_652 VPWR VGND sg13cmos5l_fill_2
XFILLER_3_674 VPWR VGND sg13cmos5l_decap_4
XFILLER_48_91 VPWR VGND sg13cmos5l_decap_4
XFILLER_47_884 VPWR VGND sg13cmos5l_decap_8
XFILLER_0_21 VPWR VGND sg13cmos5l_decap_8
X_4214__169 _4214_/D VPWR VGND sg13cmos5l_tielo
XFILLER_34_523 VPWR VGND sg13cmos5l_decap_8
X_2992_ _4210_/D _3123_/A _2992_/B VPWR VGND sg13cmos5l_and2_1
X_4114__270 _4114_/RESET_B VPWR VGND sg13cmos5l_tiehi
XFILLER_21_206 VPWR VGND sg13cmos5l_decap_8
XFILLER_30_773 VPWR VGND sg13cmos5l_decap_8
X_3613_ _4323_/D _2211_/Y _3613_/A2 _3612_/Y VPWR VGND sg13cmos5l_a21oi_1
XFILLER_31_1020 VPWR VGND sg13cmos5l_decap_8
Xhold903 _4365_/D _3891_/Y VPWR VGND sg13cmos5l_dlygate4sd3_1
XFILLER_7_991 VPWR VGND sg13cmos5l_decap_8
X_3544_ _3547_/B _4281_/Q _4280_/Q _4279_/Q _4278_/Q VPWR VGND sg13cmos5l_nor4_1
Xhold925 _3599_/B _4316_/Q VPWR VGND sg13cmos5l_dlygate4sd3_1
Xhold914 hold914/X _4284_/Q VPWR VGND sg13cmos5l_dlygate4sd3_1
Xhold936 _2278_/A _4283_/Q VPWR VGND sg13cmos5l_dlygate4sd3_1
Xhold958 _2831_/B _4183_/Q VPWR VGND sg13cmos5l_dlygate4sd3_1
Xhold969 _4317_/D _3604_/Y VPWR VGND sg13cmos5l_dlygate4sd3_1
X_3475_ _3475_/X _3476_/B _3476_/C VPWR VGND sg13cmos5l_and2_1
Xhold947 _2807_/A _4177_/Q VPWR VGND sg13cmos5l_dlygate4sd3_1
X_2426_ _4097_/D _2435_/A0 hold693/X _2430_/S VPWR VGND sg13cmos5l_mux2_1
XFILLER_9_1021 VPWR VGND sg13cmos5l_decap_8
X_2357_ _2357_/X _3946_/A hold768/X _2357_/S VPWR VGND sg13cmos5l_mux2_1
X_2288_ _2535_/A _3911_/A _2288_/B _3900_/A VPWR VGND sg13cmos5l_nor3_1
X_4027_ _4027_/Q clkload8/A _4027_/D _4027_/RESET_B VPWR VGND sg13cmos5l_dfrbpq_1
XFILLER_38_873 VPWR VGND sg13cmos5l_decap_8
XFILLER_25_501 VPWR VGND sg13cmos5l_decap_8
XFILLER_37_394 VPWR VGND sg13cmos5l_decap_8
XFILLER_13_707 VPWR VGND sg13cmos5l_decap_8
XFILLER_40_526 VPWR VGND sg13cmos5l_decap_8
XFILLER_12_217 VPWR VGND sg13cmos5l_decap_4
XFILLER_20_250 VPWR VGND sg13cmos5l_decap_4
XFILLER_21_762 VPWR VGND sg13cmos5l_decap_8
XFILLER_21_795 VPWR VGND sg13cmos5l_decap_4
XFILLER_4_427 VPWR VGND sg13cmos5l_fill_2
XFILLER_0_666 VPWR VGND sg13cmos5l_decap_8
XFILLER_18_61 VPWR VGND sg13cmos5l_decap_8
XFILLER_29_851 VPWR VGND sg13cmos5l_decap_8
XFILLER_44_876 VPWR VGND sg13cmos5l_decap_8
XFILLER_43_342 VPWR VGND sg13cmos5l_decap_4
XFILLER_43_331 VPWR VGND sg13cmos5l_fill_1
XFILLER_43_320 VPWR VGND sg13cmos5l_decap_8
XFILLER_16_545 VPWR VGND sg13cmos5l_fill_1
XFILLER_28_394 VPWR VGND sg13cmos5l_decap_8
XFILLER_31_515 VPWR VGND sg13cmos5l_decap_4
XFILLER_7_221 VPWR VGND sg13cmos5l_fill_2
XFILLER_12_795 VPWR VGND sg13cmos5l_fill_2
XFILLER_8_777 VPWR VGND sg13cmos5l_decap_4
XFILLER_7_287 VPWR VGND sg13cmos5l_fill_1
XFILLER_7_276 VPWR VGND sg13cmos5l_decap_8
X_3260_ _4267_/D _3260_/A _3260_/B VPWR VGND sg13cmos5l_and2_1
XFILLER_39_604 VPWR VGND sg13cmos5l_fill_2
X_2211_ _2211_/Y _3635_/A VPWR VGND sg13cmos5l_inv_1
XFILLER_22_4 VPWR VGND sg13cmos5l_fill_2
X_3191_ _3205_/B _3183_/X _3187_/Y _3200_/B _2998_/A _3189_/X VPWR VGND sg13cmos5l_a221oi_1
X_4233__501 _4233_/RESET_B VPWR VGND sg13cmos5l_tiehi
XFILLER_19_350 VPWR VGND sg13cmos5l_fill_1
X_4151__201 _4151_/RESET_B VPWR VGND sg13cmos5l_tiehi
XFILLER_47_692 VPWR VGND sg13cmos5l_decap_8
XFILLER_35_821 VPWR VGND sg13cmos5l_fill_2
XFILLER_22_515 VPWR VGND sg13cmos5l_decap_8
X_2975_ _3175_/A _4237_/Q _4238_/Q VPWR VGND sg13cmos5l_xnor2_1
Xhold711 hold711/X _4054_/Q VPWR VGND sg13cmos5l_dlygate4sd3_1
Xhold700 hold700/X _4039_/Q VPWR VGND sg13cmos5l_dlygate4sd3_1
Xhold755 hold755/X _4031_/Q VPWR VGND sg13cmos5l_dlygate4sd3_1
Xhold744 hold744/X _4027_/Q VPWR VGND sg13cmos5l_dlygate4sd3_1
Xhold722 hold722/X _4064_/Q VPWR VGND sg13cmos5l_dlygate4sd3_1
X_3527_ _3527_/Y _3522_/Y _3523_/X _3536_/B VPWR VGND sg13cmos5l_o21ai_1
Xhold733 hold733/X _4034_/Q VPWR VGND sg13cmos5l_dlygate4sd3_1
Xhold788 hold788/X _4017_/Q VPWR VGND sg13cmos5l_dlygate4sd3_1
Xhold777 hold777/X _4042_/Q VPWR VGND sg13cmos5l_dlygate4sd3_1
Xhold766 hold766/X _4106_/Q VPWR VGND sg13cmos5l_dlygate4sd3_1
Xhold799 _2480_/A _4120_/Q VPWR VGND sg13cmos5l_dlygate4sd3_1
X_3458_ _3488_/B _3456_/Y _3457_/Y _3455_/Y VPWR VGND sg13cmos5l_a21oi_1
X_2409_ _4083_/D _3946_/A hold775/X _2410_/S VPWR VGND sg13cmos5l_mux2_1
X_3389_ _3473_/A _3447_/C _3447_/D VPWR VGND sg13cmos5l_or2_1
XFILLER_29_147 VPWR VGND sg13cmos5l_fill_2
XFILLER_29_169 VPWR VGND sg13cmos5l_fill_1
XFILLER_38_681 VPWR VGND sg13cmos5l_decap_8
XFILLER_41_824 VPWR VGND sg13cmos5l_fill_2
XFILLER_41_802 VPWR VGND sg13cmos5l_fill_1
XFILLER_40_312 VPWR VGND sg13cmos5l_decap_8
XFILLER_25_397 VPWR VGND sg13cmos5l_decap_8
XFILLER_41_879 VPWR VGND sg13cmos5l_decap_8
XFILLER_5_736 VPWR VGND sg13cmos5l_decap_8
XFILLER_45_1008 VPWR VGND sg13cmos5l_decap_8
XFILLER_4_279 VPWR VGND sg13cmos5l_fill_2
X_4104__280 _4104_/RESET_B VPWR VGND sg13cmos5l_tiehi
XFILLER_1_964 VPWR VGND sg13cmos5l_decap_8
XFILLER_49_946 VPWR VGND sg13cmos5l_decap_8
XFILLER_0_496 VPWR VGND sg13cmos5l_decap_8
XFILLER_36_629 VPWR VGND sg13cmos5l_fill_1
XFILLER_29_670 VPWR VGND sg13cmos5l_decap_4
XFILLER_28_191 VPWR VGND sg13cmos5l_fill_1
XFILLER_16_364 VPWR VGND sg13cmos5l_decap_4
X_4111__273 _4111_/RESET_B VPWR VGND sg13cmos5l_tiehi
X_2760_ _2760_/Y _4144_/Q _2760_/B VPWR VGND sg13cmos5l_nor2_1
X_2691_ _2692_/B _4097_/Q _4080_/Q _4063_/Q _4046_/Q _2708_/S0 _2708_/S1 VPWR VGND
+ sg13cmos5l_mux4_1
XFILLER_12_592 VPWR VGND sg13cmos5l_fill_2
X_4361_ _4361_/Q clkload5/A _4361_/D _4361_/RESET_B VPWR VGND sg13cmos5l_dfrbpq_1
X_4292_ _4292_/Q _4323_/CLK _4292_/D _4292_/RESET_B VPWR VGND sg13cmos5l_dfrbpq_1
X_3312_ _3312_/Y _3278_/Y _3286_/X _3311_/Y VPWR VGND sg13cmos5l_a21oi_1
X_3243_ _3243_/Y _3243_/A _3243_/B VPWR VGND sg13cmos5l_nor2_1
X_3174_ _3175_/C _4215_/Q _4216_/Q _4217_/Q VPWR VGND sg13cmos5l_o21ai_1
XFILLER_10_507 VPWR VGND sg13cmos5l_decap_8
X_2958_ _2960_/B _2958_/A _2951_/A VPWR VGND sg13cmos5l_nor2b_1
X_2889_ _2893_/B _2885_/Y _2886_/Y _2887_/Y _2888_/Y VPWR VGND sg13cmos5l_a22oi_1
Xhold596 _2786_/B _4152_/Q VPWR VGND sg13cmos5l_dlygate4sd3_1
XFILLER_14_802 VPWR VGND sg13cmos5l_fill_2
XFILLER_25_150 VPWR VGND sg13cmos5l_fill_1
XFILLER_41_632 VPWR VGND sg13cmos5l_decap_8
XFILLER_13_301 VPWR VGND sg13cmos5l_decap_8
XFILLER_14_857 VPWR VGND sg13cmos5l_decap_8
XFILLER_40_186 VPWR VGND sg13cmos5l_fill_2
XFILLER_49_743 VPWR VGND sg13cmos5l_decap_8
XFILLER_49_710 VPWR VGND sg13cmos5l_decap_8
XFILLER_36_415 VPWR VGND sg13cmos5l_fill_2
X_4230__504 _4230_/RESET_B VPWR VGND sg13cmos5l_tiehi
X_3930_ _3986_/D _3954_/A hold795/X _3935_/S VPWR VGND sg13cmos5l_mux2_1
XFILLER_17_695 VPWR VGND sg13cmos5l_decap_8
XFILLER_32_610 VPWR VGND sg13cmos5l_decap_8
X_3861_ _3861_/Y _3861_/A _3861_/B VPWR VGND sg13cmos5l_xnor2_1
XFILLER_20_816 VPWR VGND sg13cmos5l_fill_2
X_2812_ _2816_/A _2804_/D _2803_/B _2811_/Y VPWR VGND sg13cmos5l_a21o_1
X_3792_ _3851_/A _4353_/Q _3802_/B VPWR VGND sg13cmos5l_nand2_1
X_2743_ _2743_/Y _2866_/A _2735_/A _2869_/A VPWR VGND sg13cmos5l_o21ai_1
XFILLER_31_197 VPWR VGND sg13cmos5l_fill_1
XFILLER_9_894 VPWR VGND sg13cmos5l_decap_4
X_2674_ _2675_/B _4041_/Q _4024_/Q _4007_/Q _3990_/Q _2654_/S _2704_/A1 VPWR VGND
+ sg13cmos5l_mux4_1
X_4344_ _4344_/Q clkload6/A _4344_/D _4344_/RESET_B VPWR VGND sg13cmos5l_dfrbpq_1
X_4275_ _4275_/Q _4303_/CLK _4275_/D _4275_/RESET_B VPWR VGND sg13cmos5l_dfrbpq_1
X_3226_ _3227_/B _3221_/B _3224_/Y _3225_/Y _3222_/C VPWR VGND sg13cmos5l_a22oi_1
X_3157_ _3158_/A _3169_/A _3157_/B VPWR VGND sg13cmos5l_nor2_1
XFILLER_43_919 VPWR VGND sg13cmos5l_decap_8
XFILLER_42_407 VPWR VGND sg13cmos5l_decap_4
XFILLER_36_982 VPWR VGND sg13cmos5l_decap_8
X_3088_ _3115_/A _3086_/Y _3114_/C _3114_/A VPWR VGND sg13cmos5l_a21oi_1
XFILLER_22_164 VPWR VGND sg13cmos5l_decap_8
XFILLER_10_348 VPWR VGND sg13cmos5l_decap_8
XFILLER_6_319 VPWR VGND sg13cmos5l_fill_1
XFILLER_2_536 VPWR VGND sg13cmos5l_decap_8
X_4240__165 _4240_/D VPWR VGND sg13cmos5l_tielo
XFILLER_2_558 VPWR VGND sg13cmos5l_decap_8
X_4101__283 _4101_/RESET_B VPWR VGND sg13cmos5l_tiehi
XFILLER_46_768 VPWR VGND sg13cmos5l_decap_8
XFILLER_45_223 VPWR VGND sg13cmos5l_decap_4
XFILLER_26_470 VPWR VGND sg13cmos5l_decap_4
XFILLER_42_996 VPWR VGND sg13cmos5l_decap_8
XFILLER_14_676 VPWR VGND sg13cmos5l_fill_1
XFILLER_42_71 VPWR VGND sg13cmos5l_fill_2
XFILLER_9_135 VPWR VGND sg13cmos5l_decap_8
XFILLER_6_875 VPWR VGND sg13cmos5l_fill_1
XFILLER_5_396 VPWR VGND sg13cmos5l_fill_1
XFILLER_5_385 VPWR VGND sg13cmos5l_decap_8
X_4297__431 _4297_/RESET_B VPWR VGND sg13cmos5l_tiehi
X_2390_ _4067_/D _2439_/A0 hold694/X _2390_/S VPWR VGND sg13cmos5l_mux2_1
XFILLER_3_43 VPWR VGND sg13cmos5l_decap_4
XFILLER_49_540 VPWR VGND sg13cmos5l_fill_1
X_4060_ _4060_/Q _4128_/CLK _4060_/D _4060_/RESET_B VPWR VGND sg13cmos5l_dfrbpq_1
XFILLER_49_573 VPWR VGND sg13cmos5l_decap_8
X_3011_ _3011_/X _3016_/B _3016_/C _3016_/A VPWR VGND sg13cmos5l_a21o_1
XFILLER_3_1027 VPWR VGND sg13cmos5l_fill_2
XFILLER_37_735 VPWR VGND sg13cmos5l_decap_4
XFILLER_25_908 VPWR VGND sg13cmos5l_decap_4
XFILLER_18_971 VPWR VGND sg13cmos5l_decap_8
XFILLER_36_267 VPWR VGND sg13cmos5l_fill_2
XFILLER_33_930 VPWR VGND sg13cmos5l_decap_4
X_3913_ _3913_/Y _2535_/A _3912_/Y _4375_/Q VPWR VGND sg13cmos5l_o21ai_1
X_3844_ _3854_/S _3848_/B _3848_/C VPWR VGND sg13cmos5l_and2_1
XFILLER_20_613 VPWR VGND sg13cmos5l_fill_2
X_3775_ _4349_/D _3775_/A _3775_/B VPWR VGND sg13cmos5l_and2_1
XFILLER_9_680 VPWR VGND sg13cmos5l_fill_2
X_2726_ _4154_/D _4141_/D _2726_/B VPWR VGND sg13cmos5l_and2_1
X_2657_ _2657_/Y _2657_/A1 _2654_/X _2300_/A VPWR VGND sg13cmos5l_o21ai_1
X_4124__250 _4124_/RESET_B VPWR VGND sg13cmos5l_tiehi
Xfanout103 _3954_/A input9/X VPWR VGND sg13cmos5l_buf_1
X_2588_ _2589_/B _4096_/Q _4079_/Q _4062_/Q _4045_/Q _2708_/S0 _2708_/S1 VPWR VGND
+ sg13cmos5l_mux4_1
Xfanout114 _2437_/A0 input11/X VPWR VGND sg13cmos5l_buf_1
Xfanout125 _3890_/B1 input1/X VPWR VGND sg13cmos5l_buf_1
X_4327_ _4327_/Q _4353_/CLK _4327_/D _4327_/RESET_B VPWR VGND sg13cmos5l_dfrbpq_1
XFILLER_41_1011 VPWR VGND sg13cmos5l_decap_8
X_4258_ _4258_/Q _4262_/CLK _4258_/D _4258_/RESET_B VPWR VGND sg13cmos5l_dfrbpq_1
X_3209_ _3305_/B _3189_/B _3200_/B _2969_/Y VPWR VGND sg13cmos5l_o21ai_1
X_4189_ _4189_/Q _4238_/CLK _4189_/D _4189_/RESET_B VPWR VGND sg13cmos5l_dfrbpq_1
XFILLER_43_716 VPWR VGND sg13cmos5l_fill_2
XFILLER_24_941 VPWR VGND sg13cmos5l_decap_8
XFILLER_10_123 VPWR VGND sg13cmos5l_fill_2
XFILLER_10_189 VPWR VGND sg13cmos5l_decap_8
XFILLER_12_41 VPWR VGND sg13cmos5l_decap_4
XFILLER_2_377 VPWR VGND sg13cmos5l_decap_8
XFILLER_19_779 VPWR VGND sg13cmos5l_fill_2
XFILLER_46_587 VPWR VGND sg13cmos5l_decap_8
XFILLER_15_930 VPWR VGND sg13cmos5l_fill_1
XFILLER_33_204 VPWR VGND sg13cmos5l_decap_8
XFILLER_33_215 VPWR VGND sg13cmos5l_fill_1
XFILLER_33_259 VPWR VGND sg13cmos5l_decap_8
XFILLER_14_451 VPWR VGND sg13cmos5l_decap_8
XFILLER_15_996 VPWR VGND sg13cmos5l_decap_8
XFILLER_30_911 VPWR VGND sg13cmos5l_decap_4
XFILLER_30_922 VPWR VGND sg13cmos5l_fill_1
XFILLER_42_793 VPWR VGND sg13cmos5l_fill_2
X_3560_ _3562_/A _3545_/X _3546_/Y _3565_/B _3356_/B _3560_/C1 VPWR VGND sg13cmos5l_a221oi_1
X_4182__174 _4182_/D VPWR VGND sg13cmos5l_tielo
XFILLER_6_650 VPWR VGND sg13cmos5l_fill_2
X_2511_ _2511_/Y _2515_/B1 hold633/X _2449_/A VPWR VGND sg13cmos5l_o21ai_1
XFILLER_6_683 VPWR VGND sg13cmos5l_fill_1
XFILLER_5_160 VPWR VGND sg13cmos5l_decap_8
X_3491_ _3491_/Y _3493_/A _3493_/B VPWR VGND sg13cmos5l_nand2_1
X_2442_ _2546_/B _2544_/A _2710_/A VPWR VGND sg13cmos5l_and2_1
X_2373_ _4052_/D _3965_/A0 hold752/X _2380_/S VPWR VGND sg13cmos5l_mux2_1
X_4112_ _4112_/Q _4136_/CLK _4112_/D _4112_/RESET_B VPWR VGND sg13cmos5l_dfrbpq_1
X_4043_ _4043_/Q _4128_/CLK _4043_/D _4043_/RESET_B VPWR VGND sg13cmos5l_dfrbpq_1
XFILLER_49_392 VPWR VGND sg13cmos5l_fill_1
XFILLER_25_738 VPWR VGND sg13cmos5l_fill_2
XFILLER_40_708 VPWR VGND sg13cmos5l_decap_8
XFILLER_33_760 VPWR VGND sg13cmos5l_decap_8
XFILLER_33_771 VPWR VGND sg13cmos5l_fill_2
XFILLER_20_432 VPWR VGND sg13cmos5l_fill_1
XFILLER_21_944 VPWR VGND sg13cmos5l_decap_8
XFILLER_21_955 VPWR VGND sg13cmos5l_fill_1
X_3827_ _3828_/A _3783_/A _3826_/Y _3834_/B VPWR VGND sg13cmos5l_mux2_1
X_3758_ _3759_/B _3757_/B _3756_/Y _3757_/Y VPWR VGND sg13cmos5l_a21oi_1
XFILLER_20_498 VPWR VGND sg13cmos5l_decap_8
X_2709_ _2710_/C _2709_/A _2709_/B VPWR VGND sg13cmos5l_nand2_1
X_3689_ _3689_/X _3701_/B _3690_/B VPWR VGND sg13cmos5l_and2_1
XFILLER_0_837 VPWR VGND sg13cmos5l_decap_8
XFILLER_28_554 VPWR VGND sg13cmos5l_decap_4
XFILLER_43_535 VPWR VGND sg13cmos5l_decap_8
XFILLER_12_922 VPWR VGND sg13cmos5l_decap_8
XFILLER_11_410 VPWR VGND sg13cmos5l_fill_1
XFILLER_23_292 VPWR VGND sg13cmos5l_decap_8
XFILLER_8_948 VPWR VGND sg13cmos5l_decap_8
XFILLER_11_465 VPWR VGND sg13cmos5l_decap_8
XFILLER_12_999 VPWR VGND sg13cmos5l_decap_8
XFILLER_11_476 VPWR VGND sg13cmos5l_fill_1
XFILLER_48_1006 VPWR VGND sg13cmos5l_decap_8
XFILLER_3_686 VPWR VGND sg13cmos5l_decap_8
XFILLER_2_163 VPWR VGND sg13cmos5l_fill_1
X_4294__434 _4294_/RESET_B VPWR VGND sg13cmos5l_tiehi
XFILLER_48_70 VPWR VGND sg13cmos5l_decap_8
XFILLER_47_863 VPWR VGND sg13cmos5l_decap_8
XFILLER_0_77 VPWR VGND sg13cmos5l_decap_8
XFILLER_0_1019 VPWR VGND sg13cmos5l_decap_8
X_2991_ _2992_/B _2999_/S _3197_/A _2990_/Y VPWR VGND sg13cmos5l_a21o_1
XFILLER_14_281 VPWR VGND sg13cmos5l_decap_8
X_4227__509 _4227_/RESET_B VPWR VGND sg13cmos5l_tiehi
XFILLER_9_75 VPWR VGND sg13cmos5l_decap_8
XFILLER_30_763 VPWR VGND sg13cmos5l_decap_4
X_3612_ _3612_/Y hold835/X _3613_/A2 _3616_/A VPWR VGND sg13cmos5l_o21ai_1
XFILLER_7_970 VPWR VGND sg13cmos5l_decap_8
Xhold904 _2284_/A _4221_/Q VPWR VGND sg13cmos5l_dlygate4sd3_1
Xhold926 _3768_/B _3767_/X VPWR VGND sg13cmos5l_dlygate4sd3_1
X_3543_ _3556_/B _4280_/Q _4279_/Q _4278_/Q VPWR VGND sg13cmos5l_or3_1
Xhold915 _4284_/D _3425_/Y VPWR VGND sg13cmos5l_dlygate4sd3_1
Xhold937 _2324_/A _4127_/Q VPWR VGND sg13cmos5l_dlygate4sd3_1
Xhold959 hold959/X _2847_/A VPWR VGND sg13cmos5l_dlygate4sd3_1
Xhold948 _2817_/A _2808_/Y VPWR VGND sg13cmos5l_dlygate4sd3_1
X_3474_ _3476_/C _3483_/B _3483_/C _3355_/B VPWR VGND sg13cmos5l_a21o_1
XFILLER_9_1000 VPWR VGND sg13cmos5l_decap_8
X_2425_ _4096_/D _2434_/A0 hold732/X _2430_/S VPWR VGND sg13cmos5l_mux2_1
X_2356_ _4039_/D _3958_/A hold700/X _2359_/S VPWR VGND sg13cmos5l_mux2_1
X_2287_ _3912_/A _4368_/Q _4367_/Q VPWR VGND sg13cmos5l_nor2_1
XFILLER_38_863 VPWR VGND sg13cmos5l_fill_1
XFILLER_37_351 VPWR VGND sg13cmos5l_decap_8
X_4026_ _4026_/Q _4128_/CLK _4026_/D _4026_/RESET_B VPWR VGND sg13cmos5l_dfrbpq_1
XFILLER_38_885 VPWR VGND sg13cmos5l_decap_8
XFILLER_25_524 VPWR VGND sg13cmos5l_decap_8
XFILLER_40_516 VPWR VGND sg13cmos5l_decap_4
XFILLER_21_752 VPWR VGND sg13cmos5l_fill_1
XFILLER_0_656 VPWR VGND sg13cmos5l_fill_2
XFILLER_29_841 VPWR VGND sg13cmos5l_fill_1
XFILLER_28_351 VPWR VGND sg13cmos5l_decap_8
XFILLER_28_340 VPWR VGND sg13cmos5l_fill_1
XFILLER_29_885 VPWR VGND sg13cmos5l_decap_8
XFILLER_29_896 VPWR VGND sg13cmos5l_fill_2
XFILLER_44_855 VPWR VGND sg13cmos5l_decap_8
XFILLER_16_557 VPWR VGND sg13cmos5l_decap_8
XFILLER_12_774 VPWR VGND sg13cmos5l_decap_8
XFILLER_8_756 VPWR VGND sg13cmos5l_decap_8
XFILLER_8_734 VPWR VGND sg13cmos5l_decap_8
XFILLER_7_233 VPWR VGND sg13cmos5l_decap_8
XFILLER_7_299 VPWR VGND sg13cmos5l_decap_8
XFILLER_4_984 VPWR VGND sg13cmos5l_decap_8
XFILLER_3_461 VPWR VGND sg13cmos5l_decap_8
X_2210_ _2210_/Y _2210_/A VPWR VGND sg13cmos5l_inv_1
XFILLER_39_627 VPWR VGND sg13cmos5l_decap_8
X_3190_ _3190_/Y _3189_/A _3189_/B _3200_/B _2998_/A VPWR VGND sg13cmos5l_a22oi_1
XFILLER_38_137 VPWR VGND sg13cmos5l_fill_1
XFILLER_15_4 VPWR VGND sg13cmos5l_decap_8
XFILLER_38_148 VPWR VGND sg13cmos5l_fill_2
XFILLER_22_527 VPWR VGND sg13cmos5l_decap_4
XFILLER_34_387 VPWR VGND sg13cmos5l_fill_1
X_2974_ _2974_/Y _2998_/A _2974_/B VPWR VGND sg13cmos5l_nand2_1
Xhold712 hold712/X _4018_/Q VPWR VGND sg13cmos5l_dlygate4sd3_1
Xhold701 hold701/X _4060_/Q VPWR VGND sg13cmos5l_dlygate4sd3_1
X_3526_ _3536_/B _4336_/Q _3822_/B VPWR VGND sg13cmos5l_xnor2_1
Xhold734 hold734/X _3989_/Q VPWR VGND sg13cmos5l_dlygate4sd3_1
Xhold745 hold745/X _4021_/Q VPWR VGND sg13cmos5l_dlygate4sd3_1
Xhold723 hold723/X _4062_/Q VPWR VGND sg13cmos5l_dlygate4sd3_1
Xhold778 hold778/X _4053_/Q VPWR VGND sg13cmos5l_dlygate4sd3_1
Xhold756 hold756/X _4110_/Q VPWR VGND sg13cmos5l_dlygate4sd3_1
Xhold767 hold767/X _4023_/Q VPWR VGND sg13cmos5l_dlygate4sd3_1
Xhold789 hold789/X _4099_/Q VPWR VGND sg13cmos5l_dlygate4sd3_1
X_3457_ _3457_/Y _4290_/Q _4261_/Q VPWR VGND sg13cmos5l_xnor2_1
X_2408_ _4082_/D _2437_/A0 hold730/X _2410_/S VPWR VGND sg13cmos5l_mux2_1
X_3388_ _3447_/D _3388_/A _3388_/B VPWR VGND sg13cmos5l_and2_1
X_2339_ _3937_/A _4123_/Q _2293_/A _2338_/Y VPWR VGND sg13cmos5l_a21oi_1
XFILLER_44_129 VPWR VGND sg13cmos5l_fill_1
X_4009_ _4009_/Q clkload9/A _4009_/D _4009_/RESET_B VPWR VGND sg13cmos5l_dfrbpq_1
XFILLER_13_505 VPWR VGND sg13cmos5l_decap_8
XFILLER_21_582 VPWR VGND sg13cmos5l_decap_8
XFILLER_5_715 VPWR VGND sg13cmos5l_decap_8
XFILLER_1_943 VPWR VGND sg13cmos5l_decap_8
XFILLER_49_925 VPWR VGND sg13cmos5l_decap_8
XFILLER_0_453 VPWR VGND sg13cmos5l_decap_8
XFILLER_17_822 VPWR VGND sg13cmos5l_decap_8
XFILLER_16_310 VPWR VGND sg13cmos5l_fill_1
XFILLER_17_833 VPWR VGND sg13cmos5l_fill_2
XFILLER_17_855 VPWR VGND sg13cmos5l_decap_8
XFILLER_44_663 VPWR VGND sg13cmos5l_fill_2
XFILLER_17_888 VPWR VGND sg13cmos5l_decap_8
XFILLER_32_814 VPWR VGND sg13cmos5l_fill_2
XFILLER_16_387 VPWR VGND sg13cmos5l_decap_8
XFILLER_31_324 VPWR VGND sg13cmos5l_decap_4
XFILLER_40_891 VPWR VGND sg13cmos5l_decap_4
X_2690_ _2690_/Y _2690_/A1 _2687_/X _2675_/A VPWR VGND sg13cmos5l_o21ai_1
XFILLER_8_553 VPWR VGND sg13cmos5l_fill_1
X_4360_ _4360_/Q clkload5/A _4360_/D _4360_/RESET_B VPWR VGND sg13cmos5l_dfrbpq_1
X_3311_ _3311_/Y _3311_/A _3311_/B VPWR VGND sg13cmos5l_nor2_1
X_4291_ _4291_/Q _4323_/CLK _4291_/D _4291_/RESET_B VPWR VGND sg13cmos5l_dfrbpq_1
X_3242_ _3242_/Y hold887/X _3236_/Y _3260_/B VPWR VGND sg13cmos5l_o21ai_1
XFILLER_6_1014 VPWR VGND sg13cmos5l_decap_8
X_3173_ _3182_/B _4217_/Q _4215_/Q _4216_/Q VPWR VGND sg13cmos5l_or3_1
XFILLER_39_479 VPWR VGND sg13cmos5l_decap_8
X_3992__441 _3992_/RESET_B VPWR VGND sg13cmos5l_tiehi
XFILLER_47_490 VPWR VGND sg13cmos5l_decap_4
XFILLER_35_630 VPWR VGND sg13cmos5l_fill_2
XFILLER_34_162 VPWR VGND sg13cmos5l_fill_1
X_2957_ _4206_/D _2957_/A _2957_/B VPWR VGND sg13cmos5l_nor2_1
X_2888_ _2888_/Y _4168_/Q _2888_/B VPWR VGND sg13cmos5l_nor2_1
X_3509_ _3509_/X _4309_/Q _3510_/B VPWR VGND sg13cmos5l_xor2_1
Xhold597 _3087_/B _4201_/Q VPWR VGND sg13cmos5l_dlygate4sd3_1
XFILLER_39_991 VPWR VGND sg13cmos5l_decap_8
X_4134__230 _4134_/RESET_B VPWR VGND sg13cmos5l_tiehi
XFILLER_25_140 VPWR VGND sg13cmos5l_fill_1
XFILLER_13_324 VPWR VGND sg13cmos5l_decap_8
XFILLER_41_666 VPWR VGND sg13cmos5l_fill_2
XFILLER_41_699 VPWR VGND sg13cmos5l_fill_2
XFILLER_41_688 VPWR VGND sg13cmos5l_fill_2
XFILLER_9_328 VPWR VGND sg13cmos5l_decap_8
XFILLER_22_880 VPWR VGND sg13cmos5l_decap_8
XFILLER_5_523 VPWR VGND sg13cmos5l_fill_2
XFILLER_5_545 VPWR VGND sg13cmos5l_decap_8
XFILLER_49_799 VPWR VGND sg13cmos5l_decap_8
XFILLER_37_928 VPWR VGND sg13cmos5l_fill_1
XFILLER_17_630 VPWR VGND sg13cmos5l_fill_2
XFILLER_29_490 VPWR VGND sg13cmos5l_decap_8
XFILLER_16_140 VPWR VGND sg13cmos5l_fill_1
XFILLER_45_994 VPWR VGND sg13cmos5l_decap_8
X_3860_ _3861_/B _3860_/A _3860_/B VPWR VGND sg13cmos5l_nand2_1
XFILLER_31_121 VPWR VGND sg13cmos5l_decap_8
XFILLER_31_143 VPWR VGND sg13cmos5l_decap_8
X_2811_ _2811_/Y _2805_/Y _2809_/Y _2810_/Y VPWR VGND sg13cmos5l_a21oi_1
X_3791_ _3804_/A _3791_/A _3802_/B VPWR VGND sg13cmos5l_nor2_1
XFILLER_13_880 VPWR VGND sg13cmos5l_fill_2
X_2742_ _2879_/A _2866_/A _2869_/A VPWR VGND sg13cmos5l_and2_1
XFILLER_12_390 VPWR VGND sg13cmos5l_decap_8
XFILLER_9_873 VPWR VGND sg13cmos5l_decap_8
X_2673_ _2679_/C _2673_/A _2673_/B VPWR VGND sg13cmos5l_or2_1
X_4343_ _4343_/Q _4363_/CLK _4343_/D _4343_/RESET_B VPWR VGND sg13cmos5l_dfrbpq_1
X_4274_ _4274_/Q _4303_/CLK _4274_/D _4274_/RESET_B VPWR VGND sg13cmos5l_dfrbpq_1
X_3225_ _3225_/Y _3442_/A _3225_/B VPWR VGND sg13cmos5l_nor2_1
XFILLER_39_243 VPWR VGND sg13cmos5l_fill_1
X_3156_ _4241_/D _3156_/A _3258_/B VPWR VGND sg13cmos5l_nor2_1
XFILLER_27_405 VPWR VGND sg13cmos5l_fill_2
Xclkbuf_leaf_19_clk _4303_/CLK clkbuf_leaf_3_clk/A VPWR VGND sg13cmos5l_buf_8
X_3087_ _3114_/C _3087_/A _3087_/B _4233_/Q VPWR VGND sg13cmos5l_nand3_1
XFILLER_36_961 VPWR VGND sg13cmos5l_decap_8
XFILLER_35_482 VPWR VGND sg13cmos5l_fill_1
XFILLER_22_121 VPWR VGND sg13cmos5l_fill_2
XFILLER_10_316 VPWR VGND sg13cmos5l_fill_2
XFILLER_22_154 VPWR VGND sg13cmos5l_fill_1
X_3989_ _3989_/Q clkload5/A _3989_/D _3989_/RESET_B VPWR VGND sg13cmos5l_dfrbpq_1
X_4322__400 _4322_/RESET_B VPWR VGND sg13cmos5l_tiehi
XFILLER_46_703 VPWR VGND sg13cmos5l_fill_1
XFILLER_18_416 VPWR VGND sg13cmos5l_decap_4
XFILLER_46_747 VPWR VGND sg13cmos5l_fill_2
XFILLER_18_449 VPWR VGND sg13cmos5l_decap_8
XFILLER_33_419 VPWR VGND sg13cmos5l_decap_8
XFILLER_27_994 VPWR VGND sg13cmos5l_decap_8
XFILLER_42_975 VPWR VGND sg13cmos5l_decap_8
XFILLER_9_114 VPWR VGND sg13cmos5l_decap_8
X_4362__235 _4362_/RESET_B VPWR VGND sg13cmos5l_tiehi
XFILLER_42_83 VPWR VGND sg13cmos5l_fill_2
XFILLER_6_821 VPWR VGND sg13cmos5l_fill_2
XFILLER_6_810 VPWR VGND sg13cmos5l_decap_8
XFILLER_6_843 VPWR VGND sg13cmos5l_fill_2
XFILLER_47_7 VPWR VGND sg13cmos5l_decap_8
XFILLER_49_552 VPWR VGND sg13cmos5l_decap_8
X_3010_ _3016_/C _4187_/Q _4188_/Q _4189_/Q VPWR VGND sg13cmos5l_o21ai_1
XFILLER_3_1006 VPWR VGND sg13cmos5l_decap_8
XFILLER_45_791 VPWR VGND sg13cmos5l_decap_8
XFILLER_17_460 VPWR VGND sg13cmos5l_decap_8
XFILLER_18_994 VPWR VGND sg13cmos5l_fill_2
X_3912_ _3912_/Y _3912_/A _3911_/A VPWR VGND sg13cmos5l_nor2b_1
X_3843_ _3848_/C _3843_/A VPWR VGND sg13cmos5l_inv_1
X_4148__207 _4148_/RESET_B VPWR VGND sg13cmos5l_tiehi
XFILLER_32_452 VPWR VGND sg13cmos5l_decap_4
X_3774_ _4347_/D hold839/X _3773_/Y _3772_/A VPWR VGND sg13cmos5l_a21oi_1
X_2725_ _2726_/B _2725_/A _2725_/B VPWR VGND sg13cmos5l_nand2_1
Xclkbuf_leaf_8_clk clkload9/A clkload0/A VPWR VGND sg13cmos5l_buf_8
X_2656_ _2656_/Y _2654_/S _3986_/Q _2655_/Y VPWR VGND sg13cmos5l_a21oi_1
X_2587_ _2587_/Y _2690_/A1 _2584_/X _2675_/A VPWR VGND sg13cmos5l_o21ai_1
Xfanout104 _2434_/A0 input8/X VPWR VGND sg13cmos5l_buf_1
Xfanout115 _3958_/A input11/X VPWR VGND sg13cmos5l_buf_1
X_4326_ _4326_/Q _4377_/CLK _4326_/D _4326_/RESET_B VPWR VGND sg13cmos5l_dfrbpq_1
Xfanout126 _3615_/A fanout132/X VPWR VGND sg13cmos5l_buf_1
X_4257_ _4257_/Q _4262_/CLK _4257_/D _4257_/RESET_B VPWR VGND sg13cmos5l_dfrbpq_1
X_4188_ _4188_/Q _4209_/CLK _4188_/D _4188_/RESET_B VPWR VGND sg13cmos5l_dfrbpq_1
X_3208_ _4248_/D _3320_/A _3208_/B VPWR VGND sg13cmos5l_nor2_1
X_3139_ _3139_/Y _4269_/Q _3139_/B VPWR VGND sg13cmos5l_nor2_1
XFILLER_11_603 VPWR VGND sg13cmos5l_decap_8
XFILLER_23_463 VPWR VGND sg13cmos5l_fill_1
XFILLER_11_647 VPWR VGND sg13cmos5l_decap_8
XFILLER_7_629 VPWR VGND sg13cmos5l_fill_2
XFILLER_12_31 VPWR VGND sg13cmos5l_fill_1
XFILLER_12_64 VPWR VGND sg13cmos5l_decap_8
XFILLER_12_75 VPWR VGND sg13cmos5l_fill_1
XFILLER_3_846 VPWR VGND sg13cmos5l_decap_8
XFILLER_37_83 VPWR VGND sg13cmos5l_fill_1
XFILLER_26_290 VPWR VGND sg13cmos5l_fill_2
X_4188__565 _4188_/RESET_B VPWR VGND sg13cmos5l_tiehi
XFILLER_15_975 VPWR VGND sg13cmos5l_decap_4
XFILLER_41_293 VPWR VGND sg13cmos5l_fill_1
XFILLER_30_989 VPWR VGND sg13cmos5l_decap_8
X_2510_ _4133_/D _2216_/Y _2515_/B1 _2509_/Y VPWR VGND sg13cmos5l_a21oi_1
X_3490_ _3493_/B _3490_/A _3490_/B VPWR VGND sg13cmos5l_nor2_1
X_2441_ _2710_/A _4138_/Q _2441_/B VPWR VGND sg13cmos5l_and2_1
XFILLER_45_4 VPWR VGND sg13cmos5l_fill_2
X_2372_ _4051_/D _3950_/A0 hold717/X _2380_/S VPWR VGND sg13cmos5l_mux2_1
XFILLER_2_890 VPWR VGND sg13cmos5l_decap_8
X_4111_ _4111_/Q _4136_/CLK _4111_/D _4111_/RESET_B VPWR VGND sg13cmos5l_dfrbpq_1
XFILLER_25_1018 VPWR VGND sg13cmos5l_decap_8
X_4042_ _4042_/Q clkload3/A _4042_/D _4042_/RESET_B VPWR VGND sg13cmos5l_dfrbpq_1
XFILLER_24_216 VPWR VGND sg13cmos5l_decap_8
XFILLER_24_227 VPWR VGND sg13cmos5l_fill_2
XFILLER_21_912 VPWR VGND sg13cmos5l_decap_8
XFILLER_21_923 VPWR VGND sg13cmos5l_fill_2
XFILLER_20_411 VPWR VGND sg13cmos5l_fill_2
XFILLER_32_293 VPWR VGND sg13cmos5l_fill_2
X_3826_ _3826_/Y _3826_/A _3826_/B VPWR VGND sg13cmos5l_nand2_1
XFILLER_20_455 VPWR VGND sg13cmos5l_fill_2
X_3757_ _3757_/Y _3757_/A _3757_/B VPWR VGND sg13cmos5l_nor2_1
X_2708_ _2709_/B _4101_/Q _4084_/Q _4067_/Q _4050_/Q _2708_/S0 _2708_/S1 VPWR VGND
+ sg13cmos5l_mux4_1
X_3688_ _3690_/B _4337_/Q _4338_/Q _4339_/Q VPWR VGND sg13cmos5l_o21ai_1
X_2639_ _2639_/Y _2639_/A VPWR VGND sg13cmos5l_inv_1
XFILLER_0_816 VPWR VGND sg13cmos5l_decap_8
X_4309_ _4309_/Q _4333_/CLK _4309_/D _4309_/RESET_B VPWR VGND sg13cmos5l_dfrbpq_1
XFILLER_28_533 VPWR VGND sg13cmos5l_decap_8
XFILLER_43_558 VPWR VGND sg13cmos5l_fill_1
XFILLER_24_772 VPWR VGND sg13cmos5l_decap_8
XFILLER_30_208 VPWR VGND sg13cmos5l_decap_4
XFILLER_24_783 VPWR VGND sg13cmos5l_fill_1
XFILLER_24_794 VPWR VGND sg13cmos5l_decap_4
XFILLER_8_927 VPWR VGND sg13cmos5l_decap_8
XFILLER_12_978 VPWR VGND sg13cmos5l_decap_8
XFILLER_23_96 VPWR VGND sg13cmos5l_decap_8
XFILLER_3_632 VPWR VGND sg13cmos5l_fill_1
XFILLER_2_153 VPWR VGND sg13cmos5l_decap_4
XFILLER_2_197 VPWR VGND sg13cmos5l_fill_2
XFILLER_38_319 VPWR VGND sg13cmos5l_decap_4
XFILLER_47_842 VPWR VGND sg13cmos5l_decap_8
XFILLER_0_56 VPWR VGND sg13cmos5l_decap_8
X_2990_ _2990_/Y _2990_/A _2995_/B _2995_/C VPWR VGND sg13cmos5l_nor3_1
XFILLER_9_54 VPWR VGND sg13cmos5l_decap_8
XFILLER_15_794 VPWR VGND sg13cmos5l_decap_8
X_3611_ _4322_/D _2212_/Y _3613_/A2 _3610_/Y VPWR VGND sg13cmos5l_a21oi_1
Xhold927 _3089_/A _4235_/Q VPWR VGND sg13cmos5l_dlygate4sd3_1
XFILLER_6_481 VPWR VGND sg13cmos5l_decap_8
Xhold916 _3745_/A _4319_/Q VPWR VGND sg13cmos5l_dlygate4sd3_1
X_3542_ _4308_/D _3619_/B _3628_/A VPWR VGND sg13cmos5l_nor2_1
Xhold905 _3061_/B _3060_/Y VPWR VGND sg13cmos5l_dlygate4sd3_1
X_3473_ _3476_/B _3473_/A _3483_/B _3483_/C VPWR VGND sg13cmos5l_nand3_1
Xhold949 _3488_/A _4298_/Q VPWR VGND sg13cmos5l_dlygate4sd3_1
Xhold938 _2893_/A _4191_/Q VPWR VGND sg13cmos5l_dlygate4sd3_1
X_2424_ _4095_/D _3951_/A0 hold684/X _2430_/S VPWR VGND sg13cmos5l_mux2_1
X_2355_ _4038_/D _3956_/A hold713/X _2359_/S VPWR VGND sg13cmos5l_mux2_1
XFILLER_36_0 VPWR VGND sg13cmos5l_fill_2
XFILLER_28_19 VPWR VGND sg13cmos5l_fill_2
XFILLER_38_831 VPWR VGND sg13cmos5l_decap_8
X_2286_ _4374_/D _2522_/A _2718_/A VPWR VGND sg13cmos5l_and2_1
X_4025_ _4025_/Q clkload3/A _4025_/D _4025_/RESET_B VPWR VGND sg13cmos5l_dfrbpq_1
XFILLER_37_385 VPWR VGND sg13cmos5l_fill_1
XFILLER_33_580 VPWR VGND sg13cmos5l_decap_4
X_4347__369 _4347_/RESET_B VPWR VGND sg13cmos5l_tiehi
X_3809_ _3872_/B _3804_/A _3801_/B _3808_/X VPWR VGND sg13cmos5l_o21ai_1
XFILLER_5_919 VPWR VGND sg13cmos5l_decap_8
XFILLER_0_624 VPWR VGND sg13cmos5l_decap_8
X_4319__405 _4319_/RESET_B VPWR VGND sg13cmos5l_tiehi
X_4178__575 _4178_/RESET_B VPWR VGND sg13cmos5l_tiehi
XFILLER_47_149 VPWR VGND sg13cmos5l_decap_4
XFILLER_44_834 VPWR VGND sg13cmos5l_decap_8
XFILLER_43_300 VPWR VGND sg13cmos5l_fill_2
XFILLER_16_536 VPWR VGND sg13cmos5l_decap_8
XFILLER_8_713 VPWR VGND sg13cmos5l_decap_4
XFILLER_11_241 VPWR VGND sg13cmos5l_fill_2
XFILLER_15_1017 VPWR VGND sg13cmos5l_decap_8
XFILLER_15_1028 VPWR VGND sg13cmos5l_fill_1
X_4185__568 _4185_/RESET_B VPWR VGND sg13cmos5l_tiehi
XFILLER_7_223 VPWR VGND sg13cmos5l_fill_1
XFILLER_7_256 VPWR VGND sg13cmos5l_decap_8
XFILLER_4_963 VPWR VGND sg13cmos5l_decap_8
XFILLER_3_440 VPWR VGND sg13cmos5l_decap_8
X_4005__372 _4005_/RESET_B VPWR VGND sg13cmos5l_tiehi
XFILLER_35_823 VPWR VGND sg13cmos5l_fill_1
XFILLER_35_867 VPWR VGND sg13cmos5l_decap_8
XFILLER_35_878 VPWR VGND sg13cmos5l_fill_1
XFILLER_35_889 VPWR VGND sg13cmos5l_decap_8
X_2973_ _2973_/Y _2974_/B VPWR VGND sg13cmos5l_inv_1
Xhold702 hold702/X _4045_/Q VPWR VGND sg13cmos5l_dlygate4sd3_1
Xhold746 hold746/X _4014_/Q VPWR VGND sg13cmos5l_dlygate4sd3_1
Xhold735 hold735/X _3996_/Q VPWR VGND sg13cmos5l_dlygate4sd3_1
X_3525_ _3525_/Y _3822_/A _3822_/B VPWR VGND sg13cmos5l_nand2_1
Xhold713 hold713/X _4038_/Q VPWR VGND sg13cmos5l_dlygate4sd3_1
Xhold724 hold724/X _3988_/Q VPWR VGND sg13cmos5l_dlygate4sd3_1
Xhold779 hold779/X _3980_/Q VPWR VGND sg13cmos5l_dlygate4sd3_1
Xhold768 hold768/X _4040_/Q VPWR VGND sg13cmos5l_dlygate4sd3_1
Xhold757 hold757/X _4089_/Q VPWR VGND sg13cmos5l_dlygate4sd3_1
X_3456_ _3456_/Y _4289_/Q _4260_/Q VPWR VGND sg13cmos5l_xnor2_1
X_2407_ _4081_/D _2436_/A0 hold800/X _2410_/S VPWR VGND sg13cmos5l_mux2_1
X_3387_ _3447_/C _3367_/X _3368_/Y _3381_/Y _3168_/A _3375_/B VPWR VGND sg13cmos5l_a221oi_1
X_2338_ _2338_/Y input2/X _2449_/A input3/X VPWR VGND sg13cmos5l_nand3b_1
X_2269_ _2269_/Y _2269_/A VPWR VGND sg13cmos5l_inv_1
XFILLER_29_149 VPWR VGND sg13cmos5l_fill_1
X_4008_ _4008_/Q _4136_/CLK _4008_/D _4008_/RESET_B VPWR VGND sg13cmos5l_dfrbpq_1
XFILLER_26_812 VPWR VGND sg13cmos5l_decap_4
XFILLER_38_1028 VPWR VGND sg13cmos5l_fill_1
XFILLER_25_366 VPWR VGND sg13cmos5l_decap_4
XFILLER_26_867 VPWR VGND sg13cmos5l_decap_8
XFILLER_26_878 VPWR VGND sg13cmos5l_fill_2
XFILLER_25_388 VPWR VGND sg13cmos5l_decap_4
XFILLER_4_248 VPWR VGND sg13cmos5l_decap_8
XFILLER_4_259 VPWR VGND sg13cmos5l_fill_2
XFILLER_1_922 VPWR VGND sg13cmos5l_decap_8
XFILLER_49_904 VPWR VGND sg13cmos5l_decap_8
XFILLER_1_999 VPWR VGND sg13cmos5l_decap_8
X_4291__438 _4291_/RESET_B VPWR VGND sg13cmos5l_tiehi
XFILLER_48_447 VPWR VGND sg13cmos5l_fill_1
XFILLER_29_661 VPWR VGND sg13cmos5l_decap_4
XFILLER_16_322 VPWR VGND sg13cmos5l_fill_2
XFILLER_43_141 VPWR VGND sg13cmos5l_fill_2
XFILLER_43_130 VPWR VGND sg13cmos5l_decap_8
XFILLER_16_399 VPWR VGND sg13cmos5l_decap_8
XFILLER_31_314 VPWR VGND sg13cmos5l_fill_1
XFILLER_43_196 VPWR VGND sg13cmos5l_decap_4
XFILLER_8_532 VPWR VGND sg13cmos5l_decap_4
X_3310_ _3310_/Y _3300_/X _3319_/A _3309_/Y VPWR VGND sg13cmos5l_o21ai_1
X_4290_ _4290_/Q _4323_/CLK _4290_/D _4290_/RESET_B VPWR VGND sg13cmos5l_dfrbpq_1
X_3241_ _3243_/A _3241_/A _3236_/Y VPWR VGND sg13cmos5l_nor2b_1
X_4200__546 _4200_/RESET_B VPWR VGND sg13cmos5l_tiehi
X_3172_ _4244_/D _3258_/B _3266_/A VPWR VGND sg13cmos5l_nor2_1
XFILLER_48_992 VPWR VGND sg13cmos5l_decap_8
XFILLER_35_664 VPWR VGND sg13cmos5l_fill_2
XFILLER_34_174 VPWR VGND sg13cmos5l_decap_8
XFILLER_22_347 VPWR VGND sg13cmos5l_decap_8
X_2956_ _2957_/B _2949_/Y _2958_/A _2962_/A VPWR VGND sg13cmos5l_o21ai_1
X_2887_ _2887_/Y _3079_/A _4168_/Q _2885_/Y VPWR VGND sg13cmos5l_o21ai_1
X_3508_ _3510_/B _4308_/Q _3523_/B VPWR VGND sg13cmos5l_nor2_1
Xhold587 _3253_/B _4229_/Q VPWR VGND sg13cmos5l_dlygate4sd3_1
X_3439_ _4293_/D _3615_/A _3439_/B VPWR VGND sg13cmos5l_and2_1
Xhold598 _3438_/B _4260_/Q VPWR VGND sg13cmos5l_dlygate4sd3_1
X_4175__578 _4175_/RESET_B VPWR VGND sg13cmos5l_tiehi
XFILLER_46_929 VPWR VGND sg13cmos5l_decap_8
XFILLER_45_406 VPWR VGND sg13cmos5l_fill_2
XFILLER_39_970 VPWR VGND sg13cmos5l_decap_8
XFILLER_41_612 VPWR VGND sg13cmos5l_decap_4
XFILLER_14_826 VPWR VGND sg13cmos5l_fill_2
XFILLER_25_163 VPWR VGND sg13cmos5l_decap_8
XFILLER_9_307 VPWR VGND sg13cmos5l_decap_8
XFILLER_25_196 VPWR VGND sg13cmos5l_fill_1
XFILLER_9_318 VPWR VGND sg13cmos5l_fill_1
XFILLER_40_188 VPWR VGND sg13cmos5l_fill_1
XFILLER_21_391 VPWR VGND sg13cmos5l_fill_1
XFILLER_31_85 VPWR VGND sg13cmos5l_fill_1
XFILLER_0_273 VPWR VGND sg13cmos5l_decap_8
XFILLER_0_240 VPWR VGND sg13cmos5l_fill_1
XFILLER_0_295 VPWR VGND sg13cmos5l_decap_8
X_4002__397 _4002_/RESET_B VPWR VGND sg13cmos5l_tiehi
XFILLER_49_778 VPWR VGND sg13cmos5l_decap_8
XFILLER_36_439 VPWR VGND sg13cmos5l_decap_4
XFILLER_45_973 VPWR VGND sg13cmos5l_decap_8
XFILLER_17_664 VPWR VGND sg13cmos5l_decap_4
X_2810_ _2810_/Y _2804_/C _2808_/Y _2803_/X VPWR VGND sg13cmos5l_o21ai_1
X_3790_ _3790_/Y _3788_/Y _3789_/Y _3787_/Y VPWR VGND sg13cmos5l_a21oi_1
X_2741_ _2869_/A _4182_/Q _2741_/B VPWR VGND sg13cmos5l_xnor2_1
XFILLER_9_852 VPWR VGND sg13cmos5l_decap_8
XFILLER_8_351 VPWR VGND sg13cmos5l_decap_8
X_2672_ _2673_/B _2670_/Y _2671_/Y _2607_/Y VPWR VGND sg13cmos5l_o21ai_1
X_4342_ _4342_/Q clkload6/A _4342_/D _4342_/RESET_B VPWR VGND sg13cmos5l_dfrbpq_1
XFILLER_28_1016 VPWR VGND sg13cmos5l_decap_8
X_4273_ _4273_/Q _4303_/CLK _4273_/D _4273_/RESET_B VPWR VGND sg13cmos5l_dfrbpq_1
XFILLER_4_590 VPWR VGND sg13cmos5l_decap_4
XFILLER_28_1027 VPWR VGND sg13cmos5l_fill_2
X_3224_ _3224_/Y _4224_/Q _3224_/B VPWR VGND sg13cmos5l_nor2_1
.ends
