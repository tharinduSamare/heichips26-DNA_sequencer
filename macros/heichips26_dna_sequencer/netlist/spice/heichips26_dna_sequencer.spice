* NGSPICE file created from heichips26_dna_sequencer.ext - technology: ihp-sg13cmos5l

* Black-box entry subcircuit for sg13cmos5l_inv_1 abstract view
.subckt sg13cmos5l_inv_1 Y A VDD VSS
.ends

* Black-box entry subcircuit for sg13cmos5l_decap_4 abstract view
.subckt sg13cmos5l_decap_4 VDD VSS
.ends

* Black-box entry subcircuit for sg13cmos5l_decap_8 abstract view
.subckt sg13cmos5l_decap_8 VDD VSS
.ends

* Black-box entry subcircuit for sg13cmos5l_fill_2 abstract view
.subckt sg13cmos5l_fill_2 VDD VSS
.ends

* Black-box entry subcircuit for sg13cmos5l_a21o_1 abstract view
.subckt sg13cmos5l_a21o_1 X A1 A2 B1 VDD VSS
.ends

* Black-box entry subcircuit for sg13cmos5l_dfrbpq_1 abstract view
.subckt sg13cmos5l_dfrbpq_1 Q CLK D RESET_B VDD VSS
.ends

* Black-box entry subcircuit for sg13cmos5l_nand2b_1 abstract view
.subckt sg13cmos5l_nand2b_1 Y A_N B VDD VSS
.ends

* Black-box entry subcircuit for sg13cmos5l_dlygate4sd3_1 abstract view
.subckt sg13cmos5l_dlygate4sd3_1 X A VDD VSS
.ends

* Black-box entry subcircuit for sg13cmos5l_fill_1 abstract view
.subckt sg13cmos5l_fill_1 VDD VSS
.ends

* Black-box entry subcircuit for sg13cmos5l_tiehi abstract view
.subckt sg13cmos5l_tiehi L_HI VDD VSS
.ends

* Black-box entry subcircuit for sg13cmos5l_a21oi_1 abstract view
.subckt sg13cmos5l_a21oi_1 Y A1 A2 B1 VDD VSS
.ends

* Black-box entry subcircuit for sg13cmos5l_nor2b_1 abstract view
.subckt sg13cmos5l_nor2b_1 Y A B_N VDD VSS
.ends

* Black-box entry subcircuit for sg13cmos5l_o21ai_1 abstract view
.subckt sg13cmos5l_o21ai_1 Y A1 A2 B1 VDD VSS
.ends

* Black-box entry subcircuit for sg13cmos5l_nand2_1 abstract view
.subckt sg13cmos5l_nand2_1 Y A B VDD VSS
.ends

* Black-box entry subcircuit for sg13cmos5l_mux2_1 abstract view
.subckt sg13cmos5l_mux2_1 X A0 A1 S VDD VSS
.ends

* Black-box entry subcircuit for sg13cmos5l_buf_1 abstract view
.subckt sg13cmos5l_buf_1 X A VDD VSS
.ends

* Black-box entry subcircuit for sg13cmos5l_xnor2_1 abstract view
.subckt sg13cmos5l_xnor2_1 Y A B VDD VSS
.ends

* Black-box entry subcircuit for sg13cmos5l_nor2_1 abstract view
.subckt sg13cmos5l_nor2_1 Y A B VDD VSS
.ends

* Black-box entry subcircuit for sg13cmos5l_nor3_1 abstract view
.subckt sg13cmos5l_nor3_1 Y A B C VDD VSS
.ends

* Black-box entry subcircuit for sg13cmos5l_mux4_1 abstract view
.subckt sg13cmos5l_mux4_1 X A0 A1 A2 A3 S0 S1 VDD VSS
.ends

* Black-box entry subcircuit for sg13cmos5l_and2_1 abstract view
.subckt sg13cmos5l_and2_1 X A B VDD VSS
.ends

* Black-box entry subcircuit for sg13cmos5l_nand3_1 abstract view
.subckt sg13cmos5l_nand3_1 Y A B C VDD VSS
.ends

* Black-box entry subcircuit for sg13cmos5l_a221oi_1 abstract view
.subckt sg13cmos5l_a221oi_1 Y A1 A2 B1 B2 C1 VDD VSS
.ends

* Black-box entry subcircuit for sg13cmos5l_a22oi_1 abstract view
.subckt sg13cmos5l_a22oi_1 Y A1 A2 B1 B2 VDD VSS
.ends

* Black-box entry subcircuit for sg13cmos5l_buf_8 abstract view
.subckt sg13cmos5l_buf_8 X A VDD VSS
.ends

* Black-box entry subcircuit for sg13cmos5l_tielo abstract view
.subckt sg13cmos5l_tielo L_LO VDD VSS
.ends

* Black-box entry subcircuit for sg13cmos5l_xor2_1 abstract view
.subckt sg13cmos5l_xor2_1 X A B VDD VSS
.ends

* Black-box entry subcircuit for sg13cmos5l_and3_1 abstract view
.subckt sg13cmos5l_and3_1 X A B C VDD VSS
.ends

* Black-box entry subcircuit for sg13cmos5l_or2_1 abstract view
.subckt sg13cmos5l_or2_1 X A B VDD VSS
.ends

* Black-box entry subcircuit for sg13cmos5l_nor4_1 abstract view
.subckt sg13cmos5l_nor4_1 Y A B C D VDD VSS
.ends

* Black-box entry subcircuit for sg13cmos5l_nand4_1 abstract view
.subckt sg13cmos5l_nand4_1 Y A B C D VDD VSS
.ends

* Black-box entry subcircuit for sg13cmos5l_or3_1 abstract view
.subckt sg13cmos5l_or3_1 X A B C VDD VSS
.ends

* Black-box entry subcircuit for sg13cmos5l_nand3b_1 abstract view
.subckt sg13cmos5l_nand3b_1 Y A_N B C VDD VSS
.ends

* Black-box entry subcircuit for sg13cmos5l_inv_4 abstract view
.subckt sg13cmos5l_inv_4 Y A VDD VSS
.ends

* Black-box entry subcircuit for sg13cmos5l_inv_2 abstract view
.subckt sg13cmos5l_inv_2 Y A VDD VSS
.ends

* Black-box entry subcircuit for sg13cmos5l_and4_1 abstract view
.subckt sg13cmos5l_and4_1 X A B C D VDD VSS
.ends

.subckt heichips26_dna_sequencer VGND VPWR clk ena rst_n ui_in[0] ui_in[1] ui_in[2]
+ ui_in[3] ui_in[4] ui_in[5] ui_in[6] ui_in[7] uio_in[0] uio_in[1] uio_in[2] uio_in[3]
+ uio_in[4] uio_in[5] uio_in[6] uio_in[7] uio_oe[0] uio_oe[1] uio_oe[2] uio_oe[3]
+ uio_oe[4] uio_oe[5] uio_oe[6] uio_oe[7] uio_out[0] uio_out[1] uio_out[2] uio_out[3]
+ uio_out[4] uio_out[5] uio_out[6] uio_out[7] uo_out[0] uo_out[1] uo_out[2] uo_out[3]
+ uo_out[4] uo_out[5] uo_out[6] uo_out[7]
X_3155_ _3155_/Y _5924_/Q VPWR VGND sg13cmos5l_inv_1
X_3086_ _3796_/A _3415_/A VPWR VGND sg13cmos5l_inv_1
XFILLER_36_940 VPWR VGND sg13cmos5l_decap_4
XFILLER_35_450 VPWR VGND sg13cmos5l_decap_8
XFILLER_36_973 VPWR VGND sg13cmos5l_fill_2
X_3988_ _3988_/X _3973_/Y _3976_/Y _3987_/Y VPWR VGND sg13cmos5l_a21o_1
X_5727_ _5727_/Q _6047_/CLK _5727_/D _5727_/RESET_B VPWR VGND sg13cmos5l_dfrbpq_1
X_5658_ _5658_/Q _5692_/CLK _5658_/D _5658_/RESET_B VPWR VGND sg13cmos5l_dfrbpq_1
X_5589_ _5589_/Q clkload3/A _5589_/D _5589_/RESET_B VPWR VGND sg13cmos5l_dfrbpq_1
X_4609_ _4609_/Y _5927_/Q _5975_/Q VPWR VGND sg13cmos5l_nand2b_1
Xhold1051 _3608_/A _5795_/Q VPWR VGND sg13cmos5l_dlygate4sd3_1
Xhold1040 _5779_/D _3576_/Y VPWR VGND sg13cmos5l_dlygate4sd3_1
XFILLER_18_406 VPWR VGND sg13cmos5l_fill_1
XFILLER_46_737 VPWR VGND sg13cmos5l_decap_8
XFILLER_45_203 VPWR VGND sg13cmos5l_fill_2
Xhold1073 _3409_/A _5819_/Q VPWR VGND sg13cmos5l_dlygate4sd3_1
Xhold1084 _3448_/A _5718_/Q VPWR VGND sg13cmos5l_dlygate4sd3_1
Xhold1062 _4491_/B _5905_/Q VPWR VGND sg13cmos5l_dlygate4sd3_1
X_5832__565 _5832_/RESET_B VPWR VGND sg13cmos5l_tiehi
Xhold1095 _5865_/D _4160_/Y VPWR VGND sg13cmos5l_dlygate4sd3_1
XFILLER_26_494 VPWR VGND sg13cmos5l_fill_2
XFILLER_41_486 VPWR VGND sg13cmos5l_decap_4
X_5507__542 _5507_/RESET_B VPWR VGND sg13cmos5l_tiehi
X_6037__315 _6037_/RESET_B VPWR VGND sg13cmos5l_tiehi
XFILLER_1_571 VPWR VGND sg13cmos5l_fill_1
XFILLER_49_520 VPWR VGND sg13cmos5l_decap_8
XFILLER_49_597 VPWR VGND sg13cmos5l_decap_8
XFILLER_37_759 VPWR VGND sg13cmos5l_fill_1
X_4960_ _4960_/Y _4951_/B _4951_/C _4957_/S VPWR VGND sg13cmos5l_a21oi_1
X_4891_ _4892_/C _4891_/A _4890_/A VPWR VGND sg13cmos5l_nor2b_1
X_3911_ _3911_/Y _3910_/B _5624_/Q _3910_/Y VPWR VGND sg13cmos5l_o21ai_1
X_3842_ _3843_/C _3838_/A _3620_/B _3621_/A VPWR VGND sg13cmos5l_a21oi_1
XFILLER_20_648 VPWR VGND sg13cmos5l_fill_1
XFILLER_34_1020 VPWR VGND sg13cmos5l_decap_8
X_5512_ _5512_/Q _5810_/CLK _5512_/D _5512_/RESET_B VPWR VGND sg13cmos5l_dfrbpq_1
X_3773_ _3773_/Y _3773_/A _3773_/B VPWR VGND sg13cmos5l_nand2_1
X_5443_ _5443_/Q clkload9/A _5443_/D _5443_/RESET_B VPWR VGND sg13cmos5l_dfrbpq_1
X_5374_ _5503_/D _5374_/A0 _5374_/A1 _5379_/S VPWR VGND sg13cmos5l_mux2_1
X_5603__817 _5603_/RESET_B VPWR VGND sg13cmos5l_tiehi
X_4325_ _4325_/Y _5908_/Q _4327_/B _4345_/B VPWR VGND sg13cmos5l_a21oi_1
Xfanout105 _3440_/A _5164_/B VPWR VGND sg13cmos5l_buf_1
Xfanout127 _3752_/A _5806_/Q VPWR VGND sg13cmos5l_buf_1
Xfanout138 _3745_/A fanout142/X VPWR VGND sg13cmos5l_buf_1
Xfanout116 _5352_/A _5840_/Q VPWR VGND sg13cmos5l_buf_1
XFILLER_47_18 VPWR VGND sg13cmos5l_fill_1
X_4256_ _4256_/Y _5866_/Q _5865_/Q VPWR VGND sg13cmos5l_xnor2_1
Xfanout149 _4071_/A _4061_/A VPWR VGND sg13cmos5l_buf_1
X_3207_ _3208_/B _3163_/A _3162_/Y _3220_/B VPWR VGND sg13cmos5l_a21oi_1
X_4187_ _4187_/Y _4128_/A _4304_/A2 _4190_/A VPWR VGND sg13cmos5l_o21ai_1
X_3138_ _3138_/Y _5807_/Q VPWR VGND sg13cmos5l_inv_1
XFILLER_27_225 VPWR VGND sg13cmos5l_fill_1
X_3069_ _5142_/B _6021_/Q VPWR VGND sg13cmos5l_inv_1
XFILLER_24_965 VPWR VGND sg13cmos5l_fill_2
XFILLER_23_464 VPWR VGND sg13cmos5l_decap_8
XFILLER_6_129 VPWR VGND sg13cmos5l_fill_1
X_5489__578 _5489_/RESET_B VPWR VGND sg13cmos5l_tiehi
XFILLER_3_869 VPWR VGND sg13cmos5l_fill_2
X_5578__849 _5578_/RESET_B VPWR VGND sg13cmos5l_tiehi
XFILLER_46_534 VPWR VGND sg13cmos5l_decap_8
XFILLER_46_589 VPWR VGND sg13cmos5l_decap_8
XFILLER_42_762 VPWR VGND sg13cmos5l_fill_2
XFILLER_15_987 VPWR VGND sg13cmos5l_decap_8
XFILLER_15_998 VPWR VGND sg13cmos5l_fill_2
XFILLER_41_294 VPWR VGND sg13cmos5l_fill_2
X_4110_ _4110_/Y _4079_/S _5499_/Q _4109_/Y VPWR VGND sg13cmos5l_o21ai_1
X_5090_ _5090_/X _5089_/B _5078_/B _5116_/A VPWR VGND sg13cmos5l_a21o_1
X_4041_ _4041_/Y _4041_/A _4041_/B VPWR VGND sg13cmos5l_nor2_1
XFILLER_49_394 VPWR VGND sg13cmos5l_decap_8
X_5992_ _5992_/Q _6077_/CLK _5992_/D _5992_/RESET_B VPWR VGND sg13cmos5l_dfrbpq_1
X_4943_ _4943_/Y _4943_/A VPWR VGND sg13cmos5l_inv_1
XFILLER_24_228 VPWR VGND sg13cmos5l_fill_2
XFILLER_20_423 VPWR VGND sg13cmos5l_fill_2
X_4874_ _4891_/A _4872_/Y _4874_/B VPWR VGND sg13cmos5l_nand2b_1
XFILLER_20_434 VPWR VGND sg13cmos5l_decap_8
X_3825_ _5838_/D _5428_/A _3825_/B _5304_/D VPWR VGND sg13cmos5l_nor3_1
X_3756_ _3756_/X _5800_/Q _5794_/Q _5788_/Q _5782_/Q _3749_/B _3752_/A VPWR VGND sg13cmos5l_mux4_1
X_5426_ _5822_/D _5426_/A _5426_/B VPWR VGND sg13cmos5l_nor2_1
X_3687_ _3687_/Y _3726_/A1 _3141_/Y _3752_/A VPWR VGND sg13cmos5l_a21oi_1
X_5357_ _5488_/D _5357_/A0 _5357_/A1 _5360_/S VPWR VGND sg13cmos5l_mux2_1
X_5288_ _6072_/D _5290_/B _5287_/X _6074_/D VPWR VGND sg13cmos5l_a21oi_1
X_4308_ _5903_/D _4358_/B _4308_/B VPWR VGND sg13cmos5l_and2_1
X_4239_ _4420_/B _4239_/A _4241_/B VPWR VGND sg13cmos5l_nor2_1
XFILLER_12_913 VPWR VGND sg13cmos5l_decap_8
X_6034__318 _6034_/RESET_B VPWR VGND sg13cmos5l_tiehi
XFILLER_47_865 VPWR VGND sg13cmos5l_decap_8
XFILLER_19_545 VPWR VGND sg13cmos5l_fill_1
XFILLER_19_556 VPWR VGND sg13cmos5l_fill_1
X_5537__332 _5537_/RESET_B VPWR VGND sg13cmos5l_tiehi
XFILLER_42_592 VPWR VGND sg13cmos5l_fill_1
X_4590_ _4590_/Y _4580_/A _4580_/B _4400_/A VPWR VGND sg13cmos5l_o21ai_1
X_3610_ _3610_/Y _3610_/A _3617_/B VPWR VGND sg13cmos5l_nand2_1
X_3541_ _5762_/D _3565_/A1 _3542_/S _3540_/Y VPWR VGND sg13cmos5l_a21oi_1
X_3472_ _3472_/Y _3472_/A _3481_/B VPWR VGND sg13cmos5l_nand2_1
XFILLER_43_2 VPWR VGND sg13cmos5l_fill_1
X_5211_ _5211_/Y _5226_/A _5231_/C VPWR VGND sg13cmos5l_nand2_1
XFILLER_9_1002 VPWR VGND sg13cmos5l_fill_1
X_5142_ _5142_/Y _6023_/Q _5142_/B _5148_/B VPWR VGND sg13cmos5l_nor3_1
Xhold1606 _3096_/A _5887_/Q VPWR VGND sg13cmos5l_dlygate4sd3_1
XFILLER_29_0 VPWR VGND sg13cmos5l_fill_2
Xhold1617 _4220_/A _4211_/Y VPWR VGND sg13cmos5l_dlygate4sd3_1
X_5073_ _5177_/B hold1614/X _5166_/A VPWR VGND sg13cmos5l_nand2b_1
Xhold1628 _4683_/B _4682_/Y VPWR VGND sg13cmos5l_dlygate4sd3_1
Xhold1639 _4356_/A2 _4332_/Y VPWR VGND sg13cmos5l_dlygate4sd3_1
XFILLER_38_843 VPWR VGND sg13cmos5l_decap_8
X_4024_ _4024_/Y _4024_/A1 _4023_/Y _4042_/A1 VPWR VGND sg13cmos5l_o21ai_1
XFILLER_38_898 VPWR VGND sg13cmos5l_decap_8
X_5975_ _5975_/Q _6005_/CLK _5975_/D _5975_/RESET_B VPWR VGND sg13cmos5l_dfrbpq_1
XFILLER_40_507 VPWR VGND sg13cmos5l_fill_2
X_4926_ _4927_/B _4926_/A _4926_/B VPWR VGND sg13cmos5l_nand2_1
X_4857_ _4857_/X _4879_/A _4857_/B VPWR VGND sg13cmos5l_and2_1
X_3808_ _3809_/B _5829_/Q _5828_/Q _3812_/D VPWR VGND sg13cmos5l_nand3_1
X_5568__859 _5568_/RESET_B VPWR VGND sg13cmos5l_tiehi
XFILLER_20_297 VPWR VGND sg13cmos5l_fill_2
X_4788_ _4788_/Y _6007_/Q _3149_/Y _4618_/A _6006_/Q _4787_/Y VPWR VGND sg13cmos5l_a221oi_1
X_3739_ _3739_/X _5751_/Q _5745_/Q _5739_/Q _5733_/Q _3710_/S _3739_/S1 VPWR VGND
+ sg13cmos5l_mux4_1
X_5409_ _5417_/S _5409_/A _5409_/B _5409_/C VPWR VGND sg13cmos5l_nand3_1
XFILLER_0_636 VPWR VGND sg13cmos5l_fill_1
XFILLER_48_607 VPWR VGND sg13cmos5l_fill_2
XFILLER_29_821 VPWR VGND sg13cmos5l_fill_1
XFILLER_47_139 VPWR VGND sg13cmos5l_fill_2
XFILLER_29_843 VPWR VGND sg13cmos5l_fill_1
XFILLER_16_515 VPWR VGND sg13cmos5l_fill_1
XFILLER_18_75 VPWR VGND sg13cmos5l_fill_2
XFILLER_29_898 VPWR VGND sg13cmos5l_fill_2
XFILLER_44_835 VPWR VGND sg13cmos5l_decap_8
XFILLER_16_559 VPWR VGND sg13cmos5l_fill_2
XFILLER_4_920 VPWR VGND sg13cmos5l_fill_2
XFILLER_46_161 VPWR VGND sg13cmos5l_fill_1
XFILLER_34_301 VPWR VGND sg13cmos5l_fill_1
X_5760_ _5760_/Q _5834_/CLK _5760_/D _5760_/RESET_B VPWR VGND sg13cmos5l_dfrbpq_1
X_4711_ _4719_/B _6006_/Q _4785_/A VPWR VGND sg13cmos5l_nor2_1
XFILLER_30_540 VPWR VGND sg13cmos5l_decap_4
X_5691_ _5691_/Q _5840_/CLK _5691_/D _5691_/RESET_B VPWR VGND sg13cmos5l_dfrbpq_1
X_4642_ _4642_/Y _4642_/A1 _5003_/A2 _4998_/A VPWR VGND sg13cmos5l_o21ai_1
X_4573_ _4573_/Y _4573_/A _4573_/B VPWR VGND sg13cmos5l_nor2_1
X_3524_ _3524_/Y _3524_/A _3531_/B VPWR VGND sg13cmos5l_nand2_1
X_3455_ _3455_/Y _3455_/A _3455_/B VPWR VGND sg13cmos5l_nor2_1
X_3386_ _5685_/D _3386_/A0 _3215_/A _3387_/S VPWR VGND sg13cmos5l_mux2_1
Xhold1425 _5830_/D _3811_/Y VPWR VGND sg13cmos5l_dlygate4sd3_1
X_5125_ _5125_/Y _5134_/B _6062_/Q _5138_/B _3070_/Y VPWR VGND sg13cmos5l_a22oi_1
Xhold1403 _5300_/A0 _5438_/Q VPWR VGND sg13cmos5l_dlygate4sd3_1
Xhold1414 _3393_/A1 _5691_/Q VPWR VGND sg13cmos5l_dlygate4sd3_1
Xhold1447 _3235_/A0 _5562_/Q VPWR VGND sg13cmos5l_dlygate4sd3_1
Xhold1458 _3241_/A0 _5568_/Q VPWR VGND sg13cmos5l_dlygate4sd3_1
X_5056_ _5057_/B _5035_/A _5035_/B _5055_/Y VPWR VGND sg13cmos5l_o21ai_1
Xhold1436 _4200_/A _5876_/Q VPWR VGND sg13cmos5l_dlygate4sd3_1
Xhold1469 _3299_/A0 _5611_/Q VPWR VGND sg13cmos5l_dlygate4sd3_1
X_4007_ _4007_/Y _4009_/A _4006_/X _4012_/A VPWR VGND sg13cmos5l_o21ai_1
XFILLER_41_816 VPWR VGND sg13cmos5l_decap_8
X_5958_ _5958_/Q _6037_/CLK _5958_/D _5958_/RESET_B VPWR VGND sg13cmos5l_dfrbpq_1
X_4909_ _4910_/C _6037_/Q _4907_/B _4928_/B VPWR VGND sg13cmos5l_o21ai_1
X_5889_ _5889_/Q _5894_/CLK _5889_/D _5889_/RESET_B VPWR VGND sg13cmos5l_dfrbpq_1
XFILLER_1_967 VPWR VGND sg13cmos5l_decap_8
XFILLER_49_938 VPWR VGND sg13cmos5l_decap_8
XFILLER_48_404 VPWR VGND sg13cmos5l_decap_8
XFILLER_43_142 VPWR VGND sg13cmos5l_fill_1
XFILLER_44_698 VPWR VGND sg13cmos5l_fill_2
XFILLER_8_577 VPWR VGND sg13cmos5l_fill_2
X_5842__545 _5842_/RESET_B VPWR VGND sg13cmos5l_tiehi
XFILLER_3_271 VPWR VGND sg13cmos5l_decap_8
X_3240_ _5567_/D _3240_/A0 _3217_/A _3240_/S VPWR VGND sg13cmos5l_mux2_1
XFILLER_6_1027 VPWR VGND sg13cmos5l_fill_2
X_3171_ _3171_/Y _3171_/A _3171_/B VPWR VGND sg13cmos5l_nor2_1
XFILLER_48_971 VPWR VGND sg13cmos5l_decap_8
X_5558__869 _5558_/RESET_B VPWR VGND sg13cmos5l_tiehi
X_5812_ _5812_/Q clkload8/A _5812_/D _5812_/RESET_B VPWR VGND sg13cmos5l_dfrbpq_1
X_5743_ _5743_/Q _6063_/CLK _5743_/D _5743_/RESET_B VPWR VGND sg13cmos5l_dfrbpq_1
X_5674_ _5674_/Q _5674_/CLK _5674_/D _5674_/RESET_B VPWR VGND sg13cmos5l_dfrbpq_1
X_4625_ _4625_/Y _5956_/Q _4621_/Y _4632_/A _4633_/A1 VPWR VGND sg13cmos5l_a22oi_1
X_4556_ _4656_/A _4556_/A _4562_/A VPWR VGND sg13cmos5l_nand2_1
X_3507_ _3507_/Y _3607_/A _3507_/B VPWR VGND sg13cmos5l_nand2_1
X_4487_ _4487_/Y _5931_/Q _5904_/Q VPWR VGND sg13cmos5l_xnor2_1
X_3438_ _3438_/Y _3438_/A _3440_/B VPWR VGND sg13cmos5l_nor2_1
Xhold1200 _3312_/A1 _5623_/Q VPWR VGND sg13cmos5l_dlygate4sd3_1
X_3369_ _5673_/D _3392_/A0 _3369_/A1 _3374_/B VPWR VGND sg13cmos5l_mux2_1
Xhold1211 _3285_/A1 _5599_/Q VPWR VGND sg13cmos5l_dlygate4sd3_1
X_5108_ _5108_/Y _5108_/A VPWR VGND sg13cmos5l_inv_1
Xhold1233 _5387_/A0 _5515_/Q VPWR VGND sg13cmos5l_dlygate4sd3_1
Xhold1222 _5415_/A1 _5540_/Q VPWR VGND sg13cmos5l_dlygate4sd3_1
Xhold1266 _3355_/A1 _5661_/Q VPWR VGND sg13cmos5l_dlygate4sd3_1
XFILLER_45_418 VPWR VGND sg13cmos5l_fill_2
XFILLER_45_407 VPWR VGND sg13cmos5l_decap_8
Xhold1255 _5320_/A0 _5455_/Q VPWR VGND sg13cmos5l_dlygate4sd3_1
Xhold1244 _3226_/A1 _5554_/Q VPWR VGND sg13cmos5l_dlygate4sd3_1
Xhold1288 _5411_/A1 _5536_/Q VPWR VGND sg13cmos5l_dlygate4sd3_1
X_5039_ _5051_/A _5046_/A _5039_/B VPWR VGND sg13cmos5l_nor2_1
Xhold1299 _3266_/A0 _5584_/Q VPWR VGND sg13cmos5l_dlygate4sd3_1
Xhold1277 _3392_/A1 _5690_/Q VPWR VGND sg13cmos5l_dlygate4sd3_1
XFILLER_38_470 VPWR VGND sg13cmos5l_decap_8
XFILLER_25_120 VPWR VGND sg13cmos5l_fill_2
XFILLER_26_676 VPWR VGND sg13cmos5l_fill_2
XFILLER_41_635 VPWR VGND sg13cmos5l_fill_2
XFILLER_40_145 VPWR VGND sg13cmos5l_fill_1
XFILLER_22_893 VPWR VGND sg13cmos5l_decap_4
XFILLER_21_392 VPWR VGND sg13cmos5l_fill_2
X_5499__558 _5499_/RESET_B VPWR VGND sg13cmos5l_tiehi
XFILLER_37_919 VPWR VGND sg13cmos5l_fill_2
XFILLER_45_930 VPWR VGND sg13cmos5l_decap_8
XFILLER_31_101 VPWR VGND sg13cmos5l_fill_1
XFILLER_9_897 VPWR VGND sg13cmos5l_decap_4
X_4410_ _4410_/Y _4410_/A _4410_/B VPWR VGND sg13cmos5l_nand2_1
X_5390_ _5398_/S _5409_/A _5409_/C _5390_/C VPWR VGND sg13cmos5l_nand3_1
X_4341_ _4341_/Y _4341_/A _4343_/B VPWR VGND sg13cmos5l_nand2_1
XFILLER_28_1006 VPWR VGND sg13cmos5l_fill_2
X_4272_ _4273_/B _4154_/X _4263_/Y _4268_/A _4271_/Y VPWR VGND sg13cmos5l_a22oi_1
XFILLER_28_1028 VPWR VGND sg13cmos5l_fill_1
X_6011_ _6011_/Q _6037_/CLK _6011_/D _6011_/RESET_B VPWR VGND sg13cmos5l_dfrbpq_1
X_3223_ _3231_/S _5409_/A _5409_/C _5352_/D VPWR VGND sg13cmos5l_nand3_1
X_3154_ _3154_/Y _5925_/Q VPWR VGND sg13cmos5l_inv_1
X_3085_ _3807_/B _3162_/D VPWR VGND sg13cmos5l_inv_1
XFILLER_39_289 VPWR VGND sg13cmos5l_fill_1
XFILLER_36_996 VPWR VGND sg13cmos5l_decap_8
XFILLER_22_123 VPWR VGND sg13cmos5l_fill_2
XFILLER_11_808 VPWR VGND sg13cmos5l_fill_2
X_3987_ _3987_/Y _3978_/Y _3980_/Y _3986_/Y VPWR VGND sg13cmos5l_a21oi_1
XFILLER_23_679 VPWR VGND sg13cmos5l_fill_2
X_5726_ _5726_/Q _6047_/CLK _5726_/D _5726_/RESET_B VPWR VGND sg13cmos5l_dfrbpq_1
X_5657_ _5657_/Q _5695_/CLK _5657_/D _5657_/RESET_B VPWR VGND sg13cmos5l_dfrbpq_1
X_5588_ _5588_/Q clkload3/A _5588_/D _5588_/RESET_B VPWR VGND sg13cmos5l_dfrbpq_1
X_4608_ _4608_/Y _4830_/A _5926_/Q _5925_/Q _4561_/A _4607_/Y VPWR VGND sg13cmos5l_a221oi_1
X_4539_ _4546_/A _4539_/A _4539_/B _4759_/A VPWR VGND sg13cmos5l_nand3_1
XFILLER_46_716 VPWR VGND sg13cmos5l_decap_8
Xhold1041 _3583_/A _5783_/Q VPWR VGND sg13cmos5l_dlygate4sd3_1
Xhold1030 _3614_/A _5798_/Q VPWR VGND sg13cmos5l_dlygate4sd3_1
Xhold1085 _3143_/A _5787_/Q VPWR VGND sg13cmos5l_dlygate4sd3_1
Xhold1074 _5819_/D _3789_/Y VPWR VGND sg13cmos5l_dlygate4sd3_1
Xhold1063 _3476_/A _5731_/Q VPWR VGND sg13cmos5l_dlygate4sd3_1
Xhold1052 _3522_/A _5753_/Q VPWR VGND sg13cmos5l_dlygate4sd3_1
XFILLER_27_930 VPWR VGND sg13cmos5l_decap_4
Xhold1096 _3432_/A _5711_/Q VPWR VGND sg13cmos5l_dlygate4sd3_1
XFILLER_26_462 VPWR VGND sg13cmos5l_decap_4
Xclkbuf_3_6__f_clk clkbuf_3_6__f_clk/X clkbuf_0_clk/X VPWR VGND sg13cmos5l_buf_8
XFILLER_41_465 VPWR VGND sg13cmos5l_decap_8
XFILLER_49_576 VPWR VGND sg13cmos5l_decap_8
XFILLER_18_974 VPWR VGND sg13cmos5l_decap_8
X_4890_ _4892_/B _4890_/A _4871_/X VPWR VGND sg13cmos5l_nor2b_1
X_3910_ _3910_/Y _5607_/Q _3910_/B VPWR VGND sg13cmos5l_nand2b_1
X_3841_ _3844_/B _5304_/C _3841_/B VPWR VGND sg13cmos5l_nand2_1
X_3772_ _3773_/B _3772_/A _3772_/B VPWR VGND sg13cmos5l_xnor2_1
X_5511_ _5511_/Q clkload4/A _5511_/D _5511_/RESET_B VPWR VGND sg13cmos5l_dfrbpq_1
X_5442_ _5442_/Q _5674_/CLK _5442_/D _5442_/RESET_B VPWR VGND sg13cmos5l_dfrbpq_1
X_5373_ _5502_/D _5373_/A0 _5373_/A1 _5379_/S VPWR VGND sg13cmos5l_mux2_1
X_4324_ _4345_/B _4324_/A _4327_/B VPWR VGND sg13cmos5l_nor2_1
Xfanout128 _3736_/A1 _5806_/Q VPWR VGND sg13cmos5l_buf_1
Xfanout106 _3591_/A _6051_/Q VPWR VGND sg13cmos5l_buf_1
Xfanout117 _5304_/B hold1624/X VPWR VGND sg13cmos5l_buf_1
X_4255_ _4255_/X _4261_/B _4261_/C _4261_/A VPWR VGND sg13cmos5l_a21o_1
Xfanout139 _3710_/S _3755_/S VPWR VGND sg13cmos5l_buf_1
XFILLER_41_1025 VPWR VGND sg13cmos5l_decap_4
X_3206_ _3206_/Y _3865_/B _3206_/A2 _4131_/A VPWR VGND sg13cmos5l_a21oi_1
X_4186_ _4186_/Y _3081_/Y _4186_/A2 _4185_/Y VPWR VGND sg13cmos5l_a21oi_1
X_5918__298 _5918_/D VPWR VGND sg13cmos5l_tielo
X_3137_ _3137_/Y _3734_/S VPWR VGND sg13cmos5l_inv_1
XFILLER_27_259 VPWR VGND sg13cmos5l_decap_4
X_3068_ _5141_/A _3068_/A VPWR VGND sg13cmos5l_inv_1
XFILLER_36_771 VPWR VGND sg13cmos5l_decap_8
XFILLER_23_410 VPWR VGND sg13cmos5l_fill_2
XFILLER_36_793 VPWR VGND sg13cmos5l_fill_2
XFILLER_23_443 VPWR VGND sg13cmos5l_decap_8
XFILLER_24_999 VPWR VGND sg13cmos5l_fill_1
X_5709_ _5709_/Q _6047_/CLK _5709_/D _5709_/RESET_B VPWR VGND sg13cmos5l_dfrbpq_1
XFILLER_3_804 VPWR VGND sg13cmos5l_fill_2
XFILLER_46_513 VPWR VGND sg13cmos5l_decap_8
XFILLER_46_568 VPWR VGND sg13cmos5l_decap_8
XFILLER_15_966 VPWR VGND sg13cmos5l_decap_8
XFILLER_2_870 VPWR VGND sg13cmos5l_decap_8
X_4040_ _4040_/X _5695_/Q _5678_/Q _5661_/Q _5644_/Q _3910_/B _4040_/S1 VPWR VGND
+ sg13cmos5l_mux4_1
XFILLER_37_502 VPWR VGND sg13cmos5l_decap_8
X_5991_ _5991_/Q _6056_/CLK _5991_/D _5991_/RESET_B VPWR VGND sg13cmos5l_dfrbpq_1
XFILLER_24_218 VPWR VGND sg13cmos5l_decap_4
X_4942_ _4943_/A _5985_/Q _4951_/B VPWR VGND sg13cmos5l_xor2_1
X_4873_ _4874_/B _4872_/B _4872_/C _4749_/B VPWR VGND sg13cmos5l_o21ai_1
X_3824_ _5304_/D _3824_/A _3824_/B _3824_/C VPWR VGND sg13cmos5l_and3_1
X_3755_ _3755_/X _5752_/Q _5746_/Q _3755_/S VPWR VGND sg13cmos5l_mux2_1
X_3686_ _3686_/X _5761_/Q _5755_/Q _3734_/S VPWR VGND sg13cmos5l_mux2_1
X_5425_ _5821_/D _5429_/A _5425_/B VPWR VGND sg13cmos5l_nor2_1
X_5356_ _5487_/D _5356_/A0 _5356_/A1 _5360_/S VPWR VGND sg13cmos5l_mux2_1
X_5287_ _5287_/X _5287_/A _5287_/B VPWR VGND sg13cmos5l_xor2_1
X_4307_ _5902_/D _3075_/Y _4307_/A2 _4306_/Y VPWR VGND sg13cmos5l_a21oi_1
X_5718__702 _5718_/RESET_B VPWR VGND sg13cmos5l_tiehi
X_4238_ _4238_/Y _4476_/A _5913_/Q VPWR VGND sg13cmos5l_nor2_1
X_5577__850 _5577_/RESET_B VPWR VGND sg13cmos5l_tiehi
XFILLER_28_502 VPWR VGND sg13cmos5l_fill_2
X_4169_ _4169_/Y _4314_/A _5884_/Q _4169_/C VPWR VGND sg13cmos5l_nand3_1
XFILLER_43_549 VPWR VGND sg13cmos5l_fill_1
XFILLER_24_752 VPWR VGND sg13cmos5l_fill_2
XFILLER_24_763 VPWR VGND sg13cmos5l_fill_2
X_6027__326 _6027_/RESET_B VPWR VGND sg13cmos5l_tiehi
XFILLER_23_251 VPWR VGND sg13cmos5l_fill_2
XFILLER_24_785 VPWR VGND sg13cmos5l_fill_2
XFILLER_8_918 VPWR VGND sg13cmos5l_decap_4
XFILLER_48_62 VPWR VGND sg13cmos5l_fill_1
XFILLER_14_295 VPWR VGND sg13cmos5l_fill_2
XFILLER_7_962 VPWR VGND sg13cmos5l_decap_8
X_3540_ _3540_/Y _3540_/A _3542_/S VPWR VGND sg13cmos5l_nor2_1
XFILLER_6_461 VPWR VGND sg13cmos5l_fill_1
X_3471_ _3480_/S _3793_/A _3507_/B VPWR VGND sg13cmos5l_nand2_1
X_5210_ _5231_/C _6016_/Q _6014_/Q _6015_/Q VPWR VGND sg13cmos5l_nor3_1
X_5141_ _5141_/Y _5141_/A _5141_/B _5141_/C VPWR VGND sg13cmos5l_nor3_1
X_5072_ _5176_/B _5278_/A _6053_/Q VPWR VGND sg13cmos5l_nor2_1
Xhold1607 _3150_/A _5957_/Q VPWR VGND sg13cmos5l_dlygate4sd3_1
Xhold1629 _4500_/A _5937_/Q VPWR VGND sg13cmos5l_dlygate4sd3_1
Xhold1618 _5884_/D _4221_/Y VPWR VGND sg13cmos5l_dlygate4sd3_1
X_4023_ _4023_/Y _4022_/B _5625_/Q _4022_/Y VPWR VGND sg13cmos5l_o21ai_1
X_5974_ _5974_/Q _6005_/CLK _5974_/D _5974_/RESET_B VPWR VGND sg13cmos5l_dfrbpq_1
X_4925_ _4926_/B _4928_/A _4928_/C _4923_/Y VPWR VGND sg13cmos5l_o21ai_1
X_4856_ _4857_/B _6002_/Q _4867_/B VPWR VGND sg13cmos5l_or2_1
XFILLER_33_593 VPWR VGND sg13cmos5l_fill_1
X_3807_ _3813_/B _3807_/A _3807_/B _3807_/C VPWR VGND sg13cmos5l_nand3_1
X_4787_ _4787_/Y _5010_/A _5957_/Q _4784_/Y _4786_/Y _4785_/Y VPWR VGND sg13cmos5l_a221oi_1
X_3738_ _3738_/Y _3739_/S1 _3731_/X _5807_/Q VPWR VGND sg13cmos5l_o21ai_1
X_3669_ _3669_/Y _3731_/S _5724_/Q _3668_/Y VPWR VGND sg13cmos5l_o21ai_1
X_5408_ _5534_/D _5408_/A0 _5408_/A1 _5408_/S VPWR VGND sg13cmos5l_mux2_1
X_5339_ _5472_/D _5339_/A0 _3384_/A _5341_/S VPWR VGND sg13cmos5l_mux2_1
XFILLER_44_858 VPWR VGND sg13cmos5l_decap_8
XFILLER_34_31 VPWR VGND sg13cmos5l_fill_1
XFILLER_24_560 VPWR VGND sg13cmos5l_fill_2
X_6040__312 _6040_/RESET_B VPWR VGND sg13cmos5l_tiehi
XFILLER_4_910 VPWR VGND sg13cmos5l_fill_1
XFILLER_4_943 VPWR VGND sg13cmos5l_fill_2
XFILLER_4_932 VPWR VGND sg13cmos5l_fill_1
X_5875__503 _5875_/RESET_B VPWR VGND sg13cmos5l_tiehi
XFILLER_47_663 VPWR VGND sg13cmos5l_fill_1
XFILLER_19_343 VPWR VGND sg13cmos5l_fill_2
XFILLER_19_387 VPWR VGND sg13cmos5l_decap_8
XFILLER_22_508 VPWR VGND sg13cmos5l_fill_1
XFILLER_34_357 VPWR VGND sg13cmos5l_fill_2
XFILLER_34_368 VPWR VGND sg13cmos5l_fill_1
X_5690_ _5690_/Q _5860_/CLK _5690_/D _5690_/RESET_B VPWR VGND sg13cmos5l_dfrbpq_1
X_4710_ _5975_/D _4710_/A _4710_/B _4710_/C VPWR VGND sg13cmos5l_nor3_1
X_4641_ _5960_/D _4818_/A _4641_/B VPWR VGND sg13cmos5l_and2_1
X_5708__712 _5708_/RESET_B VPWR VGND sg13cmos5l_tiehi
X_5567__860 _5567_/RESET_B VPWR VGND sg13cmos5l_tiehi
X_4572_ _4572_/Y _4769_/A _4757_/A VPWR VGND sg13cmos5l_nand2_1
X_3523_ _5753_/D _3609_/A1 _3531_/B _3522_/Y VPWR VGND sg13cmos5l_o21ai_1
X_3454_ _3454_/X _3454_/A0 _3440_/A _3455_/B VPWR VGND sg13cmos5l_mux2_1
XFILLER_41_0 VPWR VGND sg13cmos5l_fill_2
X_3385_ _5684_/D _3122_/Y _3388_/S _3384_/Y VPWR VGND sg13cmos5l_o21ai_1
X_5124_ _6045_/D _5266_/A _5251_/A VPWR VGND sg13cmos5l_nor2_1
Xhold1415 _5423_/A0 _5548_/Q VPWR VGND sg13cmos5l_dlygate4sd3_1
Xhold1404 _3247_/A1 _5570_/Q VPWR VGND sg13cmos5l_dlygate4sd3_1
Xhold1426 _3516_/A1 _5751_/Q VPWR VGND sg13cmos5l_dlygate4sd3_1
X_5055_ _5055_/Y _5055_/A _5055_/B VPWR VGND sg13cmos5l_xnor2_1
Xhold1448 _3403_/A1 _5700_/Q VPWR VGND sg13cmos5l_dlygate4sd3_1
Xhold1437 _3246_/A1 _5569_/Q VPWR VGND sg13cmos5l_dlygate4sd3_1
Xhold1459 _5394_/A1 _5521_/Q VPWR VGND sg13cmos5l_dlygate4sd3_1
X_5715__705 _5715_/RESET_B VPWR VGND sg13cmos5l_tiehi
X_4006_ _4006_/X _5487_/Q _5470_/Q _5453_/Q _5436_/Q _4029_/S _4031_/A1 VPWR VGND
+ sg13cmos5l_mux4_1
X_5574__853 _5574_/RESET_B VPWR VGND sg13cmos5l_tiehi
XFILLER_25_302 VPWR VGND sg13cmos5l_fill_1
XFILLER_26_825 VPWR VGND sg13cmos5l_decap_4
X_5957_ _5957_/Q _6007_/CLK _5957_/D _5957_/RESET_B VPWR VGND sg13cmos5l_dfrbpq_1
X_4908_ _4928_/B _6010_/Q _6009_/Q VPWR VGND sg13cmos5l_xnor2_1
XFILLER_34_891 VPWR VGND sg13cmos5l_decap_8
XFILLER_40_338 VPWR VGND sg13cmos5l_fill_1
X_5888_ _5888_/Q _5894_/CLK _5888_/D _5888_/RESET_B VPWR VGND sg13cmos5l_dfrbpq_1
XFILLER_21_574 VPWR VGND sg13cmos5l_fill_2
X_4839_ _4839_/Y _4749_/B _4872_/A _4838_/Y VPWR VGND sg13cmos5l_o21ai_1
XFILLER_4_239 VPWR VGND sg13cmos5l_fill_2
X_5581__846 _5581_/RESET_B VPWR VGND sg13cmos5l_tiehi
XFILLER_49_917 VPWR VGND sg13cmos5l_decap_8
XFILLER_0_445 VPWR VGND sg13cmos5l_fill_2
XFILLER_1_946 VPWR VGND sg13cmos5l_decap_8
XFILLER_44_688 VPWR VGND sg13cmos5l_decap_4
XFILLER_12_530 VPWR VGND sg13cmos5l_fill_1
XFILLER_31_327 VPWR VGND sg13cmos5l_fill_2
XFILLER_12_541 VPWR VGND sg13cmos5l_fill_2
XFILLER_12_596 VPWR VGND sg13cmos5l_fill_2
X_5944__294 _5944_/D VPWR VGND sg13cmos5l_tielo
XFILLER_6_35 VPWR VGND sg13cmos5l_fill_1
XFILLER_4_784 VPWR VGND sg13cmos5l_fill_2
XFILLER_3_250 VPWR VGND sg13cmos5l_fill_2
XFILLER_6_1006 VPWR VGND sg13cmos5l_decap_8
X_3170_ _3171_/B _4071_/A _3169_/X _3931_/A VPWR VGND sg13cmos5l_o21ai_1
XFILLER_48_950 VPWR VGND sg13cmos5l_decap_8
XFILLER_35_622 VPWR VGND sg13cmos5l_fill_2
X_5811_ _5811_/Q clkload8/A _5811_/D _5811_/RESET_B VPWR VGND sg13cmos5l_dfrbpq_1
XFILLER_23_828 VPWR VGND sg13cmos5l_fill_1
X_5742_ _5742_/Q _5825_/CLK _5742_/D _5742_/RESET_B VPWR VGND sg13cmos5l_dfrbpq_1
X_5673_ _5673_/Q _5860_/CLK _5673_/D _5673_/RESET_B VPWR VGND sg13cmos5l_dfrbpq_1
X_4624_ _4632_/A _4463_/A _4622_/X _4623_/Y _4615_/C VPWR VGND sg13cmos5l_a22oi_1
X_4555_ _4569_/S _4555_/A _4555_/B VPWR VGND sg13cmos5l_nor2_1
X_3506_ _3506_/Y _3518_/A1 _3498_/B _3505_/Y VPWR VGND sg13cmos5l_o21ai_1
X_5958__408 _5958_/RESET_B VPWR VGND sg13cmos5l_tiehi
X_4486_ _4486_/Y _5930_/Q _5903_/Q VPWR VGND sg13cmos5l_xnor2_1
X_3437_ _5713_/D _3501_/A1 _3440_/B _3436_/Y VPWR VGND sg13cmos5l_a21oi_1
X_3368_ _5672_/D _3391_/A0 _3368_/A1 _3374_/B VPWR VGND sg13cmos5l_mux2_1
Xhold1234 _5349_/A0 _5481_/Q VPWR VGND sg13cmos5l_dlygate4sd3_1
Xhold1223 _5329_/A0 _5463_/Q VPWR VGND sg13cmos5l_dlygate4sd3_1
Xhold1201 _3140_/A _5748_/Q VPWR VGND sg13cmos5l_dlygate4sd3_1
X_5107_ _5108_/A _6041_/Q _5106_/Y _5120_/S VPWR VGND sg13cmos5l_mux2_1
Xhold1212 _3379_/A0 _5680_/Q VPWR VGND sg13cmos5l_dlygate4sd3_1
Xhold1267 _3250_/A1 _5573_/Q VPWR VGND sg13cmos5l_dlygate4sd3_1
X_3299_ _5611_/D _3299_/A0 _5372_/A0 _3307_/S VPWR VGND sg13cmos5l_mux2_1
X_6030__322 _6030_/RESET_B VPWR VGND sg13cmos5l_tiehi
Xhold1245 _3405_/A1 _5702_/Q VPWR VGND sg13cmos5l_dlygate4sd3_1
Xhold1256 _3406_/A1 _5703_/Q VPWR VGND sg13cmos5l_dlygate4sd3_1
Xhold1289 _3554_/A0 _5769_/Q VPWR VGND sg13cmos5l_dlygate4sd3_1
X_5038_ _5039_/B _5038_/A _5038_/B VPWR VGND sg13cmos5l_xnor2_1
Xhold1278 _5373_/A1 _5502_/Q VPWR VGND sg13cmos5l_dlygate4sd3_1
X_5898__300 _5898_/D VPWR VGND sg13cmos5l_tielo
XFILLER_1_787 VPWR VGND sg13cmos5l_fill_2
XFILLER_37_909 VPWR VGND sg13cmos5l_fill_2
XFILLER_29_460 VPWR VGND sg13cmos5l_decap_8
X_5557__870 _5557_/RESET_B VPWR VGND sg13cmos5l_tiehi
XFILLER_16_110 VPWR VGND sg13cmos5l_fill_2
XFILLER_45_986 VPWR VGND sg13cmos5l_decap_8
XFILLER_44_485 VPWR VGND sg13cmos5l_decap_8
XFILLER_9_876 VPWR VGND sg13cmos5l_decap_8
X_5705__715 _5705_/RESET_B VPWR VGND sg13cmos5l_tiehi
X_4340_ _4343_/B _4337_/Y _4339_/Y _4336_/Y VPWR VGND sg13cmos5l_o21ai_1
X_5564__863 _5564_/RESET_B VPWR VGND sg13cmos5l_tiehi
X_4271_ _4271_/Y _4271_/A _4256_/Y VPWR VGND sg13cmos5l_nor2b_1
X_6010_ _6010_/Q _6061_/CLK _6010_/D _6010_/RESET_B VPWR VGND sg13cmos5l_dfrbpq_1
X_3222_ _5352_/D _3824_/A _3824_/B VPWR VGND sg13cmos5l_nor2_1
X_3153_ _4830_/A _4615_/B VPWR VGND sg13cmos5l_inv_1
X_3084_ _3807_/A _3803_/A VPWR VGND sg13cmos5l_inv_1
X_5712__708 _5712_/RESET_B VPWR VGND sg13cmos5l_tiehi
X_5571__856 _5571_/RESET_B VPWR VGND sg13cmos5l_tiehi
XFILLER_36_986 VPWR VGND sg13cmos5l_decap_4
X_3986_ _3986_/Y _3982_/Y _3985_/Y _4102_/A VPWR VGND sg13cmos5l_o21ai_1
XFILLER_23_669 VPWR VGND sg13cmos5l_fill_1
X_5725_ _5725_/Q _6074_/CLK _5725_/D _5725_/RESET_B VPWR VGND sg13cmos5l_dfrbpq_1
X_5656_ _5656_/Q _5860_/CLK _5656_/D _5656_/RESET_B VPWR VGND sg13cmos5l_dfrbpq_1
X_4607_ _4607_/Y _4829_/A _3154_/Y _3155_/Y _5972_/Q VPWR VGND sg13cmos5l_a22oi_1
X_5587_ _5587_/Q clkload5/A _5587_/D _5587_/RESET_B VPWR VGND sg13cmos5l_dfrbpq_1
X_4538_ _4759_/A _4829_/A _5974_/Q VPWR VGND sg13cmos5l_xnor2_1
X_4469_ _4469_/Y _3076_/Y _4471_/A2 _4468_/Y VPWR VGND sg13cmos5l_a21oi_1
Xhold1031 _5798_/D _3615_/Y VPWR VGND sg13cmos5l_dlygate4sd3_1
Xhold1042 _3558_/A _5771_/Q VPWR VGND sg13cmos5l_dlygate4sd3_1
Xhold1020 _4309_/B _5878_/Q VPWR VGND sg13cmos5l_dlygate4sd3_1
Xhold1075 _3502_/A _5744_/Q VPWR VGND sg13cmos5l_dlygate4sd3_1
Xhold1064 _3477_/B1 _3476_/Y VPWR VGND sg13cmos5l_dlygate4sd3_1
Xhold1053 _3524_/A _5754_/Q VPWR VGND sg13cmos5l_dlygate4sd3_1
Xhold1086 _5787_/D _3592_/Y VPWR VGND sg13cmos5l_dlygate4sd3_1
Xhold1097 _4465_/B _5899_/Q VPWR VGND sg13cmos5l_dlygate4sd3_1
XFILLER_14_614 VPWR VGND sg13cmos5l_fill_2
XFILLER_27_975 VPWR VGND sg13cmos5l_decap_8
XFILLER_27_997 VPWR VGND sg13cmos5l_decap_4
XFILLER_14_625 VPWR VGND sg13cmos5l_fill_2
XFILLER_41_444 VPWR VGND sg13cmos5l_decap_8
XFILLER_6_802 VPWR VGND sg13cmos5l_fill_2
XFILLER_6_835 VPWR VGND sg13cmos5l_fill_2
XFILLER_49_555 VPWR VGND sg13cmos5l_decap_8
XFILLER_3_1009 VPWR VGND sg13cmos5l_decap_8
XFILLER_18_953 VPWR VGND sg13cmos5l_decap_8
X_5811__607 _5811_/RESET_B VPWR VGND sg13cmos5l_tiehi
XFILLER_33_912 VPWR VGND sg13cmos5l_decap_8
X_5948__418 _5948_/RESET_B VPWR VGND sg13cmos5l_tiehi
X_5514__504 _5514_/RESET_B VPWR VGND sg13cmos5l_tiehi
XFILLER_33_934 VPWR VGND sg13cmos5l_fill_1
XFILLER_33_956 VPWR VGND sg13cmos5l_decap_8
X_3840_ _5842_/D _5428_/A _3840_/B _3843_/A _3840_/D VPWR VGND sg13cmos5l_nor4_1
X_3771_ _3772_/B _3771_/A _3782_/D VPWR VGND sg13cmos5l_xnor2_1
XFILLER_32_488 VPWR VGND sg13cmos5l_fill_2
XFILLER_34_1011 VPWR VGND sg13cmos5l_fill_1
X_5510_ _5510_/Q clkload2/A _5510_/D _5510_/RESET_B VPWR VGND sg13cmos5l_dfrbpq_1
X_5441_ _5441_/Q _5555_/CLK _5441_/D _5441_/RESET_B VPWR VGND sg13cmos5l_dfrbpq_1
X_5372_ _5501_/D _5372_/A0 _5372_/A1 _5379_/S VPWR VGND sg13cmos5l_mux2_1
X_4323_ _4332_/A _4346_/A _4331_/B VPWR VGND sg13cmos5l_or2_1
Xfanout129 _3760_/A1 _3739_/S1 VPWR VGND sg13cmos5l_buf_1
Xfanout107 _5164_/B _6051_/Q VPWR VGND sg13cmos5l_buf_1
Xfanout118 _5352_/B hold1624/X VPWR VGND sg13cmos5l_buf_1
X_4254_ _4261_/C _5866_/Q _5865_/Q _4254_/B1 VPWR VGND sg13cmos5l_o21ai_1
X_3205_ _3205_/Y _3191_/A _5279_/C _5275_/A VPWR VGND sg13cmos5l_o21ai_1
X_4185_ _4185_/Y _5875_/Q _4186_/A2 _4190_/A VPWR VGND sg13cmos5l_o21ai_1
XFILLER_27_205 VPWR VGND sg13cmos5l_decap_4
X_3136_ _4831_/A _3136_/A VPWR VGND sg13cmos5l_inv_1
X_3067_ _3067_/Y _6048_/Q VPWR VGND sg13cmos5l_inv_1
XFILLER_23_499 VPWR VGND sg13cmos5l_decap_4
X_3969_ _3969_/Y _5617_/Q _4097_/S VPWR VGND sg13cmos5l_nand2b_1
X_5708_ _5708_/Q _6077_/CLK _5708_/D _5708_/RESET_B VPWR VGND sg13cmos5l_dfrbpq_1
X_5639_ _5639_/Q _5860_/CLK _5639_/D _5639_/RESET_B VPWR VGND sg13cmos5l_dfrbpq_1
XFILLER_18_205 VPWR VGND sg13cmos5l_fill_1
XFILLER_46_547 VPWR VGND sg13cmos5l_decap_8
XFILLER_2_1020 VPWR VGND sg13cmos5l_decap_8
X_5554__873 _5554_/RESET_B VPWR VGND sg13cmos5l_tiehi
XFILLER_18_1028 VPWR VGND sg13cmos5l_fill_1
XFILLER_30_926 VPWR VGND sg13cmos5l_fill_1
X_5702__718 _5702_/RESET_B VPWR VGND sg13cmos5l_tiehi
X_5561__866 _5561_/RESET_B VPWR VGND sg13cmos5l_tiehi
X_5990_ _5990_/Q _6056_/CLK _5990_/D _5990_/RESET_B VPWR VGND sg13cmos5l_dfrbpq_1
XFILLER_37_569 VPWR VGND sg13cmos5l_fill_2
X_4941_ _4953_/B _5985_/Q _4951_/B VPWR VGND sg13cmos5l_nor2_1
X_4872_ _4872_/Y _4872_/A _4872_/B _4872_/C VPWR VGND sg13cmos5l_nor3_1
X_3823_ _3825_/B _3824_/B _3824_/C _3824_/A VPWR VGND sg13cmos5l_a21oi_1
X_3754_ _3754_/Y _3753_/B _5740_/Q _3753_/Y VPWR VGND sg13cmos5l_o21ai_1
XFILLER_20_469 VPWR VGND sg13cmos5l_decap_8
X_3685_ _5810_/D input4/X _3683_/X _3684_/Y VPWR VGND sg13cmos5l_a21oi_1
X_5488__580 _5488_/RESET_B VPWR VGND sg13cmos5l_tiehi
X_5424_ _5820_/D _5429_/A _5424_/B _5424_/C VPWR VGND sg13cmos5l_nor3_1
X_5355_ _5486_/D _5355_/A0 _5355_/A1 _5360_/S VPWR VGND sg13cmos5l_mux2_1
X_5286_ _5286_/Y _5287_/A _3159_/D _5285_/Y VPWR VGND sg13cmos5l_o21ai_1
X_4306_ _4306_/Y _4200_/A _4307_/A2 _4358_/B VPWR VGND sg13cmos5l_o21ai_1
X_4237_ _4423_/B _4477_/A _5913_/Q VPWR VGND sg13cmos5l_nor2_1
XFILLER_28_547 VPWR VGND sg13cmos5l_decap_8
X_4168_ _4168_/X _3858_/Y _4167_/Y _4169_/C VPWR VGND sg13cmos5l_mux2_1
X_3119_ _3119_/Y _3119_/A VPWR VGND sg13cmos5l_inv_1
X_4099_ _4099_/Y _4099_/A1 _4096_/Y _4098_/Y VPWR VGND sg13cmos5l_o21ai_1
XFILLER_15_219 VPWR VGND sg13cmos5l_fill_2
XFILLER_8_908 VPWR VGND sg13cmos5l_decap_8
XFILLER_20_992 VPWR VGND sg13cmos5l_fill_1
X_5938__428 _5938_/RESET_B VPWR VGND sg13cmos5l_tiehi
XFILLER_47_801 VPWR VGND sg13cmos5l_decap_8
X_5511__529 _5511_/RESET_B VPWR VGND sg13cmos5l_tiehi
X_3470_ _3507_/B _3796_/A _5826_/Q _4131_/A VPWR VGND sg13cmos5l_nor3_1
X_5140_ _5141_/C _6048_/Q _5140_/B VPWR VGND sg13cmos5l_nor2_1
X_5071_ _6039_/D _5071_/A _5071_/B _5071_/C VPWR VGND sg13cmos5l_nor3_1
Xhold1608 _4638_/B _4637_/X VPWR VGND sg13cmos5l_dlygate4sd3_1
Xhold1619 hold1619/X _5840_/Q VPWR VGND sg13cmos5l_dlygate4sd3_1
XFILLER_38_812 VPWR VGND sg13cmos5l_decap_4
X_4022_ _4022_/Y _5608_/Q _4022_/B VPWR VGND sg13cmos5l_nand2b_1
X_5973_ _5973_/Q _5973_/CLK _5973_/D _5973_/RESET_B VPWR VGND sg13cmos5l_dfrbpq_1
X_4924_ _4924_/Y _4924_/A _4924_/B _4924_/C VPWR VGND sg13cmos5l_nand3_1
X_4855_ _4879_/A _6001_/Q _4867_/B _4871_/A VPWR VGND sg13cmos5l_a21o_1
X_3806_ _3806_/Y _3807_/A _3800_/Y _3805_/Y VPWR VGND sg13cmos5l_a21oi_1
XFILLER_21_789 VPWR VGND sg13cmos5l_fill_2
X_4786_ _4786_/Y _5955_/Q _6004_/Q VPWR VGND sg13cmos5l_nand2b_1
X_3737_ _3737_/Y _3733_/Y _3736_/Y _3762_/A VPWR VGND sg13cmos5l_o21ai_1
XFILLER_20_299 VPWR VGND sg13cmos5l_fill_1
X_3668_ _3668_/Y _5718_/Q _3731_/S VPWR VGND sg13cmos5l_nand2b_1
X_3599_ _5790_/D _3611_/A1 _3605_/B _3598_/Y VPWR VGND sg13cmos5l_o21ai_1
X_5407_ _5533_/D _5407_/A0 _3217_/A _5407_/S VPWR VGND sg13cmos5l_mux2_1
X_5338_ _5471_/D _5338_/A0 _5298_/A _5341_/S VPWR VGND sg13cmos5l_mux2_1
XFILLER_48_609 VPWR VGND sg13cmos5l_fill_1
X_5269_ _6064_/D _5272_/A _5269_/B _5269_/C VPWR VGND sg13cmos5l_nor3_1
X_6052__943 _6052_/RESET_B VPWR VGND sg13cmos5l_tiehi
X_5868__511 _5868_/RESET_B VPWR VGND sg13cmos5l_tiehi
X_5551__876 _5551_/RESET_B VPWR VGND sg13cmos5l_tiehi
XFILLER_4_922 VPWR VGND sg13cmos5l_fill_1
XFILLER_4_999 VPWR VGND sg13cmos5l_decap_8
XFILLER_34_336 VPWR VGND sg13cmos5l_fill_2
X_4640_ _4640_/Y _4627_/Y _4640_/A2 _4710_/A VPWR VGND sg13cmos5l_a21oi_1
X_4571_ _5947_/D _4638_/A _4571_/B VPWR VGND sg13cmos5l_nor2_1
X_3522_ _3522_/Y _3522_/A _3531_/B VPWR VGND sg13cmos5l_nand2_1
X_3453_ _5720_/D _3615_/A1 _3452_/B _3452_/Y VPWR VGND sg13cmos5l_a21oi_1
X_5123_ _5251_/A _5100_/A _5119_/B _5122_/Y VPWR VGND sg13cmos5l_a21oi_1
X_3384_ _3384_/Y _3384_/A _3388_/S VPWR VGND sg13cmos5l_nand2_1
XFILLER_34_0 VPWR VGND sg13cmos5l_fill_2
Xhold1416 _3363_/A0 _5668_/Q VPWR VGND sg13cmos5l_dlygate4sd3_1
Xhold1405 _3838_/A _5844_/Q VPWR VGND sg13cmos5l_dlygate4sd3_1
Xhold1449 _3357_/A0 _5662_/Q VPWR VGND sg13cmos5l_dlygate4sd3_1
X_5054_ _5055_/B _6034_/Q _5059_/B VPWR VGND sg13cmos5l_xnor2_1
Xhold1427 _3249_/A1 _5572_/Q VPWR VGND sg13cmos5l_dlygate4sd3_1
XFILLER_38_631 VPWR VGND sg13cmos5l_fill_1
Xhold1438 _3330_/A1 _5638_/Q VPWR VGND sg13cmos5l_dlygate4sd3_1
X_4005_ _4005_/Y _4011_/A _4005_/B VPWR VGND sg13cmos5l_nor2_1
XFILLER_26_848 VPWR VGND sg13cmos5l_fill_2
XFILLER_41_807 VPWR VGND sg13cmos5l_fill_1
X_5956_ _5956_/Q _6007_/CLK _5956_/D _5956_/RESET_B VPWR VGND sg13cmos5l_dfrbpq_1
XFILLER_34_881 VPWR VGND sg13cmos5l_fill_1
X_5887_ _5887_/Q _5894_/CLK _5887_/D _5887_/RESET_B VPWR VGND sg13cmos5l_dfrbpq_1
X_4907_ _4910_/B _6037_/Q _4907_/B VPWR VGND sg13cmos5l_nand2_1
X_4838_ _4838_/Y _4838_/A _4877_/B VPWR VGND sg13cmos5l_nand2_1
X_4769_ _4770_/B _4769_/A _4771_/B VPWR VGND sg13cmos5l_or2_1
XFILLER_48_439 VPWR VGND sg13cmos5l_decap_8
XFILLER_17_826 VPWR VGND sg13cmos5l_fill_2
XFILLER_44_634 VPWR VGND sg13cmos5l_fill_1
XFILLER_45_86 VPWR VGND sg13cmos5l_fill_1
XFILLER_8_535 VPWR VGND sg13cmos5l_fill_1
XFILLER_8_579 VPWR VGND sg13cmos5l_fill_1
XFILLER_0_991 VPWR VGND sg13cmos5l_decap_8
XFILLER_47_483 VPWR VGND sg13cmos5l_decap_8
X_5810_ _5810_/Q _5810_/CLK _5810_/D _5810_/RESET_B VPWR VGND sg13cmos5l_dfrbpq_1
X_5741_ _5741_/Q _6063_/CLK _5741_/D _5741_/RESET_B VPWR VGND sg13cmos5l_dfrbpq_1
XFILLER_16_881 VPWR VGND sg13cmos5l_decap_4
X_5672_ _5672_/Q _5695_/CLK _5672_/D _5672_/RESET_B VPWR VGND sg13cmos5l_dfrbpq_1
X_4623_ _4623_/Y _5976_/Q _5972_/Q VPWR VGND sg13cmos5l_nor2b_1
X_4554_ _4555_/B _4561_/B _4573_/B VPWR VGND sg13cmos5l_nor2_1
X_3505_ _3505_/Y _3505_/A _3505_/B VPWR VGND sg13cmos5l_nand2_1
X_4485_ _4485_/Y _4491_/A _4491_/B VPWR VGND sg13cmos5l_nand2_1
XFILLER_44_1013 VPWR VGND sg13cmos5l_decap_8
X_3436_ _3436_/Y _3436_/A _3440_/B VPWR VGND sg13cmos5l_nor2_1
X_5858__521 _5858_/RESET_B VPWR VGND sg13cmos5l_tiehi
X_3367_ _5671_/D _5353_/A0 _3367_/A1 _3374_/B VPWR VGND sg13cmos5l_mux2_1
Xhold1213 _3371_/A1 _5675_/Q VPWR VGND sg13cmos5l_dlygate4sd3_1
Xhold1224 _5421_/A0 _5546_/Q VPWR VGND sg13cmos5l_dlygate4sd3_1
Xhold1202 _5748_/D _3511_/Y VPWR VGND sg13cmos5l_dlygate4sd3_1
X_5106_ _5106_/Y _5106_/A _5119_/B VPWR VGND sg13cmos5l_nand2_1
X_5037_ _5038_/B _5037_/A1 _5042_/B _5022_/Y VPWR VGND sg13cmos5l_a21oi_1
X_3298_ _3306_/S _5361_/C _5342_/B _3317_/D VPWR VGND sg13cmos5l_nor3_1
Xhold1257 _3364_/A0 _5669_/Q VPWR VGND sg13cmos5l_dlygate4sd3_1
Xhold1246 _3283_/A1 _5597_/Q VPWR VGND sg13cmos5l_dlygate4sd3_1
XFILLER_39_962 VPWR VGND sg13cmos5l_fill_1
Xhold1235 _5344_/A0 _5476_/Q VPWR VGND sg13cmos5l_dlygate4sd3_1
Xhold1279 _3341_/A0 _5648_/Q VPWR VGND sg13cmos5l_dlygate4sd3_1
Xhold1268 _3342_/A0 _5649_/Q VPWR VGND sg13cmos5l_dlygate4sd3_1
XFILLER_39_984 VPWR VGND sg13cmos5l_decap_4
XFILLER_41_637 VPWR VGND sg13cmos5l_fill_1
X_5939_ _5939_/Q _5943_/CLK _5939_/D _5939_/RESET_B VPWR VGND sg13cmos5l_dfrbpq_1
X_5865__514 _5865_/RESET_B VPWR VGND sg13cmos5l_tiehi
XFILLER_21_394 VPWR VGND sg13cmos5l_fill_1
XFILLER_31_99 VPWR VGND sg13cmos5l_fill_2
XFILLER_49_704 VPWR VGND sg13cmos5l_decap_4
XFILLER_0_232 VPWR VGND sg13cmos5l_fill_1
XFILLER_49_748 VPWR VGND sg13cmos5l_fill_1
XFILLER_49_737 VPWR VGND sg13cmos5l_decap_8
X_5872__507 _5872_/RESET_B VPWR VGND sg13cmos5l_tiehi
XFILLER_0_265 VPWR VGND sg13cmos5l_fill_2
XFILLER_45_965 VPWR VGND sg13cmos5l_decap_8
XFILLER_44_420 VPWR VGND sg13cmos5l_fill_1
XFILLER_44_464 VPWR VGND sg13cmos5l_decap_8
XFILLER_17_689 VPWR VGND sg13cmos5l_fill_1
XFILLER_31_158 VPWR VGND sg13cmos5l_fill_2
XFILLER_8_321 VPWR VGND sg13cmos5l_decap_4
XFILLER_8_310 VPWR VGND sg13cmos5l_fill_1
XFILLER_9_844 VPWR VGND sg13cmos5l_decap_8
XFILLER_9_855 VPWR VGND sg13cmos5l_fill_2
XFILLER_8_376 VPWR VGND sg13cmos5l_fill_2
X_4270_ _5891_/D _4314_/B _4343_/A VPWR VGND sg13cmos5l_nor2_1
X_3221_ _3221_/Y _5832_/Q _3162_/Y _3220_/Y VPWR VGND sg13cmos5l_a21oi_1
X_3152_ _4463_/A _5928_/Q VPWR VGND sg13cmos5l_inv_1
XFILLER_39_247 VPWR VGND sg13cmos5l_fill_1
X_3083_ _3083_/Y _3083_/A VPWR VGND sg13cmos5l_inv_1
X_5818__593 _5818_/RESET_B VPWR VGND sg13cmos5l_tiehi
XFILLER_23_604 VPWR VGND sg13cmos5l_fill_2
XFILLER_35_464 VPWR VGND sg13cmos5l_decap_8
XFILLER_22_125 VPWR VGND sg13cmos5l_fill_1
X_3985_ _3985_/Y _4111_/A1 _3984_/Y _3918_/A VPWR VGND sg13cmos5l_o21ai_1
X_5724_ _5724_/Q _6047_/CLK _5724_/D _5724_/RESET_B VPWR VGND sg13cmos5l_dfrbpq_1
X_5655_ _5655_/Q _5695_/CLK _5655_/D _5655_/RESET_B VPWR VGND sg13cmos5l_dfrbpq_1
X_4606_ _5953_/D _4606_/A _4606_/B VPWR VGND sg13cmos5l_nor2_1
X_5586_ _5586_/Q clkload8/A _5586_/D _5586_/RESET_B VPWR VGND sg13cmos5l_dfrbpq_1
X_4537_ _4539_/B _5946_/Q _5945_/Q _5947_/Q VPWR VGND sg13cmos5l_o21ai_1
X_5543__948 _5543_/RESET_B VPWR VGND sg13cmos5l_tiehi
X_4468_ _4468_/Y _5931_/Q _4471_/A2 _4649_/A VPWR VGND sg13cmos5l_o21ai_1
X_3419_ _3419_/Y _3509_/A1 _3418_/B _3419_/B1 VPWR VGND sg13cmos5l_o21ai_1
X_4399_ _5916_/D _4480_/A _4480_/B _4460_/A VPWR VGND sg13cmos5l_a21oi_1
X_5498__560 _5498_/RESET_B VPWR VGND sg13cmos5l_tiehi
Xhold1021 _3488_/A _5737_/Q VPWR VGND sg13cmos5l_dlygate4sd3_1
Xhold1010 _3419_/B1 _3418_/Y VPWR VGND sg13cmos5l_dlygate4sd3_1
Xhold1032 _4182_/B _5851_/Q VPWR VGND sg13cmos5l_dlygate4sd3_1
XFILLER_45_217 VPWR VGND sg13cmos5l_fill_1
Xhold1076 _5744_/D _3503_/Y VPWR VGND sg13cmos5l_dlygate4sd3_1
Xhold1054 _3580_/A _5782_/Q VPWR VGND sg13cmos5l_dlygate4sd3_1
Xhold1065 _5731_/D _3477_/Y VPWR VGND sg13cmos5l_dlygate4sd3_1
X_6069_ _6069_/Q _6077_/CLK _6069_/D _6069_/RESET_B VPWR VGND sg13cmos5l_dfrbpq_1
Xhold1043 _5005_/B _5996_/Q VPWR VGND sg13cmos5l_dlygate4sd3_1
Xhold1098 _3555_/A _5770_/Q VPWR VGND sg13cmos5l_dlygate4sd3_1
Xhold1087 _3474_/A _5730_/Q VPWR VGND sg13cmos5l_dlygate4sd3_1
XFILLER_27_954 VPWR VGND sg13cmos5l_decap_8
X_5872__304 _5872_/D VPWR VGND sg13cmos5l_tielo
XFILLER_49_534 VPWR VGND sg13cmos5l_decap_8
XFILLER_18_987 VPWR VGND sg13cmos5l_decap_4
XFILLER_32_456 VPWR VGND sg13cmos5l_decap_4
X_3770_ _5815_/D _3772_/A _3773_/A _3769_/Y VPWR VGND sg13cmos5l_a21oi_1
X_5440_ _5440_/Q _5853_/CLK _5440_/D _5440_/RESET_B VPWR VGND sg13cmos5l_dfrbpq_1
X_5371_ _5379_/S _5371_/A _5371_/B _5409_/A _5409_/C VPWR VGND sg13cmos5l_nand4_1
X_4322_ _4331_/B _5908_/Q _4327_/B VPWR VGND sg13cmos5l_xnor2_1
X_4253_ _4261_/B _5866_/Q _5865_/Q _5867_/Q VPWR VGND sg13cmos5l_or3_1
Xfanout108 _4978_/B _4936_/A VPWR VGND sg13cmos5l_buf_1
Xfanout119 _3824_/A _5371_/A VPWR VGND sg13cmos5l_buf_1
X_3204_ _3204_/Y _3865_/A _3204_/B VPWR VGND sg13cmos5l_nor2_1
X_5855__524 _5855_/RESET_B VPWR VGND sg13cmos5l_tiehi
X_6018__284 _6018_/D VPWR VGND sg13cmos5l_tielo
X_4184_ _4184_/Y _4124_/A _4186_/A2 _4183_/Y VPWR VGND sg13cmos5l_a21oi_1
X_3135_ _4970_/B _5987_/Q VPWR VGND sg13cmos5l_inv_1
X_3066_ _3066_/Y _3066_/A VPWR VGND sg13cmos5l_inv_1
XFILLER_35_261 VPWR VGND sg13cmos5l_fill_2
X_3968_ _3968_/Y _3955_/Y _3956_/Y _3967_/Y VPWR VGND sg13cmos5l_o21ai_1
XFILLER_23_478 VPWR VGND sg13cmos5l_decap_8
X_5707_ _5707_/Q _6047_/CLK _5707_/D _5707_/RESET_B VPWR VGND sg13cmos5l_dfrbpq_1
XFILLER_32_990 VPWR VGND sg13cmos5l_decap_8
X_5862__517 _5862_/RESET_B VPWR VGND sg13cmos5l_tiehi
X_3899_ _3899_/Y _4040_/S1 _3898_/X _3880_/A VPWR VGND sg13cmos5l_a21oi_1
X_5638_ _5638_/Q _5860_/CLK _5638_/D _5638_/RESET_B VPWR VGND sg13cmos5l_dfrbpq_1
X_5569_ _5569_/Q _5906_/CLK _5569_/D _5569_/RESET_B VPWR VGND sg13cmos5l_dfrbpq_1
X_5899__473 _5899_/RESET_B VPWR VGND sg13cmos5l_tiehi
XFILLER_19_707 VPWR VGND sg13cmos5l_fill_2
XFILLER_18_1007 VPWR VGND sg13cmos5l_decap_8
XFILLER_30_905 VPWR VGND sg13cmos5l_fill_2
XFILLER_10_673 VPWR VGND sg13cmos5l_fill_2
X_5954__412 _5954_/RESET_B VPWR VGND sg13cmos5l_tiehi
X_4940_ _4951_/B _5984_/Q _5983_/Q _5982_/Q VPWR VGND sg13cmos5l_or3_1
X_4871_ _4871_/X _4871_/A _4880_/A _4871_/C VPWR VGND sg13cmos5l_or3_1
X_3822_ _5837_/D _5428_/A _3822_/B VPWR VGND sg13cmos5l_nor2_1
XFILLER_20_448 VPWR VGND sg13cmos5l_decap_8
X_5961__405 _5961_/RESET_B VPWR VGND sg13cmos5l_tiehi
X_3753_ _3753_/Y _5734_/Q _3753_/B VPWR VGND sg13cmos5l_nand2b_1
X_3684_ _3684_/Y input4/X _3684_/A2 _5304_/C VPWR VGND sg13cmos5l_o21ai_1
X_5423_ _5548_/D _5423_/A0 _5423_/A1 _5423_/S VPWR VGND sg13cmos5l_mux2_1
X_5354_ _5485_/D _5354_/A0 _5354_/A1 _5360_/S VPWR VGND sg13cmos5l_mux2_1
X_4305_ _5901_/D _3076_/Y _5003_/A2 _4304_/Y VPWR VGND sg13cmos5l_a21oi_1
X_5285_ _5285_/Y _5290_/B _5432_/B _5285_/C VPWR VGND sg13cmos5l_nand3b_1
X_4236_ _4236_/Y _4229_/Y _4250_/B _4233_/Y _4235_/Y VPWR VGND sg13cmos5l_a22oi_1
X_4167_ _4167_/Y _5886_/Q _5883_/Q VPWR VGND sg13cmos5l_nor2b_1
X_3118_ _3118_/Y _5447_/Q VPWR VGND sg13cmos5l_inv_1
X_4098_ _4098_/Y _4098_/A1 _4097_/X _4065_/A VPWR VGND sg13cmos5l_a21oi_1
XFILLER_11_404 VPWR VGND sg13cmos5l_fill_2
XFILLER_12_938 VPWR VGND sg13cmos5l_decap_8
XFILLER_24_765 VPWR VGND sg13cmos5l_fill_1
XFILLER_20_982 VPWR VGND sg13cmos5l_fill_2
XFILLER_2_168 VPWR VGND sg13cmos5l_fill_2
X_5504__548 _5504_/RESET_B VPWR VGND sg13cmos5l_tiehi
XFILLER_47_879 VPWR VGND sg13cmos5l_fill_1
XFILLER_34_529 VPWR VGND sg13cmos5l_fill_2
Xfanout90 _3720_/A _3138_/Y VPWR VGND sg13cmos5l_buf_1
XFILLER_7_931 VPWR VGND sg13cmos5l_fill_2
XFILLER_7_920 VPWR VGND sg13cmos5l_fill_1
XFILLER_10_492 VPWR VGND sg13cmos5l_fill_2
XFILLER_6_485 VPWR VGND sg13cmos5l_fill_2
XFILLER_2_680 VPWR VGND sg13cmos5l_fill_1
X_5070_ _5071_/C _5070_/A _5069_/A VPWR VGND sg13cmos5l_nor2b_1
X_4021_ _4021_/Y _4022_/B _3120_/Y _4020_/Y VPWR VGND sg13cmos5l_a21oi_1
Xhold1609 _3098_/A _5884_/Q VPWR VGND sg13cmos5l_dlygate4sd3_1
X_5972_ _5972_/Q _5973_/CLK _5972_/D _5972_/RESET_B VPWR VGND sg13cmos5l_dfrbpq_1
X_4923_ _4923_/Y _5173_/A _4932_/B VPWR VGND sg13cmos5l_nand2_1
X_4854_ _4871_/A _4870_/A _4870_/B _4870_/C VPWR VGND sg13cmos5l_a21oi_1
X_3805_ _3805_/Y _3800_/Y _3804_/Y _3220_/C VPWR VGND sg13cmos5l_o21ai_1
XFILLER_21_779 VPWR VGND sg13cmos5l_fill_1
X_4785_ _4785_/Y _4785_/A _5956_/Q VPWR VGND sg13cmos5l_nor2b_1
X_3736_ _3736_/Y _3736_/A1 _3734_/X _3720_/A VPWR VGND sg13cmos5l_o21ai_1
X_3667_ _3667_/X _5712_/Q _5706_/Q _3731_/S VPWR VGND sg13cmos5l_mux2_1
X_3598_ _3598_/Y _3598_/A _3605_/B VPWR VGND sg13cmos5l_nand2_1
X_5406_ _5532_/D _5406_/A0 _3215_/A _5408_/S VPWR VGND sg13cmos5l_mux2_1
X_5337_ _5470_/D _5337_/A0 _5356_/A0 _5341_/S VPWR VGND sg13cmos5l_mux2_1
X_5268_ _5269_/C _5270_/A _5270_/C _5248_/Y VPWR VGND sg13cmos5l_a21oi_1
XFILLER_47_109 VPWR VGND sg13cmos5l_fill_2
X_4219_ _4221_/B _4219_/A _4207_/C VPWR VGND sg13cmos5l_nor2b_1
X_5199_ _5199_/X _5199_/A _5199_/B VPWR VGND sg13cmos5l_xor2_1
XFILLER_16_529 VPWR VGND sg13cmos5l_fill_1
XFILLER_43_359 VPWR VGND sg13cmos5l_fill_2
XFILLER_24_573 VPWR VGND sg13cmos5l_fill_2
XFILLER_12_746 VPWR VGND sg13cmos5l_fill_2
X_5944__422 _5944_/RESET_B VPWR VGND sg13cmos5l_tiehi
XFILLER_38_109 VPWR VGND sg13cmos5l_fill_2
X_5951__415 _5951_/RESET_B VPWR VGND sg13cmos5l_tiehi
XFILLER_30_587 VPWR VGND sg13cmos5l_fill_2
X_4570_ _4571_/B _4570_/A VPWR VGND sg13cmos5l_inv_1
X_3521_ _3528_/B _3569_/B _3793_/A _3557_/C VPWR VGND sg13cmos5l_nand3_1
X_3452_ _3452_/Y _3452_/A _3452_/B VPWR VGND sg13cmos5l_nor2_1
X_3383_ _5683_/D _3115_/Y _3387_/S _3382_/Y VPWR VGND sg13cmos5l_o21ai_1
XFILLER_41_2 VPWR VGND sg13cmos5l_fill_1
X_5122_ _5122_/Y _5122_/A _5122_/B VPWR VGND sg13cmos5l_nor2_1
XFILLER_27_0 VPWR VGND sg13cmos5l_fill_2
Xhold1406 _5313_/A1 _5449_/Q VPWR VGND sg13cmos5l_dlygate4sd3_1
X_5053_ _5070_/A _5053_/A _5053_/B VPWR VGND sg13cmos5l_nand2_1
Xhold1428 _3319_/A0 _5629_/Q VPWR VGND sg13cmos5l_dlygate4sd3_1
Xhold1439 _3278_/A0 _5593_/Q VPWR VGND sg13cmos5l_dlygate4sd3_1
Xhold1417 _5358_/A1 _5489_/Q VPWR VGND sg13cmos5l_dlygate4sd3_1
X_4004_ _4005_/B _5555_/Q _5538_/Q _5521_/Q _5504_/Q _4100_/S0 _4100_/S1 VPWR VGND
+ sg13cmos5l_mux4_1
XFILLER_19_890 VPWR VGND sg13cmos5l_fill_1
X_5955_ _5955_/Q _6007_/CLK _5955_/D _5955_/RESET_B VPWR VGND sg13cmos5l_dfrbpq_1
X_4906_ _4907_/B _6036_/Q _6009_/Q VPWR VGND sg13cmos5l_nand2_1
X_5886_ _5886_/Q _5936_/CLK _5886_/D _5886_/RESET_B VPWR VGND sg13cmos5l_dfrbpq_1
X_4837_ _4837_/Y _4745_/B _4778_/B _4872_/A _4749_/B VPWR VGND sg13cmos5l_a22oi_1
X_5828__573 _5828_/RESET_B VPWR VGND sg13cmos5l_tiehi
X_4768_ _4774_/B _4757_/Y _4765_/Y _4767_/Y VPWR VGND sg13cmos5l_o21ai_1
X_3719_ _3720_/C _3761_/B2 _3715_/X _3718_/Y VPWR VGND sg13cmos5l_a21oi_1
X_4699_ _4699_/Y _4679_/A _4676_/Y _4709_/A _4696_/Y VPWR VGND sg13cmos5l_a22oi_1
XFILLER_48_418 VPWR VGND sg13cmos5l_decap_8
XFILLER_0_447 VPWR VGND sg13cmos5l_fill_1
XFILLER_29_99 VPWR VGND sg13cmos5l_fill_1
XFILLER_44_657 VPWR VGND sg13cmos5l_decap_4
X_5534__338 _5534_/RESET_B VPWR VGND sg13cmos5l_tiehi
XFILLER_31_329 VPWR VGND sg13cmos5l_fill_1
XFILLER_12_543 VPWR VGND sg13cmos5l_fill_1
X_5807__613 _5807_/RESET_B VPWR VGND sg13cmos5l_tiehi
XFILLER_4_786 VPWR VGND sg13cmos5l_fill_1
XFILLER_3_252 VPWR VGND sg13cmos5l_fill_1
XFILLER_0_970 VPWR VGND sg13cmos5l_decap_8
XFILLER_39_429 VPWR VGND sg13cmos5l_fill_2
XFILLER_48_985 VPWR VGND sg13cmos5l_decap_8
XFILLER_47_462 VPWR VGND sg13cmos5l_decap_8
X_5740_ _5740_/Q _5825_/CLK _5740_/D _5740_/RESET_B VPWR VGND sg13cmos5l_dfrbpq_1
XFILLER_15_381 VPWR VGND sg13cmos5l_fill_2
XFILLER_15_392 VPWR VGND sg13cmos5l_decap_4
XFILLER_31_852 VPWR VGND sg13cmos5l_decap_8
XFILLER_31_863 VPWR VGND sg13cmos5l_fill_2
X_5671_ _5671_/Q _5840_/CLK _5671_/D _5671_/RESET_B VPWR VGND sg13cmos5l_dfrbpq_1
X_4622_ _4622_/X _5924_/Q _4622_/B VPWR VGND sg13cmos5l_and2_1
X_4553_ _4562_/A _4545_/X _4548_/X _4551_/Y VPWR VGND sg13cmos5l_o21ai_1
X_4484_ _4507_/A _4421_/Y _4387_/B _4502_/S VPWR VGND sg13cmos5l_mux2_1
X_3504_ _5745_/D _3440_/A _3504_/A1 _3505_/B VPWR VGND sg13cmos5l_mux2_1
X_3435_ _5712_/D _5158_/A1 _3440_/B _3434_/Y VPWR VGND sg13cmos5l_a21oi_1
X_3366_ _3376_/S _5409_/B _3389_/A _3398_/D VPWR VGND sg13cmos5l_nand3_1
Xhold1203 _5350_/A0 _5482_/Q VPWR VGND sg13cmos5l_dlygate4sd3_1
X_5105_ _5120_/S _5097_/Y _5101_/Y _5122_/B VPWR VGND sg13cmos5l_a21o_1
Xhold1225 _5422_/A0 _5547_/Q VPWR VGND sg13cmos5l_dlygate4sd3_1
Xhold1214 _5346_/A0 _5478_/Q VPWR VGND sg13cmos5l_dlygate4sd3_1
X_3297_ _5610_/D _5302_/A _3297_/A1 _3297_/S VPWR VGND sg13cmos5l_mux2_1
Xhold1236 _5397_/A1 _5524_/Q VPWR VGND sg13cmos5l_dlygate4sd3_1
X_5036_ _5047_/A _5046_/A VPWR VGND sg13cmos5l_inv_1
Xhold1247 _3300_/A0 _5612_/Q VPWR VGND sg13cmos5l_dlygate4sd3_1
X_5934__432 _5934_/RESET_B VPWR VGND sg13cmos5l_tiehi
Xhold1258 _5326_/A0 _5460_/Q VPWR VGND sg13cmos5l_dlygate4sd3_1
Xhold1269 _3340_/A0 _5647_/Q VPWR VGND sg13cmos5l_dlygate4sd3_1
XFILLER_38_484 VPWR VGND sg13cmos5l_decap_8
X_5938_ _5938_/Q _5943_/CLK _5938_/D _5938_/RESET_B VPWR VGND sg13cmos5l_dfrbpq_1
XFILLER_15_46 VPWR VGND sg13cmos5l_fill_1
X_5869_ _5869_/Q _5936_/CLK _5869_/D _5869_/RESET_B VPWR VGND sg13cmos5l_dfrbpq_1
X_5941__425 _5941_/RESET_B VPWR VGND sg13cmos5l_tiehi
XFILLER_31_78 VPWR VGND sg13cmos5l_fill_2
XFILLER_49_716 VPWR VGND sg13cmos5l_decap_8
XFILLER_1_789 VPWR VGND sg13cmos5l_fill_1
XFILLER_29_473 VPWR VGND sg13cmos5l_fill_1
XFILLER_45_944 VPWR VGND sg13cmos5l_decap_8
XFILLER_16_112 VPWR VGND sg13cmos5l_fill_1
XFILLER_44_443 VPWR VGND sg13cmos5l_decap_8
XFILLER_16_134 VPWR VGND sg13cmos5l_fill_2
XFILLER_40_671 VPWR VGND sg13cmos5l_fill_2
X_3220_ _3220_/Y input3/X _3220_/B _3220_/C VPWR VGND sg13cmos5l_nand3_1
X_3151_ _4791_/B _5955_/Q VPWR VGND sg13cmos5l_inv_1
X_3082_ _4124_/A _3082_/A VPWR VGND sg13cmos5l_inv_1
XFILLER_36_944 VPWR VGND sg13cmos5l_fill_2
X_3984_ _3984_/Y _4109_/B _5498_/Q _3983_/Y VPWR VGND sg13cmos5l_o21ai_1
X_5723_ _5723_/Q _6074_/CLK _5723_/D _5723_/RESET_B VPWR VGND sg13cmos5l_dfrbpq_1
X_5654_ _5654_/Q _5860_/CLK _5654_/D _5654_/RESET_B VPWR VGND sg13cmos5l_dfrbpq_1
X_4605_ _4693_/B _4579_/Y _4600_/B _4400_/X VPWR VGND sg13cmos5l_a21oi_1
XFILLER_11_1002 VPWR VGND sg13cmos5l_decap_4
X_5585_ _5585_/Q clkload3/A _5585_/D _5585_/RESET_B VPWR VGND sg13cmos5l_dfrbpq_1
X_4536_ _4550_/B _5948_/Q _4539_/A VPWR VGND sg13cmos5l_xnor2_1
X_4467_ _5930_/D _3077_/Y _4471_/A2 _4466_/Y VPWR VGND sg13cmos5l_a21oi_1
X_4398_ _4398_/Y _4480_/A _4480_/B VPWR VGND sg13cmos5l_nand2_1
X_3418_ _3418_/Y _3418_/A _3418_/B VPWR VGND sg13cmos5l_nand2_1
Xhold1000 _3484_/A _5735_/Q VPWR VGND sg13cmos5l_dlygate4sd3_1
X_3349_ _5655_/D _3391_/A0 _3349_/A1 _3355_/S VPWR VGND sg13cmos5l_mux2_1
Xhold1033 _3478_/A _5732_/Q VPWR VGND sg13cmos5l_dlygate4sd3_1
Xhold1022 _5737_/D _3489_/Y VPWR VGND sg13cmos5l_dlygate4sd3_1
Xhold1011 _5705_/D _3419_/Y VPWR VGND sg13cmos5l_dlygate4sd3_1
Xhold1055 _3602_/A _5792_/Q VPWR VGND sg13cmos5l_dlygate4sd3_1
Xhold1066 _3490_/A _5738_/Q VPWR VGND sg13cmos5l_dlygate4sd3_1
Xhold1044 _3463_/A _5725_/Q VPWR VGND sg13cmos5l_dlygate4sd3_1
X_6068_ _6068_/Q _6077_/CLK _6068_/D _6068_/RESET_B VPWR VGND sg13cmos5l_dfrbpq_1
X_5019_ _5019_/Y _5232_/A _4938_/B _5053_/B VPWR VGND sg13cmos5l_o21ai_1
Xhold1088 _3534_/A _5759_/Q VPWR VGND sg13cmos5l_dlygate4sd3_1
Xhold1099 _5007_/B _5998_/Q VPWR VGND sg13cmos5l_dlygate4sd3_1
Xhold1077 _4315_/B _5879_/Q VPWR VGND sg13cmos5l_dlygate4sd3_1
XFILLER_42_903 VPWR VGND sg13cmos5l_fill_2
X_6049__949 _6049_/RESET_B VPWR VGND sg13cmos5l_tiehi
XFILLER_41_424 VPWR VGND sg13cmos5l_fill_2
XFILLER_41_479 VPWR VGND sg13cmos5l_decap_8
XFILLER_42_66 VPWR VGND sg13cmos5l_fill_2
XFILLER_21_170 VPWR VGND sg13cmos5l_decap_8
XFILLER_5_303 VPWR VGND sg13cmos5l_fill_2
XFILLER_10_855 VPWR VGND sg13cmos5l_fill_2
XFILLER_5_336 VPWR VGND sg13cmos5l_fill_2
X_5804__616 _5804_/RESET_B VPWR VGND sg13cmos5l_tiehi
XFILLER_5_369 VPWR VGND sg13cmos5l_fill_1
XFILLER_49_513 VPWR VGND sg13cmos5l_decap_8
XFILLER_40_490 VPWR VGND sg13cmos5l_decap_8
X_5370_ _5500_/D _5370_/A0 _5370_/A1 _5370_/S VPWR VGND sg13cmos5l_mux2_1
XFILLER_5_870 VPWR VGND sg13cmos5l_fill_1
X_4321_ _4346_/A _4328_/A _4321_/B VPWR VGND sg13cmos5l_and2_1
X_4252_ _5889_/D _4314_/B _4338_/B VPWR VGND sg13cmos5l_nor2_1
Xfanout109 _4785_/A hold1668/X VPWR VGND sg13cmos5l_buf_1
X_3203_ _3865_/B _3202_/Y _5274_/B VPWR VGND sg13cmos5l_nand2b_1
X_4183_ _4183_/Y _5874_/Q _4186_/A2 _4190_/A VPWR VGND sg13cmos5l_o21ai_1
X_3134_ _4977_/B _5988_/Q VPWR VGND sg13cmos5l_inv_1
X_3065_ _3065_/Y _6050_/Q VPWR VGND sg13cmos5l_inv_1
XFILLER_24_914 VPWR VGND sg13cmos5l_fill_2
XFILLER_23_457 VPWR VGND sg13cmos5l_decap_8
XFILLER_24_958 VPWR VGND sg13cmos5l_decap_8
X_3967_ _3967_/Y _3962_/Y _3965_/Y _3966_/Y VPWR VGND sg13cmos5l_o21ai_1
X_5706_ _5706_/Q _6047_/CLK _5706_/D _5706_/RESET_B VPWR VGND sg13cmos5l_dfrbpq_1
X_3898_ _3898_/X _5660_/Q _5643_/Q _3910_/B VPWR VGND sg13cmos5l_mux2_1
Xclkbuf_leaf_30_clk _5825_/CLK clkbuf_3_4__f_clk/X VPWR VGND sg13cmos5l_buf_8
X_5637_ _5637_/Q _5860_/CLK _5637_/D _5637_/RESET_B VPWR VGND sg13cmos5l_dfrbpq_1
X_5568_ _5568_/Q clkload4/A _5568_/D _5568_/RESET_B VPWR VGND sg13cmos5l_dfrbpq_1
X_4519_ _4521_/A _4519_/A _4522_/S VPWR VGND sg13cmos5l_nor2b_1
X_5499_ _5499_/Q _5559_/CLK _5499_/D _5499_/RESET_B VPWR VGND sg13cmos5l_dfrbpq_1
XFILLER_46_527 VPWR VGND sg13cmos5l_decap_8
XFILLER_26_240 VPWR VGND sg13cmos5l_decap_4
XFILLER_26_273 VPWR VGND sg13cmos5l_fill_1
XFILLER_42_755 VPWR VGND sg13cmos5l_decap_8
XFILLER_42_744 VPWR VGND sg13cmos5l_fill_2
XFILLER_15_958 VPWR VGND sg13cmos5l_decap_4
Xclkbuf_leaf_21_clk _6007_/CLK clkload0/A VPWR VGND sg13cmos5l_buf_8
XFILLER_5_166 VPWR VGND sg13cmos5l_fill_2
XFILLER_2_840 VPWR VGND sg13cmos5l_fill_1
XFILLER_49_387 VPWR VGND sg13cmos5l_decap_8
XFILLER_33_700 VPWR VGND sg13cmos5l_fill_2
X_4870_ _4871_/C _4870_/A _4870_/B _4870_/C VPWR VGND sg13cmos5l_and3_1
XFILLER_21_939 VPWR VGND sg13cmos5l_decap_8
X_3821_ _3822_/B _3824_/B _3824_/C VPWR VGND sg13cmos5l_xnor2_1
XFILLER_20_416 VPWR VGND sg13cmos5l_decap_8
Xclkbuf_leaf_12_clk _5695_/CLK clkbuf_leaf_6_clk/A VPWR VGND sg13cmos5l_buf_8
X_3752_ _3752_/X _3752_/A _3752_/B VPWR VGND sg13cmos5l_or2_1
X_3683_ _3683_/X input2/X _3411_/B _3682_/Y VPWR VGND sg13cmos5l_a21o_1
X_5422_ _5547_/D _5422_/A0 _3382_/A _5422_/S VPWR VGND sg13cmos5l_mux2_1
X_5353_ _5484_/D _5353_/A0 _5353_/A1 _5360_/S VPWR VGND sg13cmos5l_mux2_1
X_5998__362 _5998_/RESET_B VPWR VGND sg13cmos5l_tiehi
X_6074__839 _6074_/RESET_B VPWR VGND sg13cmos5l_tiehi
X_4304_ _4304_/Y _4304_/A1 _4304_/A2 _5432_/B VPWR VGND sg13cmos5l_o21ai_1
X_5284_ _5290_/B _5284_/A _5284_/B VPWR VGND sg13cmos5l_and2_1
X_4235_ _4235_/Y _4235_/A _4235_/B VPWR VGND sg13cmos5l_nand2_1
X_4166_ _4169_/C _5886_/Q _4161_/Y _4164_/Y _4165_/Y VPWR VGND sg13cmos5l_a22oi_1
X_3117_ _3117_/Y _3117_/A VPWR VGND sg13cmos5l_inv_1
X_4097_ _4097_/X _5593_/Q _5584_/Q _4097_/S VPWR VGND sg13cmos5l_mux2_1
X_4999_ _4999_/Y _4999_/A1 _5004_/A2 _4998_/A VPWR VGND sg13cmos5l_o21ai_1
X_5801__619 _5801_/RESET_B VPWR VGND sg13cmos5l_tiehi
X_5838__553 _5838_/RESET_B VPWR VGND sg13cmos5l_tiehi
XFILLER_34_519 VPWR VGND sg13cmos5l_fill_1
XFILLER_42_552 VPWR VGND sg13cmos5l_fill_1
XFILLER_30_747 VPWR VGND sg13cmos5l_fill_2
Xfanout91 _4009_/A _4065_/A VPWR VGND sg13cmos5l_buf_1
Xfanout80 _5071_/A _4896_/Y VPWR VGND sg13cmos5l_buf_1
XFILLER_9_1028 VPWR VGND sg13cmos5l_fill_1
X_4020_ _4020_/Y _4022_/B _5600_/Q _4024_/A1 VPWR VGND sg13cmos5l_o21ai_1
Xclkbuf_leaf_1_clk clkload1/A clkbuf_leaf_2_clk/A VPWR VGND sg13cmos5l_buf_8
XFILLER_49_173 VPWR VGND sg13cmos5l_fill_1
X_5971_ _5971_/Q _5994_/CLK _5971_/D _5971_/RESET_B VPWR VGND sg13cmos5l_dfrbpq_1
X_4922_ _4922_/Y _4924_/B _4924_/C VPWR VGND sg13cmos5l_nand2_1
X_4853_ _4870_/C _6001_/Q _4867_/B VPWR VGND sg13cmos5l_xnor2_1
X_3804_ _3804_/Y _3807_/B _3804_/B VPWR VGND sg13cmos5l_xnor2_1
X_4784_ _4784_/Y _5956_/Q _4785_/A VPWR VGND sg13cmos5l_nand2b_1
X_3735_ _3735_/Y _3736_/A1 _3726_/Y _3727_/Y _3728_/Y _3720_/A VPWR VGND sg13cmos5l_a221oi_1
X_3666_ _5809_/D _3724_/A _3089_/Y _3665_/Y VPWR VGND sg13cmos5l_a21oi_1
X_5405_ _5531_/D _5405_/A0 _5423_/A1 _5408_/S VPWR VGND sg13cmos5l_mux2_1
XFILLER_47_1012 VPWR VGND sg13cmos5l_decap_8
X_3597_ _5789_/D _3609_/A1 _3605_/B _3596_/Y VPWR VGND sg13cmos5l_o21ai_1
X_5336_ _5469_/D _5336_/A0 _5355_/A0 _5341_/S VPWR VGND sg13cmos5l_mux2_1
X_5267_ _5269_/B _5270_/A _5267_/B _5270_/C VPWR VGND sg13cmos5l_and3_1
X_4218_ _5883_/D _4218_/A _4218_/B VPWR VGND sg13cmos5l_nor2_1
X_5198_ _5199_/B _6057_/Q _5190_/B _5178_/Y VPWR VGND sg13cmos5l_a21oi_1
X_4149_ _4153_/B _4142_/Y _4147_/Y _4148_/Y VPWR VGND sg13cmos5l_o21ai_1
XFILLER_16_508 VPWR VGND sg13cmos5l_fill_2
XFILLER_24_541 VPWR VGND sg13cmos5l_decap_4
XFILLER_11_268 VPWR VGND sg13cmos5l_fill_2
Xclkload0 clkload0/X clkload0/A VPWR VGND sg13cmos5l_buf_8
XFILLER_35_828 VPWR VGND sg13cmos5l_decap_4
XFILLER_34_338 VPWR VGND sg13cmos5l_fill_1
XFILLER_15_585 VPWR VGND sg13cmos5l_fill_2
XFILLER_30_544 VPWR VGND sg13cmos5l_fill_2
XFILLER_11_780 VPWR VGND sg13cmos5l_fill_2
X_3520_ _3545_/C _3569_/B _3557_/C VPWR VGND sg13cmos5l_nand2_1
XFILLER_7_784 VPWR VGND sg13cmos5l_fill_1
X_3451_ _5719_/D _3501_/A1 _3452_/B _3450_/Y VPWR VGND sg13cmos5l_a21oi_1
X_3382_ _3382_/Y _3382_/A _3388_/S VPWR VGND sg13cmos5l_nand2_1
X_5121_ _6044_/D _5272_/A _5252_/A VPWR VGND sg13cmos5l_nor2_1
Xhold1407 _3394_/A1 _5692_/Q VPWR VGND sg13cmos5l_dlygate4sd3_1
Xhold1418 _3288_/A1 _5602_/Q VPWR VGND sg13cmos5l_dlygate4sd3_1
X_5052_ _5052_/Y _5041_/Y _5043_/Y _5047_/Y _5049_/X _5051_/Y VPWR VGND sg13cmos5l_a221oi_1
Xhold1429 _3227_/A1 _5555_/Q VPWR VGND sg13cmos5l_dlygate4sd3_1
X_4003_ _4014_/B _4003_/A _4003_/B _4003_/C VPWR VGND sg13cmos5l_nor3_1
XFILLER_25_316 VPWR VGND sg13cmos5l_fill_2
XFILLER_38_699 VPWR VGND sg13cmos5l_decap_4
XFILLER_34_872 VPWR VGND sg13cmos5l_decap_8
X_5954_ _5954_/Q _6005_/CLK _5954_/D _5954_/RESET_B VPWR VGND sg13cmos5l_dfrbpq_1
X_4905_ _4910_/A _4914_/B _4904_/B _5226_/A VPWR VGND sg13cmos5l_a21o_1
XFILLER_33_371 VPWR VGND sg13cmos5l_decap_8
X_5885_ _5885_/Q _5936_/CLK _5885_/D _5885_/RESET_B VPWR VGND sg13cmos5l_dfrbpq_1
XFILLER_40_319 VPWR VGND sg13cmos5l_decap_4
X_4836_ _4836_/X _4740_/A _4843_/A _4835_/Y VPWR VGND sg13cmos5l_a21o_1
XFILLER_14_1000 VPWR VGND sg13cmos5l_fill_1
X_4767_ _4767_/Y _4757_/A _4757_/B _4771_/B _4769_/A VPWR VGND sg13cmos5l_a22oi_1
X_3718_ _3718_/Y _3718_/A1 _3717_/Y _3139_/A VPWR VGND sg13cmos5l_o21ai_1
X_4698_ _4698_/Y _4709_/A _4696_/Y _4697_/Y VPWR VGND sg13cmos5l_o21ai_1
X_3649_ _3649_/X _5711_/Q _5705_/Q _3753_/B VPWR VGND sg13cmos5l_mux2_1
XFILLER_0_426 VPWR VGND sg13cmos5l_fill_2
X_5319_ _5454_/D _5319_/A0 _5298_/A _5322_/S VPWR VGND sg13cmos5l_mux2_1
XFILLER_28_121 VPWR VGND sg13cmos5l_fill_1
XFILLER_31_308 VPWR VGND sg13cmos5l_fill_1
XFILLER_24_360 VPWR VGND sg13cmos5l_fill_2
XFILLER_25_872 VPWR VGND sg13cmos5l_fill_1
XFILLER_12_522 VPWR VGND sg13cmos5l_fill_2
XFILLER_40_831 VPWR VGND sg13cmos5l_fill_2
XFILLER_4_776 VPWR VGND sg13cmos5l_fill_2
X_5597__823 _5597_/RESET_B VPWR VGND sg13cmos5l_tiehi
XFILLER_48_964 VPWR VGND sg13cmos5l_decap_8
XFILLER_47_441 VPWR VGND sg13cmos5l_decap_8
XFILLER_34_113 VPWR VGND sg13cmos5l_fill_1
XFILLER_37_1022 VPWR VGND sg13cmos5l_decap_8
X_5670_ _5670_/Q clkload4/A _5670_/D _5670_/RESET_B VPWR VGND sg13cmos5l_dfrbpq_1
X_4621_ _4621_/Y _4463_/A _4619_/X _4620_/Y _4615_/C VPWR VGND sg13cmos5l_a22oi_1
X_4552_ _4555_/A _4546_/Y _4547_/Y _4573_/B _4769_/A _4550_/Y VPWR VGND sg13cmos5l_a221oi_1
X_4483_ _4502_/S _4479_/Y _4481_/Y _4482_/Y VPWR VGND sg13cmos5l_o21ai_1
XFILLER_7_592 VPWR VGND sg13cmos5l_fill_2
X_3503_ _3503_/Y _5162_/A1 _3505_/B _3502_/Y VPWR VGND sg13cmos5l_o21ai_1
X_3434_ _3434_/Y _3434_/A _3440_/B VPWR VGND sg13cmos5l_nor2_1
X_3365_ _5670_/D _3365_/A0 _5408_/A1 _3365_/S VPWR VGND sg13cmos5l_mux2_1
Xhold1215 _3229_/A1 _5557_/Q VPWR VGND sg13cmos5l_dlygate4sd3_1
X_5104_ _5122_/B _5104_/A _5104_/B VPWR VGND sg13cmos5l_and2_1
Xhold1204 _3309_/A1 _5620_/Q VPWR VGND sg13cmos5l_dlygate4sd3_1
X_3296_ _5609_/D _3374_/A _3296_/A1 _3297_/S VPWR VGND sg13cmos5l_mux2_1
Xhold1248 _5311_/A1 _5447_/Q VPWR VGND sg13cmos5l_dlygate4sd3_1
X_5035_ _5046_/A _5035_/A _5035_/B VPWR VGND sg13cmos5l_nor2_1
Xhold1237 _3386_/A0 _5685_/Q VPWR VGND sg13cmos5l_dlygate4sd3_1
Xhold1226 _5364_/A0 _5494_/Q VPWR VGND sg13cmos5l_dlygate4sd3_1
Xhold1259 _3343_/A0 _5650_/Q VPWR VGND sg13cmos5l_dlygate4sd3_1
XFILLER_38_463 VPWR VGND sg13cmos5l_decap_8
XFILLER_39_975 VPWR VGND sg13cmos5l_fill_1
X_5937_ _5937_/Q _5994_/CLK _5937_/D _5937_/RESET_B VPWR VGND sg13cmos5l_dfrbpq_1
X_5868_ _5868_/Q _5894_/CLK _5868_/D _5868_/RESET_B VPWR VGND sg13cmos5l_dfrbpq_1
XFILLER_22_886 VPWR VGND sg13cmos5l_decap_8
X_5799_ _5799_/Q clkload7/A _5799_/D _5799_/RESET_B VPWR VGND sg13cmos5l_dfrbpq_1
X_4819_ _4819_/Y _5993_/Q _5172_/A2 _4998_/A VPWR VGND sg13cmos5l_o21ai_1
XFILLER_45_901 VPWR VGND sg13cmos5l_fill_2
XFILLER_45_923 VPWR VGND sg13cmos5l_decap_8
XFILLER_17_647 VPWR VGND sg13cmos5l_fill_1
XFILLER_29_496 VPWR VGND sg13cmos5l_fill_1
XFILLER_44_499 VPWR VGND sg13cmos5l_decap_8
XFILLER_12_330 VPWR VGND sg13cmos5l_fill_2
XFILLER_9_857 VPWR VGND sg13cmos5l_fill_1
XFILLER_8_378 VPWR VGND sg13cmos5l_fill_1
Xclkbuf_3_1__f_clk clkbuf_leaf_4_clk/A clkbuf_0_clk/X VPWR VGND sg13cmos5l_buf_8
X_3150_ _4618_/A _3150_/A VPWR VGND sg13cmos5l_inv_1
X_3081_ _3081_/Y _4125_/A VPWR VGND sg13cmos5l_inv_1
XFILLER_23_606 VPWR VGND sg13cmos5l_fill_1
XFILLER_23_639 VPWR VGND sg13cmos5l_fill_2
X_3983_ _3983_/Y _5481_/Q _4109_/B VPWR VGND sg13cmos5l_nand2b_1
X_5722_ _5722_/Q _6047_/CLK _5722_/D _5722_/RESET_B VPWR VGND sg13cmos5l_dfrbpq_1
X_5653_ _5653_/Q clkload4/A _5653_/D _5653_/RESET_B VPWR VGND sg13cmos5l_dfrbpq_1
X_5584_ _5584_/Q clkload6/A _5584_/D _5584_/RESET_B VPWR VGND sg13cmos5l_dfrbpq_1
XFILLER_30_193 VPWR VGND sg13cmos5l_fill_1
X_4604_ _5952_/D _4638_/A _4604_/B VPWR VGND sg13cmos5l_nor2_1
X_4535_ _4573_/A _4535_/A _4539_/A VPWR VGND sg13cmos5l_xor2_1
X_4466_ _4466_/Y _4642_/A1 _4471_/A2 _4818_/A VPWR VGND sg13cmos5l_o21ai_1
X_4397_ _4480_/B _4395_/A _4383_/Y _4396_/Y VPWR VGND sg13cmos5l_o21ai_1
X_3417_ _3417_/Y _5827_/Q _3569_/B _3417_/C _3793_/A VPWR VGND sg13cmos5l_nand4_1
X_3348_ _5654_/D _5315_/A1 _3348_/A1 _3355_/S VPWR VGND sg13cmos5l_mux2_1
Xhold1001 _5735_/D _3485_/Y VPWR VGND sg13cmos5l_dlygate4sd3_1
Xhold1012 _3465_/A _5726_/Q VPWR VGND sg13cmos5l_dlygate4sd3_1
Xhold1023 _4826_/B _5965_/Q VPWR VGND sg13cmos5l_dlygate4sd3_1
Xhold1045 _3505_/A _5746_/Q VPWR VGND sg13cmos5l_dlygate4sd3_1
Xhold1056 _5792_/D _3603_/Y VPWR VGND sg13cmos5l_dlygate4sd3_1
X_6067_ _6067_/Q _6067_/CLK _6067_/D _6067_/RESET_B VPWR VGND sg13cmos5l_dfrbpq_1
Xhold1067 _5738_/D _3491_/Y VPWR VGND sg13cmos5l_dlygate4sd3_1
X_3279_ _5594_/D _3279_/A0 _5408_/A1 _3279_/S VPWR VGND sg13cmos5l_mux2_1
Xhold1034 _3512_/A _5749_/Q VPWR VGND sg13cmos5l_dlygate4sd3_1
Xhold1078 _3114_/A _5575_/Q VPWR VGND sg13cmos5l_dlygate4sd3_1
X_5018_ _5018_/Y _4935_/B _5048_/A _5017_/Y VPWR VGND sg13cmos5l_o21ai_1
Xhold1089 _3552_/A _5768_/Q VPWR VGND sg13cmos5l_dlygate4sd3_1
XFILLER_27_923 VPWR VGND sg13cmos5l_decap_8
XFILLER_27_934 VPWR VGND sg13cmos5l_fill_2
XFILLER_27_945 VPWR VGND sg13cmos5l_fill_1
XFILLER_26_455 VPWR VGND sg13cmos5l_decap_8
XFILLER_42_948 VPWR VGND sg13cmos5l_fill_2
XFILLER_26_466 VPWR VGND sg13cmos5l_fill_1
XFILLER_41_458 VPWR VGND sg13cmos5l_decap_8
X_5587__833 _5587_/RESET_B VPWR VGND sg13cmos5l_tiehi
X_5477__602 _5477_/RESET_B VPWR VGND sg13cmos5l_tiehi
XFILLER_49_569 VPWR VGND sg13cmos5l_decap_8
X_5594__826 _5594_/RESET_B VPWR VGND sg13cmos5l_tiehi
XFILLER_36_219 VPWR VGND sg13cmos5l_fill_1
Xhold1590 _4758_/B1 _5952_/Q VPWR VGND sg13cmos5l_dlygate4sd3_1
XFILLER_33_926 VPWR VGND sg13cmos5l_decap_4
XFILLER_44_296 VPWR VGND sg13cmos5l_fill_1
XFILLER_41_981 VPWR VGND sg13cmos5l_decap_4
X_4320_ _4321_/B _5902_/Q _5879_/Q _5907_/Q VPWR VGND sg13cmos5l_nand3_1
X_5542__950 _5542_/RESET_B VPWR VGND sg13cmos5l_tiehi
X_4251_ _4338_/B _4239_/A _4241_/B _4423_/B _4247_/A _4250_/Y VPWR VGND sg13cmos5l_a221oi_1
X_3202_ _3202_/Y _6077_/Q _3199_/A _6078_/Q VPWR VGND sg13cmos5l_a21oi_1
XFILLER_41_1018 VPWR VGND sg13cmos5l_decap_8
X_4182_ _5873_/D _4190_/A _4182_/B VPWR VGND sg13cmos5l_and2_1
X_3133_ _4799_/A _5989_/Q VPWR VGND sg13cmos5l_inv_1
X_3064_ _3064_/Y _3064_/A VPWR VGND sg13cmos5l_inv_1
XFILLER_35_263 VPWR VGND sg13cmos5l_fill_1
X_3966_ _3966_/Y _3958_/Y _3960_/Y _3931_/A VPWR VGND sg13cmos5l_a21oi_1
X_5705_ _5705_/Q _6074_/CLK _5705_/D _5705_/RESET_B VPWR VGND sg13cmos5l_dfrbpq_1
X_3897_ _3897_/Y _3897_/A1 _5694_/Q _3896_/Y VPWR VGND sg13cmos5l_o21ai_1
X_5636_ _5636_/Q clkload3/A _5636_/D _5636_/RESET_B VPWR VGND sg13cmos5l_dfrbpq_1
XFILLER_31_491 VPWR VGND sg13cmos5l_fill_2
X_5567_ _5567_/Q clkload9/A _5567_/D _5567_/RESET_B VPWR VGND sg13cmos5l_dfrbpq_1
X_4518_ _5940_/D _4507_/B _4522_/S _4517_/Y VPWR VGND sg13cmos5l_a21oi_1
X_5498_ _5498_/Q _5559_/CLK _5498_/D _5498_/RESET_B VPWR VGND sg13cmos5l_dfrbpq_1
X_4449_ _4449_/Y _5925_/Q _4458_/A _4441_/Y VPWR VGND sg13cmos5l_o21ai_1
XFILLER_46_506 VPWR VGND sg13cmos5l_decap_8
XFILLER_27_720 VPWR VGND sg13cmos5l_fill_2
XFILLER_39_580 VPWR VGND sg13cmos5l_decap_8
XFILLER_15_937 VPWR VGND sg13cmos5l_decap_4
XFILLER_27_797 VPWR VGND sg13cmos5l_fill_1
XFILLER_30_907 VPWR VGND sg13cmos5l_fill_1
XFILLER_6_635 VPWR VGND sg13cmos5l_fill_1
XFILLER_6_624 VPWR VGND sg13cmos5l_fill_2
XFILLER_49_366 VPWR VGND sg13cmos5l_fill_1
XFILLER_49_344 VPWR VGND sg13cmos5l_fill_2
XFILLER_18_742 VPWR VGND sg13cmos5l_fill_2
XFILLER_45_572 VPWR VGND sg13cmos5l_decap_8
XFILLER_45_583 VPWR VGND sg13cmos5l_fill_2
XFILLER_32_211 VPWR VGND sg13cmos5l_fill_1
X_3820_ _3820_/Y _3163_/A _3818_/Y _3819_/Y VPWR VGND sg13cmos5l_a21oi_1
X_3751_ _3752_/B _5776_/Q _5770_/Q _3751_/S VPWR VGND sg13cmos5l_mux2_1
XFILLER_14_970 VPWR VGND sg13cmos5l_fill_2
XFILLER_9_440 VPWR VGND sg13cmos5l_fill_2
X_3682_ _3682_/Y input2/X _3682_/B _3682_/C VPWR VGND sg13cmos5l_nor3_1
X_5421_ _5546_/D _5421_/A0 _5421_/A1 _5423_/S VPWR VGND sg13cmos5l_mux2_1
X_5352_ _5360_/S _5352_/A _5352_/B _5352_/C _5352_/D VPWR VGND sg13cmos5l_nand4_1
XFILLER_5_690 VPWR VGND sg13cmos5l_fill_1
X_4303_ _5900_/D _3077_/Y _5003_/A2 _4302_/Y VPWR VGND sg13cmos5l_a21oi_1
X_5283_ _5283_/Y _3204_/Y _5283_/A2 _4131_/A VPWR VGND sg13cmos5l_a21oi_1
X_4234_ _4235_/B _5887_/Q _5888_/Q VPWR VGND sg13cmos5l_xnor2_1
X_4165_ _4165_/Y _5850_/Q _4314_/A _4162_/Y _4163_/Y _4143_/Y VPWR VGND sg13cmos5l_a221oi_1
X_3116_ _3116_/Y _3116_/A VPWR VGND sg13cmos5l_inv_1
X_4096_ _4096_/Y _4097_/S _5635_/Q _4095_/Y VPWR VGND sg13cmos5l_o21ai_1
XFILLER_11_406 VPWR VGND sg13cmos5l_fill_1
X_4998_ _6024_/D _4998_/A _4998_/B VPWR VGND sg13cmos5l_and2_1
X_3949_ _3949_/Y _5842_/Q _3949_/B _3949_/C VPWR VGND sg13cmos5l_nor3_1
X_5584__836 _5584_/RESET_B VPWR VGND sg13cmos5l_tiehi
X_5619_ _5619_/Q clkload3/A _5619_/D _5619_/RESET_B VPWR VGND sg13cmos5l_dfrbpq_1
X_5591__829 _5591_/RESET_B VPWR VGND sg13cmos5l_tiehi
XFILLER_14_211 VPWR VGND sg13cmos5l_fill_2
Xfanout92 _4065_/A _3111_/Y VPWR VGND sg13cmos5l_buf_1
Xfanout70 _5190_/B _5193_/B VPWR VGND sg13cmos5l_buf_1
Xfanout81 _4964_/A _4896_/Y VPWR VGND sg13cmos5l_buf_1
XFILLER_7_933 VPWR VGND sg13cmos5l_fill_1
XFILLER_10_494 VPWR VGND sg13cmos5l_fill_1
XFILLER_7_955 VPWR VGND sg13cmos5l_decap_8
X_5970_ _5970_/Q _5994_/CLK _5970_/D _5970_/RESET_B VPWR VGND sg13cmos5l_dfrbpq_1
X_4921_ _4924_/C _4910_/Y _4915_/Y _4919_/Y VPWR VGND sg13cmos5l_a21o_1
X_4852_ _4870_/B _5995_/Q _5966_/Q _6000_/Q VPWR VGND sg13cmos5l_nand3_1
XFILLER_33_564 VPWR VGND sg13cmos5l_fill_1
X_3803_ _3804_/B _3803_/A _3812_/D VPWR VGND sg13cmos5l_xnor2_1
X_4783_ _5985_/D _4783_/A _4877_/B VPWR VGND sg13cmos5l_and2_1
X_3734_ _3734_/X _5799_/Q _5793_/Q _3734_/S VPWR VGND sg13cmos5l_mux2_1
X_3665_ _3665_/Y _3663_/Y _3664_/Y _3744_/A VPWR VGND sg13cmos5l_o21ai_1
X_5404_ _5530_/D _5404_/A0 _3382_/A _5408_/S VPWR VGND sg13cmos5l_mux2_1
X_3596_ _3596_/Y _3596_/A _3605_/B VPWR VGND sg13cmos5l_nand2_1
X_5800__620 _5800_/RESET_B VPWR VGND sg13cmos5l_tiehi
X_5335_ _5468_/D _5335_/A0 _5354_/A0 _5341_/S VPWR VGND sg13cmos5l_mux2_1
X_5266_ _6063_/D _5266_/A _5266_/B _5266_/C VPWR VGND sg13cmos5l_nor3_1
X_4217_ _4218_/B _4208_/Y _4219_/A _4193_/B VPWR VGND sg13cmos5l_o21ai_1
X_5503__550 _5503_/RESET_B VPWR VGND sg13cmos5l_tiehi
X_5197_ _5270_/A _5251_/A _5197_/B VPWR VGND sg13cmos5l_nand2b_1
XFILLER_29_826 VPWR VGND sg13cmos5l_fill_1
XFILLER_18_36 VPWR VGND sg13cmos5l_fill_1
X_4148_ _4148_/Y _4148_/A _4148_/B VPWR VGND sg13cmos5l_xnor2_1
X_4079_ _4079_/X _5463_/Q _5446_/Q _4079_/S VPWR VGND sg13cmos5l_mux2_1
Xclkload1 clkload1/Y clkload1/A VPWR VGND sg13cmos5l_inv_1
XFILLER_20_770 VPWR VGND sg13cmos5l_fill_1
X_5510__532 _5510_/RESET_B VPWR VGND sg13cmos5l_tiehi
Xfanout260 _5006_/A _5166_/A VPWR VGND sg13cmos5l_buf_1
XFILLER_43_851 VPWR VGND sg13cmos5l_fill_2
XFILLER_30_589 VPWR VGND sg13cmos5l_fill_1
X_3450_ _3450_/Y _3450_/A _3452_/B VPWR VGND sg13cmos5l_nor2_1
X_5485__586 _5485_/RESET_B VPWR VGND sg13cmos5l_tiehi
X_3381_ _5682_/D _3381_/A0 _5421_/A1 _3388_/S VPWR VGND sg13cmos5l_mux2_1
X_5120_ _5252_/A _5089_/X _5119_/Y _5120_/S VPWR VGND sg13cmos5l_mux2_1
X_5995__366 _5995_/RESET_B VPWR VGND sg13cmos5l_tiehi
X_5522__469 _5522_/RESET_B VPWR VGND sg13cmos5l_tiehi
XFILLER_2_490 VPWR VGND sg13cmos5l_fill_2
X_5051_ _5051_/Y _5051_/A _5051_/B VPWR VGND sg13cmos5l_nor2_1
Xhold1408 _3359_/A0 _5664_/Q VPWR VGND sg13cmos5l_dlygate4sd3_1
Xhold1419 _5301_/A0 _5439_/Q VPWR VGND sg13cmos5l_dlygate4sd3_1
X_4002_ _4003_/C _4011_/A _3999_/Y _4001_/Y VPWR VGND sg13cmos5l_a21oi_1
XFILLER_38_623 VPWR VGND sg13cmos5l_fill_2
X_5953_ _5953_/Q _6005_/CLK _5953_/D _5953_/RESET_B VPWR VGND sg13cmos5l_dfrbpq_1
X_4904_ _4904_/X _4914_/B _4904_/B VPWR VGND sg13cmos5l_and2_1
X_5884_ _5884_/Q _5936_/CLK _5884_/D _5884_/RESET_B VPWR VGND sg13cmos5l_dfrbpq_1
X_4835_ _4835_/Y _4748_/S _4743_/Y _4777_/A _4777_/B _4742_/X VPWR VGND sg13cmos5l_a221oi_1
XFILLER_14_1023 VPWR VGND sg13cmos5l_decap_4
X_4766_ _4771_/B _5954_/Q _4766_/B VPWR VGND sg13cmos5l_xor2_1
X_3717_ _3717_/Y _3137_/Y _5726_/Q _3716_/X VPWR VGND sg13cmos5l_a21oi_1
X_4697_ _4697_/Y _4688_/X _4697_/B VPWR VGND sg13cmos5l_nand2b_1
X_3648_ _3648_/Y _3753_/B _5723_/Q _3647_/Y VPWR VGND sg13cmos5l_o21ai_1
X_3579_ _3579_/X _3591_/A _3579_/A1 _3580_/B VPWR VGND sg13cmos5l_mux2_1
XFILLER_1_939 VPWR VGND sg13cmos5l_decap_8
X_5318_ _5453_/D _5318_/A0 _5356_/A0 _5322_/S VPWR VGND sg13cmos5l_mux2_1
X_5249_ _5249_/Y _5264_/B _5249_/B _5249_/C VPWR VGND sg13cmos5l_nor3_1
XFILLER_21_1027 VPWR VGND sg13cmos5l_fill_2
XFILLER_29_634 VPWR VGND sg13cmos5l_fill_1
XFILLER_29_667 VPWR VGND sg13cmos5l_fill_1
XFILLER_45_45 VPWR VGND sg13cmos5l_fill_1
XFILLER_25_884 VPWR VGND sg13cmos5l_decap_4
XFILLER_25_895 VPWR VGND sg13cmos5l_decap_8
XFILLER_40_898 VPWR VGND sg13cmos5l_fill_2
XFILLER_48_943 VPWR VGND sg13cmos5l_decap_8
XFILLER_47_420 VPWR VGND sg13cmos5l_decap_8
XFILLER_47_497 VPWR VGND sg13cmos5l_decap_8
XFILLER_30_353 VPWR VGND sg13cmos5l_fill_1
X_4620_ _4620_/Y _4620_/A _4829_/A VPWR VGND sg13cmos5l_nor2b_1
X_6023__333 _6023_/RESET_B VPWR VGND sg13cmos5l_tiehi
X_4551_ _4551_/Y _4757_/A _4573_/A _4573_/B _4769_/A VPWR VGND sg13cmos5l_a22oi_1
X_4482_ _4482_/Y _4398_/Y _4427_/Y _4402_/Y VPWR VGND sg13cmos5l_a21oi_1
X_3502_ _3502_/Y _3502_/A _3505_/B VPWR VGND sg13cmos5l_nand2_1
X_3433_ _5711_/D _3509_/A1 _3442_/B _3432_/Y VPWR VGND sg13cmos5l_a21oi_1
XFILLER_44_1027 VPWR VGND sg13cmos5l_fill_2
X_5103_ _5104_/B _5103_/A _5103_/B VPWR VGND sg13cmos5l_nand2_1
X_3364_ _5669_/D _3364_/A0 _5398_/A0 _3364_/S VPWR VGND sg13cmos5l_mux2_1
XFILLER_32_0 VPWR VGND sg13cmos5l_fill_2
Xhold1216 _5418_/A0 _5543_/Q VPWR VGND sg13cmos5l_dlygate4sd3_1
Xhold1205 _4315_/A _5902_/Q VPWR VGND sg13cmos5l_dlygate4sd3_1
X_3295_ _5608_/D _3251_/A _3295_/A1 _3297_/S VPWR VGND sg13cmos5l_mux2_1
X_5034_ _5035_/B _6035_/Q _5059_/B _5059_/C _5033_/Y VPWR VGND sg13cmos5l_a22oi_1
Xhold1249 _5388_/A0 _5516_/Q VPWR VGND sg13cmos5l_dlygate4sd3_1
Xhold1238 _5354_/A1 _5485_/Q VPWR VGND sg13cmos5l_dlygate4sd3_1
Xhold1227 _5312_/A1 _5448_/Q VPWR VGND sg13cmos5l_dlygate4sd3_1
XFILLER_39_943 VPWR VGND sg13cmos5l_fill_2
XFILLER_26_637 VPWR VGND sg13cmos5l_fill_2
XFILLER_41_607 VPWR VGND sg13cmos5l_decap_4
XFILLER_15_37 VPWR VGND sg13cmos5l_fill_1
X_5533__340 _5533_/RESET_B VPWR VGND sg13cmos5l_tiehi
X_5936_ _5936_/Q _5936_/CLK _5936_/D _5936_/RESET_B VPWR VGND sg13cmos5l_dfrbpq_1
XFILLER_34_692 VPWR VGND sg13cmos5l_fill_2
X_5867_ _5867_/Q _5894_/CLK _5867_/D _5867_/RESET_B VPWR VGND sg13cmos5l_dfrbpq_1
XFILLER_22_865 VPWR VGND sg13cmos5l_fill_1
X_5798_ _5798_/Q _5825_/CLK _5798_/D _5798_/RESET_B VPWR VGND sg13cmos5l_dfrbpq_1
XFILLER_21_375 VPWR VGND sg13cmos5l_fill_2
X_4818_ _5992_/D _4818_/A _4818_/B VPWR VGND sg13cmos5l_and2_1
X_4749_ _5979_/D _4829_/B _4749_/B VPWR VGND sg13cmos5l_and2_1
Xoutput14 uo_out[0] _5809_/Q VPWR VGND sg13cmos5l_buf_1
XFILLER_5_1021 VPWR VGND sg13cmos5l_decap_8
XFILLER_29_453 VPWR VGND sg13cmos5l_decap_8
XFILLER_45_979 VPWR VGND sg13cmos5l_decap_8
XFILLER_44_478 VPWR VGND sg13cmos5l_decap_8
XFILLER_32_618 VPWR VGND sg13cmos5l_fill_2
XFILLER_32_629 VPWR VGND sg13cmos5l_fill_2
XFILLER_9_814 VPWR VGND sg13cmos5l_fill_2
XFILLER_4_574 VPWR VGND sg13cmos5l_fill_2
X_3080_ _4445_/B _4289_/A VPWR VGND sg13cmos5l_inv_1
X_3982_ _3982_/Y _4109_/B _3118_/Y _3981_/Y VPWR VGND sg13cmos5l_a21oi_1
XFILLER_35_478 VPWR VGND sg13cmos5l_decap_4
X_5721_ _5721_/Q _6047_/CLK _5721_/D _5721_/RESET_B VPWR VGND sg13cmos5l_dfrbpq_1
XFILLER_31_651 VPWR VGND sg13cmos5l_fill_1
X_5652_ _5652_/Q clkload9/A _5652_/D _5652_/RESET_B VPWR VGND sg13cmos5l_dfrbpq_1
X_4603_ _4604_/B _4395_/B _4582_/X _4603_/S VPWR VGND sg13cmos5l_mux2_1
X_5583_ _5583_/Q clkload5/A _5583_/D _5583_/RESET_B VPWR VGND sg13cmos5l_dfrbpq_1
X_4534_ _4549_/B _5946_/Q _5945_/Q _5947_/Q _5948_/Q VPWR VGND sg13cmos5l_nor4_1
XFILLER_8_880 VPWR VGND sg13cmos5l_fill_2
XFILLER_11_1026 VPWR VGND sg13cmos5l_fill_2
X_4465_ _5929_/D _4818_/A _4465_/B VPWR VGND sg13cmos5l_and2_1
X_4396_ _4396_/Y _4396_/A _4396_/B VPWR VGND sg13cmos5l_nor2_1
X_3416_ _3796_/B _3569_/B _3793_/A VPWR VGND sg13cmos5l_nand2_1
X_3347_ _3355_/S _3389_/A _5390_/C _3398_/D VPWR VGND sg13cmos5l_nand3_1
X_6066_ _6066_/Q _6067_/CLK _6066_/D _6066_/RESET_B VPWR VGND sg13cmos5l_dfrbpq_1
Xhold1002 _3508_/A _5747_/Q VPWR VGND sg13cmos5l_dlygate4sd3_1
Xhold1013 _3466_/B1 _3465_/Y VPWR VGND sg13cmos5l_dlygate4sd3_1
Xhold1024 _3459_/A _5723_/Q VPWR VGND sg13cmos5l_dlygate4sd3_1
Xhold1046 _5746_/D _3506_/Y VPWR VGND sg13cmos5l_dlygate4sd3_1
Xhold1057 _3587_/A _5785_/Q VPWR VGND sg13cmos5l_dlygate4sd3_1
Xhold1035 _5749_/D _3513_/Y VPWR VGND sg13cmos5l_dlygate4sd3_1
X_5017_ _5017_/Y _5053_/B _5053_/A VPWR VGND sg13cmos5l_nand2b_1
X_3278_ _5593_/D _3278_/A0 _5322_/A1 _3278_/S VPWR VGND sg13cmos5l_mux2_1
Xhold1079 _3120_/A _5574_/Q VPWR VGND sg13cmos5l_dlygate4sd3_1
Xhold1068 _3593_/A _5788_/Q VPWR VGND sg13cmos5l_dlygate4sd3_1
XFILLER_27_968 VPWR VGND sg13cmos5l_decap_8
XFILLER_14_607 VPWR VGND sg13cmos5l_fill_2
XFILLER_41_426 VPWR VGND sg13cmos5l_fill_1
X_5919_ _5919_/Q _5943_/CLK _5919_/D _5919_/RESET_B VPWR VGND sg13cmos5l_dfrbpq_1
XFILLER_1_566 VPWR VGND sg13cmos5l_fill_1
XFILLER_49_548 VPWR VGND sg13cmos5l_decap_8
XFILLER_1_599 VPWR VGND sg13cmos5l_fill_1
XFILLER_45_721 VPWR VGND sg13cmos5l_fill_2
Xhold1580 _4460_/B _4459_/Y VPWR VGND sg13cmos5l_dlygate4sd3_1
XFILLER_18_946 VPWR VGND sg13cmos5l_decap_8
XFILLER_45_743 VPWR VGND sg13cmos5l_fill_1
XFILLER_17_445 VPWR VGND sg13cmos5l_fill_2
Xhold1591 _4205_/A _5882_/Q VPWR VGND sg13cmos5l_dlygate4sd3_1
XFILLER_9_633 VPWR VGND sg13cmos5l_fill_2
XFILLER_8_121 VPWR VGND sg13cmos5l_fill_1
X_4250_ _4250_/Y _4250_/A _4250_/B VPWR VGND sg13cmos5l_nor2_1
X_4181_ _5871_/D _4221_/A _4181_/B VPWR VGND sg13cmos5l_nor2_1
X_3201_ _6077_/D _5278_/A _3201_/B VPWR VGND sg13cmos5l_nor2_1
X_3132_ _3132_/Y _5990_/Q VPWR VGND sg13cmos5l_inv_1
X_3063_ _3063_/Y _3063_/A VPWR VGND sg13cmos5l_inv_1
X_5931__437 _5931_/RESET_B VPWR VGND sg13cmos5l_tiehi
XFILLER_24_916 VPWR VGND sg13cmos5l_fill_1
XFILLER_36_787 VPWR VGND sg13cmos5l_fill_2
X_6048__951 _6048_/RESET_B VPWR VGND sg13cmos5l_tiehi
X_3965_ _3965_/Y _4091_/A1 _3964_/Y _4067_/A VPWR VGND sg13cmos5l_o21ai_1
X_3896_ _3896_/Y _3897_/A1 _3113_/Y _4031_/A1 VPWR VGND sg13cmos5l_a21oi_1
X_5704_ _5704_/Q clkload3/A _5704_/D _5704_/RESET_B VPWR VGND sg13cmos5l_dfrbpq_1
XFILLER_12_16 VPWR VGND sg13cmos5l_fill_1
X_5635_ _5635_/Q _5840_/CLK _5635_/D _5635_/RESET_B VPWR VGND sg13cmos5l_dfrbpq_1
X_5566_ _5566_/Q clkload2/A _5566_/D _5566_/RESET_B VPWR VGND sg13cmos5l_dfrbpq_1
X_4517_ _4517_/Y _4507_/A _4522_/S _4475_/B VPWR VGND sg13cmos5l_o21ai_1
X_5497_ _5497_/Q _5559_/CLK _5497_/D _5497_/RESET_B VPWR VGND sg13cmos5l_dfrbpq_1
X_4448_ _4448_/Y _5925_/Q _4458_/A _4455_/A _4456_/A1 VPWR VGND sg13cmos5l_a22oi_1
X_4379_ _4396_/B _5918_/Q _4379_/B VPWR VGND sg13cmos5l_xor2_1
XFILLER_2_1013 VPWR VGND sg13cmos5l_decap_8
X_6049_ _6049_/Q _6063_/CLK _6049_/D _6049_/RESET_B VPWR VGND sg13cmos5l_dfrbpq_1
XFILLER_39_592 VPWR VGND sg13cmos5l_decap_8
XFILLER_23_993 VPWR VGND sg13cmos5l_decap_4
XFILLER_2_831 VPWR VGND sg13cmos5l_decap_8
XFILLER_49_301 VPWR VGND sg13cmos5l_fill_2
X_5815__599 _5815_/RESET_B VPWR VGND sg13cmos5l_tiehi
X_3750_ _3750_/Y _3751_/S _5764_/Q _3749_/Y VPWR VGND sg13cmos5l_o21ai_1
XFILLER_14_982 VPWR VGND sg13cmos5l_fill_2
X_3681_ _3682_/C _5807_/Q _3681_/B _3681_/C VPWR VGND sg13cmos5l_nor3_1
X_5420_ _5545_/D _5420_/A0 _5420_/A1 _5423_/S VPWR VGND sg13cmos5l_mux2_1
X_5351_ _5483_/D _5351_/A0 _5370_/A1 _5351_/S VPWR VGND sg13cmos5l_mux2_1
X_5282_ _5282_/Y _3191_/A _5279_/C _3185_/A VPWR VGND sg13cmos5l_a21oi_1
X_4302_ _4302_/Y _4302_/A1 _4304_/A2 _4818_/A VPWR VGND sg13cmos5l_o21ai_1
X_4233_ _4233_/Y _5888_/Q _4235_/A _4247_/A VPWR VGND sg13cmos5l_o21ai_1
X_4164_ _4164_/Y _5849_/Q _5884_/Q VPWR VGND sg13cmos5l_nand2b_1
X_3115_ _3115_/Y _3115_/A VPWR VGND sg13cmos5l_inv_1
X_4095_ _4095_/Y _5618_/Q _4097_/S VPWR VGND sg13cmos5l_nand2b_1
XFILLER_28_518 VPWR VGND sg13cmos5l_fill_1
X_5495__566 _5495_/RESET_B VPWR VGND sg13cmos5l_tiehi
XFILLER_36_540 VPWR VGND sg13cmos5l_fill_1
XFILLER_36_573 VPWR VGND sg13cmos5l_fill_2
X_4997_ _4997_/Y _4986_/B _4997_/A2 _4896_/Y VPWR VGND sg13cmos5l_a21oi_1
X_3948_ _3949_/C _3945_/X _3946_/Y _3947_/Y VPWR VGND sg13cmos5l_a21oi_1
X_3879_ _3880_/B _5690_/Q _5673_/Q _5656_/Q _5639_/Q _4045_/B _4049_/A1 VPWR VGND
+ sg13cmos5l_mux4_1
X_5618_ _5618_/Q clkload5/A _5618_/D _5618_/RESET_B VPWR VGND sg13cmos5l_dfrbpq_1
X_5549_ _5549_/Q clkload2/A _5549_/D _5549_/RESET_B VPWR VGND sg13cmos5l_dfrbpq_1
XFILLER_2_116 VPWR VGND sg13cmos5l_fill_2
XFILLER_24_1025 VPWR VGND sg13cmos5l_decap_4
XFILLER_46_304 VPWR VGND sg13cmos5l_fill_2
XFILLER_15_702 VPWR VGND sg13cmos5l_decap_8
XFILLER_9_17 VPWR VGND sg13cmos5l_fill_2
XFILLER_11_952 VPWR VGND sg13cmos5l_fill_2
Xfanout82 _4892_/A _4781_/A VPWR VGND sg13cmos5l_buf_1
Xfanout71 _5059_/B _5042_/B VPWR VGND sg13cmos5l_buf_1
Xfanout60 _3279_/S _3278_/S VPWR VGND sg13cmos5l_buf_1
Xfanout93 _3509_/A1 _5141_/A VPWR VGND sg13cmos5l_buf_1
XFILLER_11_963 VPWR VGND sg13cmos5l_fill_2
XFILLER_11_974 VPWR VGND sg13cmos5l_fill_2
X_6008__286 _6008_/D VPWR VGND sg13cmos5l_tielo
X_4920_ _4928_/C _4910_/Y _4915_/Y _4919_/Y VPWR VGND sg13cmos5l_a21oi_1
X_4851_ _4870_/A _5999_/Q _4867_/B VPWR VGND sg13cmos5l_nand2_1
X_3802_ _5828_/D _3807_/B _3800_/Y _3801_/Y VPWR VGND sg13cmos5l_a21oi_1
X_4782_ _4877_/B _4757_/B _4771_/B _4572_/Y VPWR VGND sg13cmos5l_o21ai_1
X_3733_ _3733_/Y _3734_/S _5781_/Q _3732_/Y VPWR VGND sg13cmos5l_a21oi_1
X_3664_ _3664_/Y _3220_/B _3767_/B input4/X VPWR VGND sg13cmos5l_o21ai_1
X_5403_ _5529_/D _5403_/A0 _5421_/A1 _5408_/S VPWR VGND sg13cmos5l_mux2_1
X_3595_ _3602_/B _3595_/A _3607_/B VPWR VGND sg13cmos5l_nand2_1
X_5334_ _5467_/D _5334_/A0 _5353_/A0 _5341_/S VPWR VGND sg13cmos5l_mux2_1
X_5265_ _5266_/C _5113_/X _5247_/S _5270_/C _5270_/A _5249_/B VPWR VGND sg13cmos5l_a221oi_1
X_5896__479 _5896_/RESET_B VPWR VGND sg13cmos5l_tiehi
X_5196_ _5196_/Y _5197_/B VPWR VGND sg13cmos5l_inv_1
X_4216_ _4218_/A _4216_/A _4219_/A VPWR VGND sg13cmos5l_nor2b_1
X_4147_ _4147_/Y _4261_/A _4138_/A _4265_/A VPWR VGND sg13cmos5l_o21ai_1
X_4078_ _4078_/Y _4079_/S _5497_/Q _4077_/Y VPWR VGND sg13cmos5l_o21ai_1
X_5590__830 _5590_/RESET_B VPWR VGND sg13cmos5l_tiehi
XFILLER_24_521 VPWR VGND sg13cmos5l_fill_1
Xclkload2 clkload2/Y clkload2/A VPWR VGND sg13cmos5l_inv_1
X_5699__721 _5699_/RESET_B VPWR VGND sg13cmos5l_tiehi
XFILLER_1_4 VPWR VGND sg13cmos5l_fill_2
Xfanout250 _4190_/A _5432_/B VPWR VGND sg13cmos5l_buf_1
XFILLER_47_602 VPWR VGND sg13cmos5l_decap_4
Xfanout261 _5166_/A input1/X VPWR VGND sg13cmos5l_buf_1
XFILLER_43_830 VPWR VGND sg13cmos5l_decap_4
X_3380_ _5681_/D _3380_/A0 _5420_/A1 _3388_/S VPWR VGND sg13cmos5l_mux2_1
XFILLER_3_981 VPWR VGND sg13cmos5l_decap_8
X_5050_ _5050_/Y _4935_/B _5048_/B _5048_/Y VPWR VGND sg13cmos5l_a21oi_1
X_4001_ _4001_/Y _4011_/A _4000_/X _4041_/A VPWR VGND sg13cmos5l_o21ai_1
Xhold1409 _3290_/A1 _5603_/Q VPWR VGND sg13cmos5l_dlygate4sd3_1
XFILLER_25_318 VPWR VGND sg13cmos5l_fill_1
X_5952_ _5952_/Q _6005_/CLK _5952_/D _5952_/RESET_B VPWR VGND sg13cmos5l_dfrbpq_1
X_4903_ _4904_/B _6010_/Q _6009_/Q _6011_/Q VPWR VGND sg13cmos5l_o21ai_1
XFILLER_18_381 VPWR VGND sg13cmos5l_fill_1
X_5883_ _5883_/Q _5936_/CLK _5883_/D _5883_/RESET_B VPWR VGND sg13cmos5l_dfrbpq_1
X_4834_ _4864_/B _4877_/B _4877_/A VPWR VGND sg13cmos5l_nand2b_1
X_4765_ _4765_/Y _4759_/X _4764_/Y _4760_/X VPWR VGND sg13cmos5l_o21ai_1
X_3716_ _3716_/X _3745_/A _5720_/Q VPWR VGND sg13cmos5l_and2_1
X_4696_ _4696_/Y _4696_/A _4696_/B VPWR VGND sg13cmos5l_nand2_1
X_3647_ _3647_/Y _5717_/Q _3753_/B VPWR VGND sg13cmos5l_nand2b_1
X_3578_ _3578_/Y _3615_/A1 _3577_/B _3577_/Y VPWR VGND sg13cmos5l_o21ai_1
X_5317_ _5452_/D _5317_/A0 _5355_/A0 _5322_/S VPWR VGND sg13cmos5l_mux2_1
X_5248_ _5248_/Y _5248_/A VPWR VGND sg13cmos5l_inv_1
X_5179_ _5179_/Y _6055_/Q _6029_/Q VPWR VGND sg13cmos5l_xnor2_1
XFILLER_44_627 VPWR VGND sg13cmos5l_decap_8
XFILLER_24_362 VPWR VGND sg13cmos5l_fill_1
XFILLER_40_800 VPWR VGND sg13cmos5l_decap_4
XFILLER_40_833 VPWR VGND sg13cmos5l_fill_1
XFILLER_4_778 VPWR VGND sg13cmos5l_fill_1
XFILLER_48_922 VPWR VGND sg13cmos5l_decap_8
XFILLER_0_984 VPWR VGND sg13cmos5l_decap_8
XFILLER_19_80 VPWR VGND sg13cmos5l_fill_2
XFILLER_48_999 VPWR VGND sg13cmos5l_decap_8
XFILLER_47_476 VPWR VGND sg13cmos5l_decap_8
XFILLER_16_841 VPWR VGND sg13cmos5l_decap_4
XFILLER_16_874 VPWR VGND sg13cmos5l_decap_8
XFILLER_16_885 VPWR VGND sg13cmos5l_fill_1
X_5927__442 _5927_/RESET_B VPWR VGND sg13cmos5l_tiehi
X_4550_ _4550_/Y _4550_/A _4550_/B VPWR VGND sg13cmos5l_nor2_1
X_4481_ _4481_/Y _4392_/A _4425_/B _4480_/Y VPWR VGND sg13cmos5l_o21ai_1
XFILLER_7_594 VPWR VGND sg13cmos5l_fill_1
X_3501_ _5743_/D _3501_/A1 _3505_/B _3500_/Y VPWR VGND sg13cmos5l_o21ai_1
X_3432_ _3432_/Y _3432_/A _3442_/B VPWR VGND sg13cmos5l_nor2_1
X_3363_ _5668_/D _3363_/A0 _3215_/A _3365_/S VPWR VGND sg13cmos5l_mux2_1
XFILLER_44_1006 VPWR VGND sg13cmos5l_decap_8
X_5102_ _5104_/A _6046_/Q _5103_/B VPWR VGND sg13cmos5l_or2_1
X_3294_ _5607_/D _5357_/A0 _3294_/A1 _3297_/S VPWR VGND sg13cmos5l_mux2_1
Xhold1206 _3349_/A1 _5655_/Q VPWR VGND sg13cmos5l_dlygate4sd3_1
Xhold1217 _5398_/A1 _5525_/Q VPWR VGND sg13cmos5l_dlygate4sd3_1
X_5033_ _5033_/Y _6034_/Q _5059_/B VPWR VGND sg13cmos5l_nand2_1
Xhold1239 _3467_/A1 _5727_/Q VPWR VGND sg13cmos5l_dlygate4sd3_1
Xhold1228 _3367_/A1 _5671_/Q VPWR VGND sg13cmos5l_dlygate4sd3_1
XFILLER_39_955 VPWR VGND sg13cmos5l_decap_8
XFILLER_39_988 VPWR VGND sg13cmos5l_fill_2
XFILLER_38_498 VPWR VGND sg13cmos5l_decap_8
X_5935_ _5935_/Q _5994_/CLK _5935_/D _5935_/RESET_B VPWR VGND sg13cmos5l_dfrbpq_1
X_5866_ _5866_/Q _5894_/CLK _5866_/D _5866_/RESET_B VPWR VGND sg13cmos5l_dfrbpq_1
X_5689__731 _5689_/RESET_B VPWR VGND sg13cmos5l_tiehi
X_4817_ _4817_/Y _4805_/Y _4817_/A2 _4892_/A VPWR VGND sg13cmos5l_a21oi_1
X_5797_ _5797_/Q _5822_/CLK _5797_/D _5797_/RESET_B VPWR VGND sg13cmos5l_dfrbpq_1
X_4748_ _4749_/B _4746_/X _4747_/Y _4748_/S VPWR VGND sg13cmos5l_mux2_1
X_4679_ _4688_/B _4679_/A _4679_/B VPWR VGND sg13cmos5l_nor2_1
Xoutput15 uo_out[1] _5810_/Q VPWR VGND sg13cmos5l_buf_1
XFILLER_1_759 VPWR VGND sg13cmos5l_fill_1
X_5696__724 _5696_/RESET_B VPWR VGND sg13cmos5l_tiehi
XFILLER_5_1000 VPWR VGND sg13cmos5l_decap_8
XFILLER_29_410 VPWR VGND sg13cmos5l_fill_1
XFILLER_45_903 VPWR VGND sg13cmos5l_fill_1
XFILLER_45_958 VPWR VGND sg13cmos5l_decap_8
XFILLER_44_457 VPWR VGND sg13cmos5l_decap_8
XFILLER_12_332 VPWR VGND sg13cmos5l_fill_1
XFILLER_13_877 VPWR VGND sg13cmos5l_fill_2
XFILLER_8_325 VPWR VGND sg13cmos5l_fill_2
XFILLER_9_837 VPWR VGND sg13cmos5l_decap_8
X_3981_ _3981_/Y _4109_/B _5464_/Q _4111_/A1 VPWR VGND sg13cmos5l_o21ai_1
XFILLER_35_457 VPWR VGND sg13cmos5l_decap_8
X_5720_ _5720_/Q _6074_/CLK _5720_/D _5720_/RESET_B VPWR VGND sg13cmos5l_dfrbpq_1
XFILLER_22_118 VPWR VGND sg13cmos5l_fill_1
X_5651_ _5651_/Q clkload1/A _5651_/D _5651_/RESET_B VPWR VGND sg13cmos5l_dfrbpq_1
X_5582_ _5582_/Q clkload5/A _5582_/D _5582_/RESET_B VPWR VGND sg13cmos5l_dfrbpq_1
X_4602_ _5951_/D _4638_/A _4602_/B VPWR VGND sg13cmos5l_nor2_1
X_4533_ _4539_/A _5946_/Q _5945_/Q _5947_/Q VPWR VGND sg13cmos5l_or3_1
X_5825__579 _5825_/RESET_B VPWR VGND sg13cmos5l_tiehi
X_4464_ _4464_/Y _4450_/Y _4464_/A2 _4460_/A VPWR VGND sg13cmos5l_a21oi_1
X_4395_ _4480_/A _4395_/A _4395_/B VPWR VGND sg13cmos5l_or2_1
X_3415_ _3445_/C _3415_/A _3569_/B _3417_/C VPWR VGND sg13cmos5l_nand3_1
X_3346_ _5653_/D _3346_/A0 _3407_/A0 _3346_/S VPWR VGND sg13cmos5l_mux2_1
X_6065_ _6065_/Q _6067_/CLK _6065_/D _6065_/RESET_B VPWR VGND sg13cmos5l_dfrbpq_1
Xhold1014 _5726_/D _3466_/Y VPWR VGND sg13cmos5l_dlygate4sd3_1
Xhold1003 _3461_/A _5724_/Q VPWR VGND sg13cmos5l_dlygate4sd3_1
Xhold1047 _3486_/A _5736_/Q VPWR VGND sg13cmos5l_dlygate4sd3_1
Xhold1025 _3596_/A _5789_/Q VPWR VGND sg13cmos5l_dlygate4sd3_1
Xhold1036 _3585_/A _5784_/Q VPWR VGND sg13cmos5l_dlygate4sd3_1
Xhold1058 _3589_/A _5786_/Q VPWR VGND sg13cmos5l_dlygate4sd3_1
X_5016_ _5016_/Y _4935_/B _5048_/A _5013_/Y _5014_/X _5015_/Y VPWR VGND sg13cmos5l_a221oi_1
X_3277_ _5592_/D _3277_/A0 _5359_/A0 _3279_/S VPWR VGND sg13cmos5l_mux2_1
Xhold1069 _4827_/B _5966_/Q VPWR VGND sg13cmos5l_dlygate4sd3_1
XFILLER_39_785 VPWR VGND sg13cmos5l_fill_2
XFILLER_26_37 VPWR VGND sg13cmos5l_fill_2
X_5918_ _5918_/Q _5973_/CLK _5918_/D _5918_/RESET_B VPWR VGND sg13cmos5l_dfrbpq_1
Xclkbuf_leaf_33_clk _5834_/CLK clkbuf_3_4__f_clk/X VPWR VGND sg13cmos5l_buf_8
XFILLER_21_162 VPWR VGND sg13cmos5l_decap_4
X_5849_ _5849_/Q _5936_/CLK _5849_/D _5849_/RESET_B VPWR VGND sg13cmos5l_dfrbpq_1
XFILLER_10_847 VPWR VGND sg13cmos5l_fill_2
XFILLER_27_1001 VPWR VGND sg13cmos5l_fill_2
XFILLER_49_527 VPWR VGND sg13cmos5l_decap_8
X_5917__452 _5917_/RESET_B VPWR VGND sg13cmos5l_tiehi
Xhold1570 _3136_/A _5975_/Q VPWR VGND sg13cmos5l_dlygate4sd3_1
Xhold1581 _3722_/A2 _5812_/Q VPWR VGND sg13cmos5l_dlygate4sd3_1
Xhold1592 _4222_/A2 _4206_/B VPWR VGND sg13cmos5l_dlygate4sd3_1
XFILLER_44_254 VPWR VGND sg13cmos5l_fill_1
Xclkbuf_leaf_24_clk _6077_/CLK clkbuf_3_4__f_clk/X VPWR VGND sg13cmos5l_buf_8
XFILLER_32_449 VPWR VGND sg13cmos5l_decap_8
XFILLER_34_1027 VPWR VGND sg13cmos5l_fill_2
X_5924__445 _5924_/RESET_B VPWR VGND sg13cmos5l_tiehi
X_4180_ _4180_/Y _3127_/Y _3128_/A _4143_/Y VPWR VGND sg13cmos5l_a21oi_1
X_5679__741 _5679_/RESET_B VPWR VGND sg13cmos5l_tiehi
X_3200_ _3200_/Y _5274_/B _5277_/A hold962/X VPWR VGND sg13cmos5l_a21oi_1
X_3131_ _4816_/A _5991_/Q VPWR VGND sg13cmos5l_inv_1
X_3062_ _3062_/Y _3062_/A VPWR VGND sg13cmos5l_inv_1
XFILLER_48_593 VPWR VGND sg13cmos5l_decap_8
XFILLER_35_254 VPWR VGND sg13cmos5l_decap_8
X_3964_ _3964_/Y _4089_/B _5632_/Q _3963_/Y VPWR VGND sg13cmos5l_o21ai_1
Xclkbuf_leaf_15_clk _5906_/CLK clkbuf_3_6__f_clk/X VPWR VGND sg13cmos5l_buf_8
X_3895_ _3895_/Y _3880_/A _3889_/X _3881_/A VPWR VGND sg13cmos5l_o21ai_1
X_5686__734 _5686_/RESET_B VPWR VGND sg13cmos5l_tiehi
X_5703_ _5703_/Q clkload9/A _5703_/D _5703_/RESET_B VPWR VGND sg13cmos5l_dfrbpq_1
XFILLER_32_983 VPWR VGND sg13cmos5l_decap_8
X_5634_ _5634_/Q clkload5/A _5634_/D _5634_/RESET_B VPWR VGND sg13cmos5l_dfrbpq_1
XFILLER_31_493 VPWR VGND sg13cmos5l_fill_1
X_5565_ _5565_/Q clkload1/A _5565_/D _5565_/RESET_B VPWR VGND sg13cmos5l_dfrbpq_1
X_5496_ _5496_/Q _5559_/CLK _5496_/D _5496_/RESET_B VPWR VGND sg13cmos5l_dfrbpq_1
X_4516_ _4522_/S _4402_/Y _4495_/A _4514_/X _4515_/Y VPWR VGND sg13cmos5l_a22oi_1
X_4447_ _4455_/A _4445_/C _4446_/Y _4445_/Y VPWR VGND sg13cmos5l_a21oi_1
X_4378_ _4378_/Y _4364_/Y _4368_/X _4381_/A _4381_/B VPWR VGND sg13cmos5l_a22oi_1
X_5693__727 _5693_/RESET_B VPWR VGND sg13cmos5l_tiehi
X_3329_ _5637_/D _5315_/A1 _3329_/A1 _3336_/S VPWR VGND sg13cmos5l_mux2_1
X_6048_ _6048_/Q _6063_/CLK _6048_/D _6048_/RESET_B VPWR VGND sg13cmos5l_dfrbpq_1
XFILLER_23_972 VPWR VGND sg13cmos5l_decap_4
XFILLER_23_983 VPWR VGND sg13cmos5l_decap_4
XFILLER_22_493 VPWR VGND sg13cmos5l_decap_8
XFILLER_49_313 VPWR VGND sg13cmos5l_fill_1
XFILLER_49_346 VPWR VGND sg13cmos5l_fill_1
X_3680_ _3681_/C _3760_/A1 _3670_/X _3671_/Y _3672_/Y _3762_/A VPWR VGND sg13cmos5l_a221oi_1
X_5350_ _5482_/D _5350_/A0 _3217_/A _5350_/S VPWR VGND sg13cmos5l_mux2_1
X_5281_ _6069_/D _6074_/D _5281_/B VPWR VGND sg13cmos5l_nor2_1
X_4301_ _5899_/D _4818_/A _4301_/B VPWR VGND sg13cmos5l_and2_1
X_4232_ _4235_/A _5910_/Q _5887_/Q VPWR VGND sg13cmos5l_nand2_1
Xclkbuf_leaf_4_clk clkload6/A clkbuf_leaf_4_clk/A VPWR VGND sg13cmos5l_buf_8
X_4163_ _4163_/Y _5848_/Q _5883_/Q VPWR VGND sg13cmos5l_nor2b_1
X_3114_ _3114_/Y _3114_/A VPWR VGND sg13cmos5l_inv_1
X_4094_ _4094_/Y _4081_/Y _4082_/Y _4093_/Y VPWR VGND sg13cmos5l_o21ai_1
XFILLER_48_390 VPWR VGND sg13cmos5l_decap_8
X_4996_ _5148_/A _6023_/Q _4996_/B VPWR VGND sg13cmos5l_nand2b_1
X_3947_ _3947_/Y _3939_/Y _3941_/Y _4063_/A VPWR VGND sg13cmos5l_o21ai_1
XFILLER_17_1022 VPWR VGND sg13cmos5l_decap_8
XFILLER_20_920 VPWR VGND sg13cmos5l_fill_2
X_3878_ _3881_/B _4009_/A _3878_/B VPWR VGND sg13cmos5l_nor2_1
X_5617_ _5617_/Q clkload5/A _5617_/D _5617_/RESET_B VPWR VGND sg13cmos5l_dfrbpq_1
X_5907__462 _5907_/RESET_B VPWR VGND sg13cmos5l_tiehi
X_5548_ _5548_/Q clkload1/A _5548_/D _5548_/RESET_B VPWR VGND sg13cmos5l_dfrbpq_1
X_5479_ _5479_/Q _5559_/CLK _5479_/D _5479_/RESET_B VPWR VGND sg13cmos5l_dfrbpq_1
X_5914__455 _5914_/RESET_B VPWR VGND sg13cmos5l_tiehi
XFILLER_14_213 VPWR VGND sg13cmos5l_fill_1
XFILLER_27_585 VPWR VGND sg13cmos5l_fill_2
XFILLER_9_29 VPWR VGND sg13cmos5l_fill_1
Xfanout50 _3514_/B _3517_/B VPWR VGND sg13cmos5l_buf_1
XFILLER_11_920 VPWR VGND sg13cmos5l_fill_1
Xfanout61 _3267_/S _3266_/S VPWR VGND sg13cmos5l_buf_1
Xfanout83 _4829_/B _4738_/Y VPWR VGND sg13cmos5l_buf_1
X_5669__751 _5669_/RESET_B VPWR VGND sg13cmos5l_tiehi
Xfanout72 _4867_/B _4878_/B VPWR VGND sg13cmos5l_buf_1
XFILLER_7_913 VPWR VGND sg13cmos5l_decap_8
XFILLER_11_986 VPWR VGND sg13cmos5l_decap_8
Xfanout94 _3609_/A1 _5141_/A VPWR VGND sg13cmos5l_buf_1
X_5921__448 _5921_/RESET_B VPWR VGND sg13cmos5l_tiehi
X_5676__744 _5676_/RESET_B VPWR VGND sg13cmos5l_tiehi
Xclkbuf_3_7__f_clk clkload0/A clkbuf_0_clk/X VPWR VGND sg13cmos5l_buf_8
XFILLER_46_883 VPWR VGND sg13cmos5l_fill_2
X_5889__487 _5889_/RESET_B VPWR VGND sg13cmos5l_tiehi
X_4850_ _4850_/Y _6003_/Q _4867_/B VPWR VGND sg13cmos5l_nand2_1
X_3801_ _3801_/Y _3807_/B _3800_/Y _3220_/C VPWR VGND sg13cmos5l_o21ai_1
X_6045__955 _6045_/RESET_B VPWR VGND sg13cmos5l_tiehi
X_4781_ _5984_/D _4781_/A _4872_/A VPWR VGND sg13cmos5l_nor2_1
X_3732_ _3732_/Y _3734_/S _3143_/Y _3736_/A1 VPWR VGND sg13cmos5l_o21ai_1
X_3663_ _3663_/Y _3657_/Y _3662_/Y input2/X VPWR VGND sg13cmos5l_a21oi_1
Xclkload20 clkload20/Y _6063_/CLK VPWR VGND sg13cmos5l_inv_1
X_5683__737 _5683_/RESET_B VPWR VGND sg13cmos5l_tiehi
X_5402_ _5528_/D _5402_/A0 _5420_/A1 _5408_/S VPWR VGND sg13cmos5l_mux2_1
X_3594_ _5788_/D _3618_/A1 _3593_/B _3593_/Y VPWR VGND sg13cmos5l_o21ai_1
X_5333_ _5341_/S _5342_/B _5333_/B VPWR VGND sg13cmos5l_nor2_1
XFILLER_47_1026 VPWR VGND sg13cmos5l_fill_2
X_5264_ _5266_/B _5270_/A _5264_/B _5270_/C VPWR VGND sg13cmos5l_and3_1
X_5195_ _5197_/B _5195_/A _5254_/A _5253_/A VPWR VGND sg13cmos5l_nand3_1
X_4215_ _4219_/A _4207_/D _4206_/B _4214_/Y VPWR VGND sg13cmos5l_a21o_1
X_4146_ _4275_/A _4261_/A _4265_/A VPWR VGND sg13cmos5l_and2_1
X_4077_ _4077_/Y _5480_/Q _4079_/S VPWR VGND sg13cmos5l_nand2b_1
XFILLER_24_566 VPWR VGND sg13cmos5l_decap_8
X_4979_ _4990_/A _4977_/C _4978_/Y _4977_/Y VPWR VGND sg13cmos5l_a21o_1
Xclkload3 clkload3/Y clkload3/A VPWR VGND sg13cmos5l_inv_1
Xfanout240 _5367_/A1 input11/X VPWR VGND sg13cmos5l_buf_1
XFILLER_47_614 VPWR VGND sg13cmos5l_decap_4
Xfanout251 _5432_/B _5291_/A VPWR VGND sg13cmos5l_buf_1
X_5851__531 _5851_/RESET_B VPWR VGND sg13cmos5l_tiehi
XFILLER_34_319 VPWR VGND sg13cmos5l_fill_2
X_5988__375 _5988_/RESET_B VPWR VGND sg13cmos5l_tiehi
XFILLER_24_70 VPWR VGND sg13cmos5l_fill_2
XFILLER_10_293 VPWR VGND sg13cmos5l_fill_1
XFILLER_6_286 VPWR VGND sg13cmos5l_decap_4
XFILLER_2_492 VPWR VGND sg13cmos5l_fill_1
X_4000_ _4000_/X _5553_/Q _5536_/Q _5519_/Q _5502_/Q _4100_/S0 _4100_/S1 VPWR VGND
+ sg13cmos5l_mux4_1
X_5951_ _5951_/Q _5973_/CLK _5951_/D _5951_/RESET_B VPWR VGND sg13cmos5l_dfrbpq_1
X_4902_ _4902_/Y _5226_/A VPWR VGND sg13cmos5l_inv_1
X_5882_ _5882_/Q _5906_/CLK _5882_/D _5882_/RESET_B VPWR VGND sg13cmos5l_dfrbpq_1
X_4833_ _4872_/B _4838_/A _4877_/B VPWR VGND sg13cmos5l_nor2_1
X_4764_ _4764_/Y _5973_/Q _4775_/B _4762_/Y _4763_/Y VPWR VGND sg13cmos5l_a22oi_1
X_3715_ _3715_/X _5714_/Q _5708_/Q _3731_/S VPWR VGND sg13cmos5l_mux2_1
X_4695_ _4696_/B _4695_/A _4695_/B VPWR VGND sg13cmos5l_xnor2_1
X_3646_ _3646_/Y _3087_/Y _3643_/B _3645_/Y VPWR VGND sg13cmos5l_a21oi_1
X_5904__465 _5904_/RESET_B VPWR VGND sg13cmos5l_tiehi
X_3577_ _3577_/Y _3577_/A _3577_/B VPWR VGND sg13cmos5l_nand2_1
X_5316_ _5451_/D _5316_/A0 _5354_/A0 _5322_/S VPWR VGND sg13cmos5l_mux2_1
X_5247_ _5248_/A _5227_/Y _5118_/B _5247_/S VPWR VGND sg13cmos5l_mux2_1
X_5976__290 _5976_/D VPWR VGND sg13cmos5l_tielo
X_5659__761 _5659_/RESET_B VPWR VGND sg13cmos5l_tiehi
X_5178_ _5178_/Y _6056_/Q _6030_/Q VPWR VGND sg13cmos5l_nand2_1
X_5835__559 _5835_/RESET_B VPWR VGND sg13cmos5l_tiehi
XFILLER_28_157 VPWR VGND sg13cmos5l_fill_1
X_4129_ _5858_/D _3850_/Y _4129_/A2 _3857_/B _4127_/X _3857_/A VPWR VGND sg13cmos5l_a221oi_1
XFILLER_44_639 VPWR VGND sg13cmos5l_fill_1
XFILLER_16_308 VPWR VGND sg13cmos5l_fill_2
XFILLER_24_330 VPWR VGND sg13cmos5l_fill_2
X_5911__458 _5911_/RESET_B VPWR VGND sg13cmos5l_tiehi
XFILLER_24_396 VPWR VGND sg13cmos5l_fill_2
X_5666__754 _5666_/RESET_B VPWR VGND sg13cmos5l_tiehi
XFILLER_4_735 VPWR VGND sg13cmos5l_fill_1
XFILLER_3_278 VPWR VGND sg13cmos5l_fill_1
X_5879__497 _5879_/RESET_B VPWR VGND sg13cmos5l_tiehi
XFILLER_0_963 VPWR VGND sg13cmos5l_decap_8
X_5521__471 _5521_/RESET_B VPWR VGND sg13cmos5l_tiehi
XFILLER_48_978 VPWR VGND sg13cmos5l_decap_8
XFILLER_47_455 VPWR VGND sg13cmos5l_decap_8
X_5673__747 _5673_/RESET_B VPWR VGND sg13cmos5l_tiehi
XFILLER_19_168 VPWR VGND sg13cmos5l_fill_1
XFILLER_16_853 VPWR VGND sg13cmos5l_fill_1
XFILLER_43_661 VPWR VGND sg13cmos5l_fill_1
X_3500_ _3500_/Y _3500_/A _3505_/B VPWR VGND sg13cmos5l_nand2_1
X_6042__958 _6042_/RESET_B VPWR VGND sg13cmos5l_tiehi
X_4480_ _4480_/Y _4480_/A _4480_/B _4480_/C VPWR VGND sg13cmos5l_nand3_1
XFILLER_7_573 VPWR VGND sg13cmos5l_fill_1
X_3431_ _3431_/Y _3445_/C _3533_/A VPWR VGND sg13cmos5l_nor2_1
X_3362_ _5667_/D _3362_/A0 _5423_/A1 _3365_/S VPWR VGND sg13cmos5l_mux2_1
X_5101_ _5101_/Y _5110_/B _5101_/B VPWR VGND sg13cmos5l_nor2_1
X_3293_ _5606_/D _5356_/A0 _3293_/A1 _3297_/S VPWR VGND sg13cmos5l_mux2_1
Xhold1207 _5391_/A1 _5518_/Q VPWR VGND sg13cmos5l_dlygate4sd3_1
Xhold1229 _5377_/A1 _5506_/Q VPWR VGND sg13cmos5l_dlygate4sd3_1
X_5032_ _5059_/C _6034_/Q _5059_/B _5055_/A VPWR VGND sg13cmos5l_o21ai_1
Xhold1218 _3306_/A0 _5618_/Q VPWR VGND sg13cmos5l_dlygate4sd3_1
XFILLER_38_477 VPWR VGND sg13cmos5l_decap_8
X_5934_ _5934_/Q _5994_/CLK _5934_/D _5934_/RESET_B VPWR VGND sg13cmos5l_dfrbpq_1
X_5865_ _5865_/Q _5894_/CLK _5865_/D _5865_/RESET_B VPWR VGND sg13cmos5l_dfrbpq_1
X_4816_ _4816_/Y _4816_/A _4816_/B VPWR VGND sg13cmos5l_nand2_1
X_5796_ _5796_/Q clkload7/A _5796_/D _5796_/RESET_B VPWR VGND sg13cmos5l_dfrbpq_1
XFILLER_21_377 VPWR VGND sg13cmos5l_fill_1
X_4747_ _4747_/Y _4727_/A _4727_/B _4743_/B VPWR VGND sg13cmos5l_a21oi_1
X_4678_ _4679_/B _5971_/Q _4694_/B _4676_/A _4677_/Y VPWR VGND sg13cmos5l_a22oi_1
X_3629_ _3630_/B _3629_/A _3629_/B _5428_/C VPWR VGND sg13cmos5l_nand3_1
Xoutput16 uo_out[2] _5811_/Q VPWR VGND sg13cmos5l_buf_1
X_5978__385 _5978_/RESET_B VPWR VGND sg13cmos5l_tiehi
XFILLER_48_219 VPWR VGND sg13cmos5l_fill_1
XFILLER_45_937 VPWR VGND sg13cmos5l_decap_8
XFILLER_13_856 VPWR VGND sg13cmos5l_decap_8
X_5985__378 _5985_/RESET_B VPWR VGND sg13cmos5l_tiehi
X_3980_ _3980_/Y _4053_/S1 _3979_/X _4071_/A VPWR VGND sg13cmos5l_a21oi_1
XFILLER_44_992 VPWR VGND sg13cmos5l_decap_8
X_5650_ _5650_/Q clkload1/A _5650_/D _5650_/RESET_B VPWR VGND sg13cmos5l_dfrbpq_1
Xclkbuf_0_clk clkbuf_0_clk/X clk VPWR VGND sg13cmos5l_buf_8
X_4601_ _4602_/B _4657_/C _4657_/D VPWR VGND sg13cmos5l_nand2_1
X_5581_ _5581_/Q clkload5/A _5581_/D _5581_/RESET_B VPWR VGND sg13cmos5l_dfrbpq_1
XFILLER_11_1028 VPWR VGND sg13cmos5l_fill_1
X_5649__771 _5649_/RESET_B VPWR VGND sg13cmos5l_tiehi
X_4532_ _4757_/A _4831_/A _4532_/B VPWR VGND sg13cmos5l_xnor2_1
X_5469__881 _5469_/RESET_B VPWR VGND sg13cmos5l_tiehi
X_4463_ _4463_/Y _4463_/A _4463_/B VPWR VGND sg13cmos5l_nand2_1
X_3414_ _3793_/A _3582_/A _3791_/A VPWR VGND sg13cmos5l_and2_1
X_4394_ _4395_/B _4400_/A _4584_/A VPWR VGND sg13cmos5l_nand2_1
X_3345_ _5652_/D _3345_/A0 _5398_/A0 _3345_/S VPWR VGND sg13cmos5l_mux2_1
Xhold1015 _3468_/A _5728_/Q VPWR VGND sg13cmos5l_dlygate4sd3_1
X_6064_ _6064_/Q _6067_/CLK _6064_/D _6064_/RESET_B VPWR VGND sg13cmos5l_dfrbpq_1
X_3276_ _5591_/D _3276_/A0 _3384_/A _3279_/S VPWR VGND sg13cmos5l_mux2_1
Xhold1004 _3528_/A _5756_/Q VPWR VGND sg13cmos5l_dlygate4sd3_1
Xhold1048 _5736_/D _3487_/Y VPWR VGND sg13cmos5l_dlygate4sd3_1
X_5015_ _5015_/Y _5015_/A _5015_/B _5015_/C VPWR VGND sg13cmos5l_nor3_1
Xhold1037 _3562_/A _5773_/Q VPWR VGND sg13cmos5l_dlygate4sd3_1
Xhold1026 _3526_/A _5755_/Q VPWR VGND sg13cmos5l_dlygate4sd3_1
Xhold1059 _3493_/A _5740_/Q VPWR VGND sg13cmos5l_dlygate4sd3_1
X_5656__764 _5656_/RESET_B VPWR VGND sg13cmos5l_tiehi
X_5917_ _5917_/Q _5973_/CLK _5917_/D _5917_/RESET_B VPWR VGND sg13cmos5l_dfrbpq_1
XFILLER_21_141 VPWR VGND sg13cmos5l_decap_8
X_5848_ _5848_/Q _5906_/CLK _5848_/D _5848_/RESET_B VPWR VGND sg13cmos5l_dfrbpq_1
X_5779_ _5779_/Q _5822_/CLK _5779_/D _5779_/RESET_B VPWR VGND sg13cmos5l_dfrbpq_1
X_5663__757 _5663_/RESET_B VPWR VGND sg13cmos5l_tiehi
XFILLER_49_506 VPWR VGND sg13cmos5l_decap_8
Xhold1571 _3764_/A1 _5814_/Q VPWR VGND sg13cmos5l_dlygate4sd3_1
Xhold1560 _3858_/A _5850_/Q VPWR VGND sg13cmos5l_dlygate4sd3_1
Xhold1582 _4426_/A _5894_/Q VPWR VGND sg13cmos5l_dlygate4sd3_1
XFILLER_45_723 VPWR VGND sg13cmos5l_fill_1
Xhold1593 _4289_/A _5895_/Q VPWR VGND sg13cmos5l_dlygate4sd3_1
XFILLER_16_71 VPWR VGND sg13cmos5l_fill_2
XFILLER_26_992 VPWR VGND sg13cmos5l_fill_1
XFILLER_41_940 VPWR VGND sg13cmos5l_fill_2
XFILLER_9_635 VPWR VGND sg13cmos5l_fill_1
XFILLER_40_483 VPWR VGND sg13cmos5l_decap_8
X_3130_ _4287_/B _4173_/A VPWR VGND sg13cmos5l_inv_1
XFILLER_48_572 VPWR VGND sg13cmos5l_decap_8
X_3061_ _3061_/Y _3061_/A VPWR VGND sg13cmos5l_inv_1
XFILLER_35_222 VPWR VGND sg13cmos5l_fill_1
XFILLER_36_778 VPWR VGND sg13cmos5l_fill_2
X_3963_ _3963_/Y _5615_/Q _4089_/B VPWR VGND sg13cmos5l_nand2b_1
XFILLER_32_940 VPWR VGND sg13cmos5l_fill_1
X_5968__395 _5968_/RESET_B VPWR VGND sg13cmos5l_tiehi
X_5702_ _5702_/Q clkload1/A _5702_/D _5702_/RESET_B VPWR VGND sg13cmos5l_dfrbpq_1
X_3894_ _3894_/Y _4099_/A1 _3892_/X _3893_/Y VPWR VGND sg13cmos5l_a21oi_1
X_5633_ _5633_/Q clkload1/A _5633_/D _5633_/RESET_B VPWR VGND sg13cmos5l_dfrbpq_1
X_5564_ _5564_/Q clkload2/A _5564_/D _5564_/RESET_B VPWR VGND sg13cmos5l_dfrbpq_1
X_4515_ _4515_/Y _4403_/B _4495_/Y _4512_/A _4512_/B VPWR VGND sg13cmos5l_a22oi_1
X_5495_ _5495_/Q _5555_/CLK _5495_/D _5495_/RESET_B VPWR VGND sg13cmos5l_dfrbpq_1
X_4446_ _4446_/Y _5944_/Q _5940_/Q VPWR VGND sg13cmos5l_nor2b_1
X_4377_ _4381_/B _5917_/Q _4377_/B VPWR VGND sg13cmos5l_xor2_1
X_3328_ _3336_/S _3824_/A _5371_/B _3389_/A _3398_/D VPWR VGND sg13cmos5l_nand4_1
X_5975__388 _5975_/RESET_B VPWR VGND sg13cmos5l_tiehi
X_3259_ _5579_/D _3259_/A0 _3320_/A1 _3267_/S VPWR VGND sg13cmos5l_mux2_1
X_6047_ _6047_/Q _6047_/CLK _6047_/D _6047_/RESET_B VPWR VGND sg13cmos5l_dfrbpq_1
XFILLER_37_37 VPWR VGND sg13cmos5l_fill_1
XFILLER_26_244 VPWR VGND sg13cmos5l_fill_2
XFILLER_22_472 VPWR VGND sg13cmos5l_decap_8
XFILLER_6_649 VPWR VGND sg13cmos5l_fill_1
XFILLER_2_877 VPWR VGND sg13cmos5l_decap_4
XFILLER_37_509 VPWR VGND sg13cmos5l_fill_2
XFILLER_40_1021 VPWR VGND sg13cmos5l_decap_8
X_5639__781 _5639_/RESET_B VPWR VGND sg13cmos5l_tiehi
X_5459__891 _5459_/RESET_B VPWR VGND sg13cmos5l_tiehi
Xhold1390 _5383_/A0 _5511_/Q VPWR VGND sg13cmos5l_dlygate4sd3_1
XFILLER_27_92 VPWR VGND sg13cmos5l_fill_2
XFILLER_20_409 VPWR VGND sg13cmos5l_decap_8
X_5646__774 _5646_/RESET_B VPWR VGND sg13cmos5l_tiehi
X_5525__436 _5525_/RESET_B VPWR VGND sg13cmos5l_tiehi
X_5280_ _5280_/Y _3190_/A _6069_/Q _5279_/Y VPWR VGND sg13cmos5l_a21oi_1
X_5466__884 _5466_/RESET_B VPWR VGND sg13cmos5l_tiehi
X_4300_ _4300_/Y _4290_/Y _4439_/A1 _4298_/A VPWR VGND sg13cmos5l_a21oi_1
X_4231_ _4250_/B _4231_/A _4230_/Y VPWR VGND sg13cmos5l_nor2b_1
X_4162_ _4162_/Y _5849_/Q _4312_/A VPWR VGND sg13cmos5l_nand2_1
X_3113_ _3113_/Y _3113_/A VPWR VGND sg13cmos5l_inv_1
X_4093_ _4093_/Y _4088_/Y _4091_/Y _4092_/Y VPWR VGND sg13cmos5l_o21ai_1
X_5653__767 _5653_/RESET_B VPWR VGND sg13cmos5l_tiehi
XFILLER_36_575 VPWR VGND sg13cmos5l_fill_1
X_4995_ _4995_/Y _4995_/A _4995_/B VPWR VGND sg13cmos5l_nor2_1
X_3946_ _3946_/Y _4067_/A _3943_/Y _5804_/Q VPWR VGND sg13cmos5l_a21oi_1
XFILLER_20_976 VPWR VGND sg13cmos5l_fill_1
X_3877_ _3878_/B _5622_/Q _5605_/Q _5597_/Q _5571_/Q _3998_/S0 _4049_/A1 VPWR VGND
+ sg13cmos5l_mux4_1
X_5616_ _5616_/Q clkload1/A _5616_/D _5616_/RESET_B VPWR VGND sg13cmos5l_dfrbpq_1
X_5547_ _5547_/Q clkload2/A _5547_/D _5547_/RESET_B VPWR VGND sg13cmos5l_dfrbpq_1
XFILLER_2_118 VPWR VGND sg13cmos5l_fill_1
X_5478_ _5478_/Q _5555_/CLK _5478_/D _5478_/RESET_B VPWR VGND sg13cmos5l_dfrbpq_1
X_4429_ _5921_/D _4460_/A _4429_/B VPWR VGND sg13cmos5l_nor2_1
X_5474__608 _5474_/RESET_B VPWR VGND sg13cmos5l_tiehi
XFILLER_39_380 VPWR VGND sg13cmos5l_fill_1
XFILLER_42_512 VPWR VGND sg13cmos5l_decap_4
XFILLER_42_545 VPWR VGND sg13cmos5l_decap_8
XFILLER_15_748 VPWR VGND sg13cmos5l_fill_2
XFILLER_42_567 VPWR VGND sg13cmos5l_fill_2
XFILLER_9_19 VPWR VGND sg13cmos5l_fill_1
Xfanout40 _5389_/S _5388_/S VPWR VGND sg13cmos5l_buf_1
Xfanout51 _3517_/B _3507_/Y VPWR VGND sg13cmos5l_buf_1
Xfanout62 _3241_/S _3240_/S VPWR VGND sg13cmos5l_buf_1
Xfanout73 _4685_/B _4694_/B VPWR VGND sg13cmos5l_buf_1
Xfanout95 _3611_/A1 _3067_/Y VPWR VGND sg13cmos5l_buf_1
Xfanout84 _4783_/A _4738_/Y VPWR VGND sg13cmos5l_buf_1
XFILLER_7_969 VPWR VGND sg13cmos5l_fill_1
XFILLER_1_195 VPWR VGND sg13cmos5l_fill_1
XFILLER_18_586 VPWR VGND sg13cmos5l_fill_2
XFILLER_18_597 VPWR VGND sg13cmos5l_fill_2
X_3800_ _3800_/Y _3812_/D _3807_/C VPWR VGND sg13cmos5l_nor2_1
X_4780_ _4872_/A _4568_/X _4772_/S _4779_/Y VPWR VGND sg13cmos5l_a21oi_1
X_3731_ _3731_/X _5727_/Q _5721_/Q _3731_/S VPWR VGND sg13cmos5l_mux2_1
X_5965__398 _5965_/RESET_B VPWR VGND sg13cmos5l_tiehi
X_3662_ _3662_/Y _3714_/A _3658_/X _3661_/Y VPWR VGND sg13cmos5l_o21ai_1
Xclkload10 clkload10/X _5555_/CLK VPWR VGND sg13cmos5l_buf_8
X_3593_ _3593_/Y _3593_/A _3593_/B VPWR VGND sg13cmos5l_nand2_1
X_5401_ _5527_/D _5401_/A0 _5419_/A1 _5408_/S VPWR VGND sg13cmos5l_mux2_1
Xclkload21 clkload21/Y _5936_/CLK VPWR VGND sg13cmos5l_inv_1
X_5332_ _5466_/D _5332_/A0 _5370_/A1 _5332_/S VPWR VGND sg13cmos5l_mux2_1
XFILLER_47_1005 VPWR VGND sg13cmos5l_decap_8
X_5263_ _6062_/D _5266_/A _5263_/B _5263_/C VPWR VGND sg13cmos5l_nor3_1
X_5194_ _5261_/A _5195_/A _5192_/B _5193_/X VPWR VGND sg13cmos5l_o21ai_1
X_4214_ _4214_/Y _4208_/Y _4212_/Y _4213_/Y VPWR VGND sg13cmos5l_a21oi_1
X_4145_ _4265_/A _5886_/Q _4145_/B VPWR VGND sg13cmos5l_xnor2_1
X_4076_ _4076_/X _5565_/Q _5548_/Q _5531_/Q _5514_/Q _3979_/S _4076_/S1 VPWR VGND
+ sg13cmos5l_mux4_1
XFILLER_24_545 VPWR VGND sg13cmos5l_fill_2
XFILLER_34_16 VPWR VGND sg13cmos5l_fill_2
XFILLER_24_556 VPWR VGND sg13cmos5l_decap_4
X_4978_ _4978_/Y _5174_/A _4978_/B VPWR VGND sg13cmos5l_nor2_1
Xclkload4 clkload4/Y clkload4/A VPWR VGND sg13cmos5l_inv_4
X_3929_ _3930_/B _5696_/Q _5679_/Q _5662_/Q _5645_/Q _3172_/S _4076_/S1 VPWR VGND
+ sg13cmos5l_mux4_1
XFILLER_3_427 VPWR VGND sg13cmos5l_fill_2
X_5629__791 _5629_/RESET_B VPWR VGND sg13cmos5l_tiehi
XFILLER_1_6 VPWR VGND sg13cmos5l_fill_1
Xfanout241 _3382_/A _3394_/A0 VPWR VGND sg13cmos5l_buf_1
XFILLER_8_1021 VPWR VGND sg13cmos5l_decap_8
Xfanout230 _5417_/A0 input13/X VPWR VGND sg13cmos5l_buf_1
Xfanout252 _5291_/A _3417_/C VPWR VGND sg13cmos5l_buf_1
XFILLER_46_147 VPWR VGND sg13cmos5l_fill_2
X_6068__923 _6068_/RESET_B VPWR VGND sg13cmos5l_tiehi
XFILLER_27_361 VPWR VGND sg13cmos5l_decap_4
XFILLER_28_895 VPWR VGND sg13cmos5l_decap_8
X_5636__784 _5636_/RESET_B VPWR VGND sg13cmos5l_tiehi
XFILLER_15_534 VPWR VGND sg13cmos5l_fill_2
X_5456__894 _5456_/RESET_B VPWR VGND sg13cmos5l_tiehi
XFILLER_10_250 VPWR VGND sg13cmos5l_fill_2
XFILLER_11_795 VPWR VGND sg13cmos5l_fill_1
X_5643__777 _5643_/RESET_B VPWR VGND sg13cmos5l_tiehi
XFILLER_3_961 VPWR VGND sg13cmos5l_decap_8
X_5463__887 _5463_/RESET_B VPWR VGND sg13cmos5l_tiehi
X_5895__481 _5895_/RESET_B VPWR VGND sg13cmos5l_tiehi
XFILLER_18_361 VPWR VGND sg13cmos5l_decap_8
X_5950_ _5950_/Q _5973_/CLK _5950_/D _5950_/RESET_B VPWR VGND sg13cmos5l_dfrbpq_1
X_4901_ _5226_/A _6037_/Q _6038_/Q VPWR VGND sg13cmos5l_xnor2_1
XFILLER_18_372 VPWR VGND sg13cmos5l_fill_1
X_5881_ _5881_/Q _5906_/CLK _5881_/D _5881_/RESET_B VPWR VGND sg13cmos5l_dfrbpq_1
X_4832_ _6003_/D _4832_/A _4892_/A VPWR VGND sg13cmos5l_nor2_1
X_4763_ _4763_/Y _5973_/Q _5951_/Q VPWR VGND sg13cmos5l_nand2b_1
X_3714_ _3720_/B _3714_/A _3714_/B VPWR VGND sg13cmos5l_nor2_1
X_4694_ _4695_/B _5970_/Q _4694_/B VPWR VGND sg13cmos5l_xnor2_1
X_3645_ _3645_/Y _3087_/Y _3643_/B _3744_/A VPWR VGND sg13cmos5l_o21ai_1
X_5798__622 _5798_/RESET_B VPWR VGND sg13cmos5l_tiehi
X_3576_ _3576_/Y _3613_/A1 _3577_/B _3575_/Y VPWR VGND sg13cmos5l_o21ai_1
X_5315_ _5450_/D _5315_/A0 _5315_/A1 _5322_/S VPWR VGND sg13cmos5l_mux2_1
X_5246_ _5267_/B _5246_/A VPWR VGND sg13cmos5l_inv_1
XFILLER_29_16 VPWR VGND sg13cmos5l_fill_1
X_5177_ _6061_/D _5177_/A _5177_/B VPWR VGND sg13cmos5l_nor2_1
XFILLER_28_114 VPWR VGND sg13cmos5l_fill_1
X_4128_ _4128_/Y _4128_/A _4128_/B _4128_/C _4128_/D VPWR VGND sg13cmos5l_nand4_1
X_4059_ _4062_/B _4065_/A _4059_/B VPWR VGND sg13cmos5l_nor2_1
XFILLER_37_681 VPWR VGND sg13cmos5l_decap_4
XFILLER_40_824 VPWR VGND sg13cmos5l_decap_8
XFILLER_40_857 VPWR VGND sg13cmos5l_fill_2
XFILLER_3_202 VPWR VGND sg13cmos5l_fill_2
XFILLER_0_942 VPWR VGND sg13cmos5l_decap_8
XFILLER_48_957 VPWR VGND sg13cmos5l_decap_8
XFILLER_47_434 VPWR VGND sg13cmos5l_decap_8
XFILLER_35_629 VPWR VGND sg13cmos5l_fill_1
XFILLER_42_172 VPWR VGND sg13cmos5l_fill_2
XFILLER_31_846 VPWR VGND sg13cmos5l_fill_2
XFILLER_30_367 VPWR VGND sg13cmos5l_fill_1
X_3430_ _3533_/A _3582_/A _3582_/B VPWR VGND sg13cmos5l_nand2_1
X_3361_ _5666_/D _3361_/A0 _3382_/A _3365_/S VPWR VGND sg13cmos5l_mux2_1
X_5100_ _5101_/B _5100_/A _5122_/A VPWR VGND sg13cmos5l_nor2_1
X_6080_ _6080_/Q _6080_/CLK _6080_/D _6080_/RESET_B VPWR VGND sg13cmos5l_dfrbpq_1
X_5031_ _5055_/A _6033_/Q _5042_/B _5045_/A VPWR VGND sg13cmos5l_a21o_1
X_3292_ _5605_/D _5355_/A0 _3292_/A1 _3297_/S VPWR VGND sg13cmos5l_mux2_1
Xhold1219 _3354_/A1 _5660_/Q VPWR VGND sg13cmos5l_dlygate4sd3_1
Xhold1208 _3368_/A1 _5672_/Q VPWR VGND sg13cmos5l_dlygate4sd3_1
X_5500__556 _5500_/RESET_B VPWR VGND sg13cmos5l_tiehi
XFILLER_38_456 VPWR VGND sg13cmos5l_decap_8
X_5933_ _5933_/Q _5994_/CLK _5933_/D _5933_/RESET_B VPWR VGND sg13cmos5l_dfrbpq_1
X_5864_ _5864_/Q _5864_/CLK _5864_/D _5864_/RESET_B VPWR VGND sg13cmos5l_dfrbpq_1
X_4815_ _4815_/Y _4798_/Y _4809_/Y _4814_/Y VPWR VGND sg13cmos5l_a21oi_1
X_5795_ _5795_/Q _5822_/CLK _5795_/D _5795_/RESET_B VPWR VGND sg13cmos5l_dfrbpq_1
X_4746_ _4746_/X _4750_/A _4951_/A VPWR VGND sg13cmos5l_and2_1
X_4677_ _4677_/Y _5970_/Q _4685_/B VPWR VGND sg13cmos5l_nand2_1
X_3628_ _3628_/Y _5834_/Q _5428_/C _3629_/A VPWR VGND sg13cmos5l_a21oi_1
Xoutput17 uo_out[3] _5812_/Q VPWR VGND sg13cmos5l_buf_1
X_6058__933 _6058_/RESET_B VPWR VGND sg13cmos5l_tiehi
X_5540__325 _5540_/RESET_B VPWR VGND sg13cmos5l_tiehi
X_3559_ _5771_/D _3609_/A1 _3567_/B _3558_/Y VPWR VGND sg13cmos5l_o21ai_1
X_5626__794 _5626_/RESET_B VPWR VGND sg13cmos5l_tiehi
X_5229_ _5229_/Y _5120_/S _5116_/Y _5228_/A _5228_/B _5115_/Y VPWR VGND sg13cmos5l_a221oi_1
XFILLER_45_916 VPWR VGND sg13cmos5l_decap_8
XFILLER_29_467 VPWR VGND sg13cmos5l_fill_2
X_5633__787 _5633_/RESET_B VPWR VGND sg13cmos5l_tiehi
X_6065__926 _6065_/RESET_B VPWR VGND sg13cmos5l_tiehi
XFILLER_12_301 VPWR VGND sg13cmos5l_fill_2
X_5453__897 _5453_/RESET_B VPWR VGND sg13cmos5l_tiehi
X_5885__491 _5885_/RESET_B VPWR VGND sg13cmos5l_tiehi
XFILLER_40_665 VPWR VGND sg13cmos5l_fill_1
X_6072__919 _6072_/RESET_B VPWR VGND sg13cmos5l_tiehi
X_5892__484 _5892_/RESET_B VPWR VGND sg13cmos5l_tiehi
XFILLER_48_743 VPWR VGND sg13cmos5l_fill_1
XFILLER_0_794 VPWR VGND sg13cmos5l_fill_2
X_5788__632 _5788_/RESET_B VPWR VGND sg13cmos5l_tiehi
XFILLER_31_643 VPWR VGND sg13cmos5l_fill_2
X_4600_ _4657_/D _4594_/A _4600_/B _4600_/C VPWR VGND sg13cmos5l_nand3b_1
XFILLER_31_687 VPWR VGND sg13cmos5l_fill_2
X_5580_ _5580_/Q clkload3/A _5580_/D _5580_/RESET_B VPWR VGND sg13cmos5l_dfrbpq_1
X_4531_ _4550_/A _5975_/Q _4532_/B VPWR VGND sg13cmos5l_xnor2_1
X_4462_ _4462_/Y _4440_/Y _4458_/B _4461_/Y VPWR VGND sg13cmos5l_a21oi_1
X_3413_ _3545_/B _5824_/Q _3413_/B VPWR VGND sg13cmos5l_nand2_1
X_4393_ _5915_/D _4460_/A _4393_/B VPWR VGND sg13cmos5l_nor2_1
X_5795__625 _5795_/RESET_B VPWR VGND sg13cmos5l_tiehi
X_3344_ _5651_/D _3344_/A0 _3215_/A _3346_/S VPWR VGND sg13cmos5l_mux2_1
X_6063_ _6063_/Q _6063_/CLK _6063_/D _6063_/RESET_B VPWR VGND sg13cmos5l_dfrbpq_1
Xhold1005 _3529_/B1 _3528_/Y VPWR VGND sg13cmos5l_dlygate4sd3_1
X_3275_ _5590_/D _3275_/A0 _5298_/A _3279_/S VPWR VGND sg13cmos5l_mux2_1
Xhold1038 _3573_/A _5778_/Q VPWR VGND sg13cmos5l_dlygate4sd3_1
Xhold1049 _3617_/A _5800_/Q VPWR VGND sg13cmos5l_dlygate4sd3_1
X_5014_ _5014_/X _4924_/Y _4926_/B _4956_/B VPWR VGND sg13cmos5l_a21o_1
Xhold1027 _5755_/D _3527_/Y VPWR VGND sg13cmos5l_dlygate4sd3_1
Xhold1016 _4189_/B _5855_/Q VPWR VGND sg13cmos5l_dlygate4sd3_1
XFILLER_26_404 VPWR VGND sg13cmos5l_fill_2
XFILLER_39_787 VPWR VGND sg13cmos5l_fill_1
XFILLER_39_798 VPWR VGND sg13cmos5l_fill_1
XFILLER_42_919 VPWR VGND sg13cmos5l_fill_1
XFILLER_26_448 VPWR VGND sg13cmos5l_decap_8
X_5916_ _5916_/Q _5943_/CLK _5916_/D _5916_/RESET_B VPWR VGND sg13cmos5l_dfrbpq_1
XFILLER_42_16 VPWR VGND sg13cmos5l_fill_1
X_5847_ _5847_/Q _5860_/CLK _5847_/D _5847_/RESET_B VPWR VGND sg13cmos5l_dfrbpq_1
X_5778_ _5778_/Q clkload7/A _5778_/D _5778_/RESET_B VPWR VGND sg13cmos5l_dfrbpq_1
XFILLER_10_849 VPWR VGND sg13cmos5l_fill_1
X_4729_ _4743_/B _5981_/Q _4729_/B VPWR VGND sg13cmos5l_xor2_1
X_5991__372 _5991_/RESET_B VPWR VGND sg13cmos5l_tiehi
Xhold1550 _6049_/D _5161_/Y VPWR VGND sg13cmos5l_dlygate4sd3_1
Xhold1561 _3859_/B1 _3858_/Y VPWR VGND sg13cmos5l_dlygate4sd3_1
Xhold1583 _4427_/B1 _4426_/Y VPWR VGND sg13cmos5l_dlygate4sd3_1
Xhold1572 _3705_/A2 _5811_/Q VPWR VGND sg13cmos5l_dlygate4sd3_1
Xhold1594 _4296_/B _4295_/X VPWR VGND sg13cmos5l_dlygate4sd3_1
XFILLER_45_779 VPWR VGND sg13cmos5l_fill_2
XFILLER_33_919 VPWR VGND sg13cmos5l_decap_8
XFILLER_16_61 VPWR VGND sg13cmos5l_fill_2
XFILLER_41_974 VPWR VGND sg13cmos5l_decap_8
XFILLER_12_142 VPWR VGND sg13cmos5l_fill_1
XFILLER_13_654 VPWR VGND sg13cmos5l_fill_2
X_5848__537 _5848_/RESET_B VPWR VGND sg13cmos5l_tiehi
XFILLER_40_462 VPWR VGND sg13cmos5l_decap_8
XFILLER_13_698 VPWR VGND sg13cmos5l_fill_2
XFILLER_5_842 VPWR VGND sg13cmos5l_decap_4
X_6020__339 _6020_/RESET_B VPWR VGND sg13cmos5l_tiehi
X_5824__581 _5824_/RESET_B VPWR VGND sg13cmos5l_tiehi
XFILLER_4_385 VPWR VGND sg13cmos5l_fill_1
X_6076__841 _6076_/RESET_B VPWR VGND sg13cmos5l_tiehi
XFILLER_48_551 VPWR VGND sg13cmos5l_decap_8
XFILLER_36_735 VPWR VGND sg13cmos5l_decap_4
X_5701_ _5701_/Q clkload1/A _5701_/D _5701_/RESET_B VPWR VGND sg13cmos5l_dfrbpq_1
X_3962_ _3962_/Y _4085_/S _3116_/Y _3961_/Y VPWR VGND sg13cmos5l_a21oi_1
X_3893_ _3893_/Y _4099_/A1 _3891_/Y _3111_/A VPWR VGND sg13cmos5l_o21ai_1
X_5632_ _5632_/Q clkload5/A _5632_/D _5632_/RESET_B VPWR VGND sg13cmos5l_dfrbpq_1
X_5563_ _5563_/Q _5810_/CLK _5563_/D _5563_/RESET_B VPWR VGND sg13cmos5l_dfrbpq_1
X_4514_ _4514_/X _4504_/Y _4507_/X _4513_/Y VPWR VGND sg13cmos5l_a21o_1
X_5494_ _5494_/Q clkload9/A _5494_/D _5494_/RESET_B VPWR VGND sg13cmos5l_dfrbpq_1
X_4445_ _4445_/Y _5898_/Q _4445_/B _4445_/C VPWR VGND sg13cmos5l_nor3_1
X_4376_ _4379_/B _5917_/Q _4377_/B VPWR VGND sg13cmos5l_nor2b_1
X_3327_ _3398_/D _5352_/A _5352_/B VPWR VGND sg13cmos5l_nor2_1
X_5623__797 _5623_/RESET_B VPWR VGND sg13cmos5l_tiehi
X_6046_ _6046_/Q _6067_/CLK _6046_/D _6046_/RESET_B VPWR VGND sg13cmos5l_dfrbpq_1
X_3258_ _5578_/D _3258_/A0 _3391_/A0 _3267_/S VPWR VGND sg13cmos5l_mux2_1
XFILLER_2_1027 VPWR VGND sg13cmos5l_fill_2
X_3189_ _6080_/D _3157_/Y _5285_/C _4122_/A VPWR VGND sg13cmos5l_a21oi_1
XFILLER_26_201 VPWR VGND sg13cmos5l_decap_8
XFILLER_26_212 VPWR VGND sg13cmos5l_fill_1
XFILLER_41_204 VPWR VGND sg13cmos5l_fill_2
X_6062__929 _6062_/RESET_B VPWR VGND sg13cmos5l_tiehi
XFILLER_22_451 VPWR VGND sg13cmos5l_decap_8
X_5882__494 _5882_/RESET_B VPWR VGND sg13cmos5l_tiehi
XFILLER_2_856 VPWR VGND sg13cmos5l_fill_1
X_5778__642 _5778_/RESET_B VPWR VGND sg13cmos5l_tiehi
XFILLER_45_532 VPWR VGND sg13cmos5l_fill_2
Xhold1380 _3259_/A0 _5579_/Q VPWR VGND sg13cmos5l_dlygate4sd3_1
XFILLER_27_71 VPWR VGND sg13cmos5l_fill_1
Xhold1391 _5335_/A0 _5468_/Q VPWR VGND sg13cmos5l_dlygate4sd3_1
XFILLER_45_565 VPWR VGND sg13cmos5l_decap_8
XFILLER_26_790 VPWR VGND sg13cmos5l_fill_1
XFILLER_9_411 VPWR VGND sg13cmos5l_fill_1
X_5785__635 _5785_/RESET_B VPWR VGND sg13cmos5l_tiehi
XFILLER_14_996 VPWR VGND sg13cmos5l_decap_4
X_4230_ _4230_/Y _5887_/Q _5888_/Q _5889_/Q VPWR VGND sg13cmos5l_o21ai_1
X_4161_ _4161_/Y _5850_/Q _5885_/Q VPWR VGND sg13cmos5l_nand2_1
X_5792__628 _5792_/RESET_B VPWR VGND sg13cmos5l_tiehi
X_4092_ _4092_/Y _4084_/Y _4086_/Y _4068_/A VPWR VGND sg13cmos5l_a21oi_1
X_3112_ _3112_/Y _3112_/A VPWR VGND sg13cmos5l_inv_1
XFILLER_49_893 VPWR VGND sg13cmos5l_fill_2
X_4994_ _4995_/B _4994_/A1 _4987_/X _5011_/B VPWR VGND sg13cmos5l_o21ai_1
X_3945_ _3945_/X _4067_/A _3945_/B VPWR VGND sg13cmos5l_or2_1
XFILLER_32_793 VPWR VGND sg13cmos5l_fill_2
X_5615_ _5615_/Q clkload5/A _5615_/D _5615_/RESET_B VPWR VGND sg13cmos5l_dfrbpq_1
X_3876_ _3887_/B _4003_/A _3876_/B _3876_/C VPWR VGND sg13cmos5l_nor3_1
XFILLER_20_988 VPWR VGND sg13cmos5l_decap_4
X_5981__382 _5981_/RESET_B VPWR VGND sg13cmos5l_tiehi
X_5546_ _5546_/Q _5810_/CLK _5546_/D _5546_/RESET_B VPWR VGND sg13cmos5l_dfrbpq_1
X_5477_ _5477_/Q clkload9/A _5477_/D _5477_/RESET_B VPWR VGND sg13cmos5l_dfrbpq_1
X_4428_ _4480_/C _4410_/A _4423_/B _4426_/Y VPWR VGND sg13cmos5l_a21o_1
X_4359_ _4375_/B _5942_/Q _5941_/Q VPWR VGND sg13cmos5l_nor2_1
XFILLER_47_808 VPWR VGND sg13cmos5l_fill_2
X_6029_ _6029_/Q _6056_/CLK _6029_/D _6029_/RESET_B VPWR VGND sg13cmos5l_dfrbpq_1
XFILLER_27_510 VPWR VGND sg13cmos5l_fill_2
XFILLER_27_521 VPWR VGND sg13cmos5l_fill_2
Xfanout30 _3543_/B _3542_/S VPWR VGND sg13cmos5l_buf_1
Xfanout52 _3490_/B _3493_/B VPWR VGND sg13cmos5l_buf_1
Xfanout63 _5423_/S _5422_/S VPWR VGND sg13cmos5l_buf_1
Xfanout41 _5370_/S _5369_/S VPWR VGND sg13cmos5l_buf_1
Xfanout74 _4769_/A _4561_/B VPWR VGND sg13cmos5l_buf_1
Xfanout96 _5158_/A1 _3067_/Y VPWR VGND sg13cmos5l_buf_1
Xfanout85 _4638_/A _4710_/A VPWR VGND sg13cmos5l_buf_1
XFILLER_6_436 VPWR VGND sg13cmos5l_fill_2
XFILLER_8_0 VPWR VGND sg13cmos5l_fill_1
X_6019__341 _6019_/RESET_B VPWR VGND sg13cmos5l_tiehi
XFILLER_2_686 VPWR VGND sg13cmos5l_fill_1
XFILLER_37_318 VPWR VGND sg13cmos5l_fill_1
XFILLER_45_340 VPWR VGND sg13cmos5l_fill_2
X_3730_ _3730_/Y _3731_/S _5709_/Q _3729_/Y VPWR VGND sg13cmos5l_a21oi_1
X_3661_ _3661_/Y _5807_/Q _3661_/B VPWR VGND sg13cmos5l_nor2_1
Xclkload22 clkload22/Y _5894_/CLK VPWR VGND sg13cmos5l_inv_4
X_3592_ _3592_/Y _3143_/Y _3591_/B _3591_/Y VPWR VGND sg13cmos5l_a21oi_1
X_5400_ _5526_/D _5400_/A0 _5418_/A1 _5408_/S VPWR VGND sg13cmos5l_mux2_1
Xclkload11 clkload11/Y _5674_/CLK VPWR VGND sg13cmos5l_inv_2
X_5331_ _5465_/D _5331_/A0 _3217_/A _5331_/S VPWR VGND sg13cmos5l_mux2_1
XFILLER_47_1028 VPWR VGND sg13cmos5l_fill_1
X_5262_ _5263_/C _5108_/Y _5247_/S _5270_/C _5270_/A _5241_/X VPWR VGND sg13cmos5l_a221oi_1
X_5193_ _5193_/X _5193_/A _5193_/B VPWR VGND sg13cmos5l_xor2_1
X_4213_ _4213_/Y _4207_/C _4211_/Y _4206_/X VPWR VGND sg13cmos5l_o21ai_1
X_4144_ _4144_/Y _4314_/A _5885_/Q VPWR VGND sg13cmos5l_nand2_1
X_4075_ _4075_/Y _5842_/Q _4075_/B _4075_/C VPWR VGND sg13cmos5l_nor3_1
XFILLER_24_502 VPWR VGND sg13cmos5l_fill_2
XFILLER_37_896 VPWR VGND sg13cmos5l_decap_4
X_4977_ _4977_/Y _5991_/Q _4977_/B _4977_/C VPWR VGND sg13cmos5l_nor3_1
X_5768__652 _5768_/RESET_B VPWR VGND sg13cmos5l_tiehi
X_3928_ _3931_/B _4009_/A _3928_/B VPWR VGND sg13cmos5l_nor2_1
Xclkload5 clkload5/Y clkload5/A VPWR VGND sg13cmos5l_inv_2
X_3859_ _3859_/Y _3860_/B _4160_/B _3859_/B1 VPWR VGND sg13cmos5l_o21ai_1
X_5529_ _5529_/Q _5810_/CLK _5529_/D _5529_/RESET_B VPWR VGND sg13cmos5l_dfrbpq_1
XFILLER_8_1000 VPWR VGND sg13cmos5l_fill_1
Xfanout231 _3215_/A fanout235/X VPWR VGND sg13cmos5l_buf_1
Xfanout220 _5315_/A1 _5353_/A0 VPWR VGND sg13cmos5l_buf_1
Xfanout242 _5414_/A0 _3394_/A0 VPWR VGND sg13cmos5l_buf_1
X_5775__645 _5775_/RESET_B VPWR VGND sg13cmos5l_tiehi
Xfanout253 _3417_/C input1/X VPWR VGND sg13cmos5l_buf_1
XFILLER_46_159 VPWR VGND sg13cmos5l_fill_2
XFILLER_43_800 VPWR VGND sg13cmos5l_fill_2
XFILLER_43_866 VPWR VGND sg13cmos5l_fill_2
XFILLER_30_505 VPWR VGND sg13cmos5l_fill_2
XFILLER_24_94 VPWR VGND sg13cmos5l_fill_2
X_5782__638 _5782_/RESET_B VPWR VGND sg13cmos5l_tiehi
XFILLER_7_778 VPWR VGND sg13cmos5l_fill_2
XFILLER_3_995 VPWR VGND sg13cmos5l_decap_8
X_5971__392 _5971_/RESET_B VPWR VGND sg13cmos5l_tiehi
XFILLER_46_682 VPWR VGND sg13cmos5l_decap_8
X_4900_ _4924_/B _6013_/Q _4900_/B VPWR VGND sg13cmos5l_xnor2_1
X_5880_ _5880_/Q _5906_/CLK _5880_/D _5880_/RESET_B VPWR VGND sg13cmos5l_dfrbpq_1
XFILLER_34_844 VPWR VGND sg13cmos5l_fill_1
XFILLER_34_855 VPWR VGND sg13cmos5l_fill_2
X_4831_ _6002_/D _4831_/A _4892_/A VPWR VGND sg13cmos5l_nor2_1
X_4762_ _4762_/Y _5972_/Q _5950_/Q VPWR VGND sg13cmos5l_nor2_1
XFILLER_14_1016 VPWR VGND sg13cmos5l_decap_8
XFILLER_14_1027 VPWR VGND sg13cmos5l_fill_2
X_3713_ _3714_/B _5774_/Q _5768_/Q _5762_/Q _5756_/Q _3726_/A1 _3736_/A1 VPWR VGND
+ sg13cmos5l_mux4_1
X_4693_ _4709_/A _4693_/A _4693_/B VPWR VGND sg13cmos5l_nand2_1
X_3644_ _3644_/Y _5426_/A _5426_/B VPWR VGND sg13cmos5l_nor2_1
X_3575_ _3575_/Y _3575_/A _3580_/B VPWR VGND sg13cmos5l_nand2_1
X_5314_ _5322_/S _5399_/C _5333_/B VPWR VGND sg13cmos5l_nor2_1
X_5245_ _5246_/A _5245_/A _5245_/B _5245_/C VPWR VGND sg13cmos5l_nor3_1
X_5176_ _5176_/X _5176_/A _5176_/B VPWR VGND sg13cmos5l_and2_1
X_4127_ _4127_/X _4128_/A _4128_/B _4128_/C _4128_/D VPWR VGND sg13cmos5l_and4_1
XFILLER_45_16 VPWR VGND sg13cmos5l_fill_2
X_4058_ _4059_/B _5629_/Q _5612_/Q _5587_/Q _5578_/Q _4097_/S _4098_/A1 VPWR VGND
+ sg13cmos5l_mux4_1
XFILLER_25_811 VPWR VGND sg13cmos5l_fill_2
XFILLER_24_332 VPWR VGND sg13cmos5l_fill_1
XFILLER_25_888 VPWR VGND sg13cmos5l_fill_2
X_6009__351 _6009_/RESET_B VPWR VGND sg13cmos5l_tiehi
XFILLER_24_398 VPWR VGND sg13cmos5l_fill_1
XFILLER_48_936 VPWR VGND sg13cmos5l_decap_8
XFILLER_47_413 VPWR VGND sg13cmos5l_decap_8
X_6016__344 _6016_/RESET_B VPWR VGND sg13cmos5l_tiehi
XFILLER_0_998 VPWR VGND sg13cmos5l_decap_8
XFILLER_43_630 VPWR VGND sg13cmos5l_decap_8
XFILLER_11_571 VPWR VGND sg13cmos5l_fill_1
X_3360_ _5665_/D _3360_/A0 _5421_/A1 _3365_/S VPWR VGND sg13cmos5l_mux2_1
X_5030_ _5045_/A _5044_/A _5044_/B _5044_/C VPWR VGND sg13cmos5l_a21oi_1
X_3291_ _5604_/D _5354_/A0 _3291_/A1 _3297_/S VPWR VGND sg13cmos5l_mux2_1
Xhold1209 _3267_/A0 _5585_/Q VPWR VGND sg13cmos5l_dlygate4sd3_1
X_5758__662 _5758_/RESET_B VPWR VGND sg13cmos5l_tiehi
XFILLER_39_936 VPWR VGND sg13cmos5l_fill_2
X_5834__561 _5834_/RESET_B VPWR VGND sg13cmos5l_tiehi
XFILLER_47_991 VPWR VGND sg13cmos5l_decap_8
X_5932_ _5932_/Q _5994_/CLK _5932_/D _5932_/RESET_B VPWR VGND sg13cmos5l_dfrbpq_1
XFILLER_34_630 VPWR VGND sg13cmos5l_fill_2
XFILLER_34_641 VPWR VGND sg13cmos5l_fill_2
XFILLER_34_685 VPWR VGND sg13cmos5l_decap_8
X_5863_ _5863_/Q _5894_/CLK _5863_/D _5863_/RESET_B VPWR VGND sg13cmos5l_dfrbpq_1
X_5794_ _5794_/Q _5822_/CLK _5794_/D _5794_/RESET_B VPWR VGND sg13cmos5l_dfrbpq_1
X_4814_ _4814_/Y _4814_/A1 _4809_/Y _4829_/B VPWR VGND sg13cmos5l_o21ai_1
X_4745_ _5978_/D _4829_/B _4745_/B VPWR VGND sg13cmos5l_and2_1
X_5765__655 _5765_/RESET_B VPWR VGND sg13cmos5l_tiehi
X_4676_ _4676_/Y _4676_/A VPWR VGND sg13cmos5l_inv_1
X_3627_ _5802_/D _5428_/A _5429_/B VPWR VGND sg13cmos5l_nor2_1
X_3558_ _3558_/Y _3558_/A _3567_/B VPWR VGND sg13cmos5l_nand2_1
Xoutput18 uo_out[4] _5813_/Q VPWR VGND sg13cmos5l_buf_1
X_3489_ _3489_/Y _3501_/A1 _3490_/B _3488_/Y VPWR VGND sg13cmos5l_o21ai_1
XFILLER_5_1014 VPWR VGND sg13cmos5l_decap_8
X_5228_ _5228_/X _5228_/A _5228_/B VPWR VGND sg13cmos5l_and2_1
X_5159_ _6048_/D _5266_/A _5159_/B VPWR VGND sg13cmos5l_nor2_1
X_5772__648 _5772_/RESET_B VPWR VGND sg13cmos5l_tiehi
Xclkbuf_leaf_36_clk clkload8/A clkbuf_leaf_4_clk/A VPWR VGND sg13cmos5l_buf_8
XFILLER_9_807 VPWR VGND sg13cmos5l_decap_8
Xclkbuf_leaf_27_clk _6061_/CLK clkbuf_3_5__f_clk/X VPWR VGND sg13cmos5l_buf_8
XFILLER_16_652 VPWR VGND sg13cmos5l_fill_2
XFILLER_43_482 VPWR VGND sg13cmos5l_decap_8
XFILLER_8_862 VPWR VGND sg13cmos5l_decap_8
X_5528__402 _5528_/RESET_B VPWR VGND sg13cmos5l_tiehi
X_4530_ _4556_/A _4828_/A _4769_/A VPWR VGND sg13cmos5l_and2_1
XFILLER_7_372 VPWR VGND sg13cmos5l_fill_2
X_4461_ _4461_/Y _4613_/A _4458_/B _4475_/B VPWR VGND sg13cmos5l_o21ai_1
X_3412_ _3791_/A _3412_/A _3413_/B VPWR VGND sg13cmos5l_and2_1
X_4392_ _4393_/B _4392_/A VPWR VGND sg13cmos5l_inv_1
X_3343_ _5650_/D _3343_/A0 _5423_/A1 _3346_/S VPWR VGND sg13cmos5l_mux2_1
X_3274_ _5589_/D _3274_/A0 _5375_/A0 _3279_/S VPWR VGND sg13cmos5l_mux2_1
X_6062_ _6062_/Q _6067_/CLK _6062_/D _6062_/RESET_B VPWR VGND sg13cmos5l_dfrbpq_1
Xhold1006 _5756_/D _3529_/Y VPWR VGND sg13cmos5l_dlygate4sd3_1
XFILLER_23_0 VPWR VGND sg13cmos5l_fill_2
Xhold1039 _3575_/A _5779_/Q VPWR VGND sg13cmos5l_dlygate4sd3_1
Xhold1028 _3571_/A _5777_/Q VPWR VGND sg13cmos5l_dlygate4sd3_1
Xhold1017 _3500_/A _5743_/Q VPWR VGND sg13cmos5l_dlygate4sd3_1
X_5013_ _5013_/Y _5015_/A _5015_/B _5015_/C VPWR VGND sg13cmos5l_o21ai_1
XFILLER_39_733 VPWR VGND sg13cmos5l_fill_1
XFILLER_39_744 VPWR VGND sg13cmos5l_fill_1
XFILLER_27_906 VPWR VGND sg13cmos5l_decap_4
Xclkbuf_leaf_18_clk _5943_/CLK clkload0/A VPWR VGND sg13cmos5l_buf_8
X_5915_ _5915_/Q _5943_/CLK _5915_/D _5915_/RESET_B VPWR VGND sg13cmos5l_dfrbpq_1
X_5846_ _5846_/Q _5906_/CLK _5846_/D _5846_/RESET_B VPWR VGND sg13cmos5l_dfrbpq_1
XFILLER_34_482 VPWR VGND sg13cmos5l_fill_2
X_5777_ _5777_/Q _5822_/CLK _5777_/D _5777_/RESET_B VPWR VGND sg13cmos5l_dfrbpq_1
X_4728_ _4733_/A _4732_/A _4732_/B _4726_/Y _4727_/Y _4722_/Y VPWR VGND sg13cmos5l_a221oi_1
X_6006__354 _6006_/RESET_B VPWR VGND sg13cmos5l_tiehi
X_4659_ _4659_/Y _4570_/A _4604_/B _4656_/Y _4657_/Y _4658_/Y VPWR VGND sg13cmos5l_a221oi_1
X_6071__920 _6071_/RESET_B VPWR VGND sg13cmos5l_tiehi
Xhold1562 _4814_/A1 _5989_/Q VPWR VGND sg13cmos5l_dlygate4sd3_1
Xhold1540 _4633_/A1 _5955_/Q VPWR VGND sg13cmos5l_dlygate4sd3_1
Xhold1551 _3097_/A _5886_/Q VPWR VGND sg13cmos5l_dlygate4sd3_1
Xhold1584 _4429_/B _4427_/Y VPWR VGND sg13cmos5l_dlygate4sd3_1
XFILLER_45_736 VPWR VGND sg13cmos5l_decap_8
X_6013__347 _6013_/RESET_B VPWR VGND sg13cmos5l_tiehi
XFILLER_18_939 VPWR VGND sg13cmos5l_decap_8
Xhold1595 _3079_/A _5896_/Q VPWR VGND sg13cmos5l_dlygate4sd3_1
Xhold1573 _4613_/A _5926_/Q VPWR VGND sg13cmos5l_dlygate4sd3_1
XFILLER_26_972 VPWR VGND sg13cmos5l_fill_1
XFILLER_41_942 VPWR VGND sg13cmos5l_fill_1
XFILLER_41_931 VPWR VGND sg13cmos5l_decap_4
XFILLER_25_482 VPWR VGND sg13cmos5l_decap_4
XFILLER_12_165 VPWR VGND sg13cmos5l_fill_2
X_5748__672 _5748_/RESET_B VPWR VGND sg13cmos5l_tiehi
XFILLER_0_581 VPWR VGND sg13cmos5l_fill_2
XFILLER_48_530 VPWR VGND sg13cmos5l_decap_8
X_5755__665 _5755_/RESET_B VPWR VGND sg13cmos5l_tiehi
X_3961_ _3961_/Y _4089_/B _5590_/Q _4091_/A1 VPWR VGND sg13cmos5l_o21ai_1
X_5700_ _5700_/Q clkload5/A _5700_/D _5700_/RESET_B VPWR VGND sg13cmos5l_dfrbpq_1
X_3892_ _3892_/X _5456_/Q _5439_/Q _3892_/S VPWR VGND sg13cmos5l_mux2_1
XFILLER_32_975 VPWR VGND sg13cmos5l_decap_4
X_5631_ _5631_/Q _5810_/CLK _5631_/D _5631_/RESET_B VPWR VGND sg13cmos5l_dfrbpq_1
X_5530__369 _5530_/RESET_B VPWR VGND sg13cmos5l_tiehi
X_5562_ _5562_/Q clkload4/A _5562_/D _5562_/RESET_B VPWR VGND sg13cmos5l_dfrbpq_1
X_4513_ _4513_/Y _4519_/A _4504_/B _4512_/X VPWR VGND sg13cmos5l_o21ai_1
X_5762__658 _5762_/RESET_B VPWR VGND sg13cmos5l_tiehi
X_5493_ _5493_/Q _5559_/CLK _5493_/D _5493_/RESET_B VPWR VGND sg13cmos5l_dfrbpq_1
Xclkbuf_leaf_7_clk clkload9/A clkbuf_leaf_9_clk/A VPWR VGND sg13cmos5l_buf_8
X_4444_ _4458_/A _4445_/C _4443_/Y _4442_/Y VPWR VGND sg13cmos5l_a21oi_1
X_4375_ _4580_/A _5943_/Q _4375_/B VPWR VGND sg13cmos5l_xor2_1
X_3326_ _5636_/D _3326_/A0 _3407_/A0 _3326_/S VPWR VGND sg13cmos5l_mux2_1
X_6045_ _6045_/Q _6067_/CLK _6045_/D _6045_/RESET_B VPWR VGND sg13cmos5l_dfrbpq_1
X_3257_ _5577_/D _3257_/A0 _5353_/A0 _3267_/S VPWR VGND sg13cmos5l_mux2_1
XFILLER_2_1006 VPWR VGND sg13cmos5l_decap_8
X_3188_ _5857_/D _4122_/A VPWR VGND sg13cmos5l_inv_1
XFILLER_27_714 VPWR VGND sg13cmos5l_fill_1
XFILLER_23_942 VPWR VGND sg13cmos5l_decap_8
X_5829_ _5829_/Q clkload8/A _5829_/D _5829_/RESET_B VPWR VGND sg13cmos5l_dfrbpq_1
XFILLER_23_997 VPWR VGND sg13cmos5l_fill_2
XFILLER_10_658 VPWR VGND sg13cmos5l_fill_1
XFILLER_49_327 VPWR VGND sg13cmos5l_fill_2
Xhold1370 _5406_/A0 _5532_/Q VPWR VGND sg13cmos5l_dlygate4sd3_1
XFILLER_45_522 VPWR VGND sg13cmos5l_fill_1
Xhold1381 _3275_/A0 _5590_/Q VPWR VGND sg13cmos5l_dlygate4sd3_1
Xhold1392 _5310_/A1 _5446_/Q VPWR VGND sg13cmos5l_dlygate4sd3_1
XFILLER_27_94 VPWR VGND sg13cmos5l_fill_1
X_5518__478 _5518_/RESET_B VPWR VGND sg13cmos5l_tiehi
XFILLER_41_783 VPWR VGND sg13cmos5l_fill_1
X_4160_ _4160_/Y _4192_/A _4160_/B _4221_/A VPWR VGND sg13cmos5l_nor3_1
X_3111_ _3111_/Y _3111_/A VPWR VGND sg13cmos5l_inv_1
X_4091_ _4091_/Y _4091_/A1 _4090_/Y _4061_/A VPWR VGND sg13cmos5l_o21ai_1
X_4993_ _4995_/A _4993_/A _4987_/X VPWR VGND sg13cmos5l_nor2b_1
X_3944_ _3945_/B _5698_/Q _5681_/Q _5664_/Q _5647_/Q _3172_/S _4076_/S1 VPWR VGND
+ sg13cmos5l_mux4_1
XFILLER_20_901 VPWR VGND sg13cmos5l_fill_1
X_3875_ _3876_/C _3880_/A _3872_/Y _3874_/Y VPWR VGND sg13cmos5l_a21oi_1
X_5614_ _5614_/Q _5810_/CLK _5614_/D _5614_/RESET_B VPWR VGND sg13cmos5l_dfrbpq_1
X_6061__930 _6061_/RESET_B VPWR VGND sg13cmos5l_tiehi
X_5545_ _5545_/Q clkload4/A _5545_/D _5545_/RESET_B VPWR VGND sg13cmos5l_dfrbpq_1
X_6003__357 _6003_/RESET_B VPWR VGND sg13cmos5l_tiehi
X_5476_ _5476_/Q _5674_/CLK _5476_/D _5476_/RESET_B VPWR VGND sg13cmos5l_dfrbpq_1
X_4427_ _4427_/Y _4410_/A _4423_/B _4427_/B1 VPWR VGND sg13cmos5l_a21oi_1
X_4358_ _4358_/Y _4641_/B _4358_/B VPWR VGND sg13cmos5l_nand2b_1
X_3309_ _5620_/D _5315_/A1 _3309_/A1 _3316_/S VPWR VGND sg13cmos5l_mux2_1
X_4289_ _4289_/Y _4289_/A _4289_/B VPWR VGND sg13cmos5l_nand2_1
X_6028_ _6028_/Q _6056_/CLK _6028_/D _6028_/RESET_B VPWR VGND sg13cmos5l_dfrbpq_1
X_5738__682 _5738_/RESET_B VPWR VGND sg13cmos5l_tiehi
Xfanout31 _3531_/B _3528_/B VPWR VGND sg13cmos5l_buf_1
Xfanout20 _5172_/A2 _4471_/A2 VPWR VGND sg13cmos5l_buf_1
Xfanout53 _3468_/B _3467_/S VPWR VGND sg13cmos5l_buf_1
XFILLER_11_912 VPWR VGND sg13cmos5l_decap_4
Xfanout42 _5351_/S _5350_/S VPWR VGND sg13cmos5l_buf_1
Xfanout64 _5301_/S _5302_/B VPWR VGND sg13cmos5l_buf_1
Xfanout97 _3613_/A1 _3501_/A1 VPWR VGND sg13cmos5l_buf_1
Xfanout86 _4710_/A _4606_/A VPWR VGND sg13cmos5l_buf_1
Xfanout75 _5409_/C _5352_/C VPWR VGND sg13cmos5l_buf_1
X_5745__675 _5745_/RESET_B VPWR VGND sg13cmos5l_tiehi
XFILLER_2_665 VPWR VGND sg13cmos5l_fill_2
XFILLER_1_153 VPWR VGND sg13cmos5l_fill_1
X_5752__668 _5752_/RESET_B VPWR VGND sg13cmos5l_tiehi
XFILLER_14_772 VPWR VGND sg13cmos5l_fill_2
X_3660_ _3661_/B _3760_/A1 _3652_/X _3659_/Y VPWR VGND sg13cmos5l_a21oi_1
Xclkload12 clkload12/Y _5692_/CLK VPWR VGND sg13cmos5l_inv_2
X_3591_ _3591_/Y _3591_/A _3591_/B VPWR VGND sg13cmos5l_nor2_1
Xclkload23 clkload23/Y _5994_/CLK VPWR VGND sg13cmos5l_inv_1
X_5330_ _5464_/D _5330_/A0 _5416_/A0 _5332_/S VPWR VGND sg13cmos5l_mux2_1
XFILLER_6_982 VPWR VGND sg13cmos5l_decap_8
X_5261_ _5263_/B _5261_/A _5270_/A _5270_/C VPWR VGND sg13cmos5l_and3_1
X_4212_ _4212_/Y _4207_/C _4211_/Y _4216_/A VPWR VGND sg13cmos5l_a21oi_1
X_5192_ _5245_/B _5195_/A _5192_/B VPWR VGND sg13cmos5l_nor2_1
X_4143_ _4143_/Y _5886_/Q _4313_/A VPWR VGND sg13cmos5l_nor2b_1
X_4074_ _4075_/C _4074_/A _4074_/B VPWR VGND sg13cmos5l_nor2_1
XFILLER_49_691 VPWR VGND sg13cmos5l_decap_8
XFILLER_49_680 VPWR VGND sg13cmos5l_decap_4
XFILLER_37_820 VPWR VGND sg13cmos5l_fill_1
X_5473__610 _5473_/RESET_B VPWR VGND sg13cmos5l_tiehi
XFILLER_36_341 VPWR VGND sg13cmos5l_fill_1
X_4976_ _4993_/A _5991_/Q _4974_/Y _4975_/Y VPWR VGND sg13cmos5l_o21ai_1
X_3927_ _3928_/B _5628_/Q _5611_/Q _5586_/Q _5577_/Q _3892_/S _4098_/A1 VPWR VGND
+ sg13cmos5l_mux4_1
XFILLER_20_731 VPWR VGND sg13cmos5l_fill_1
Xclkload6 clkload6/Y clkload6/A VPWR VGND sg13cmos5l_inv_2
X_3858_ _3858_/Y _3858_/A _5848_/Q VPWR VGND sg13cmos5l_nor2b_1
X_3789_ _3789_/Y _3409_/A _3787_/Y _3788_/Y VPWR VGND sg13cmos5l_a21oi_1
X_5844__541 _5844_/RESET_B VPWR VGND sg13cmos5l_tiehi
X_5528_ _5528_/Q clkload4/A _5528_/D _5528_/RESET_B VPWR VGND sg13cmos5l_dfrbpq_1
X_5459_ _5459_/Q _5559_/CLK _5459_/D _5459_/RESET_B VPWR VGND sg13cmos5l_dfrbpq_1
Xfanout232 _5416_/A0 fanout235/X VPWR VGND sg13cmos5l_buf_1
Xfanout221 _5353_/A0 _5410_/A0 VPWR VGND sg13cmos5l_buf_1
Xfanout210 _5355_/A0 _3392_/A0 VPWR VGND sg13cmos5l_buf_1
Xfanout243 _5298_/A _5357_/A0 VPWR VGND sg13cmos5l_buf_1
Xfanout254 _4818_/A _5166_/A VPWR VGND sg13cmos5l_buf_1
XFILLER_46_149 VPWR VGND sg13cmos5l_fill_1
XFILLER_3_974 VPWR VGND sg13cmos5l_decap_8
XFILLER_2_440 VPWR VGND sg13cmos5l_fill_1
XFILLER_1_77 VPWR VGND sg13cmos5l_fill_1
X_4830_ _6001_/D _4830_/A _4892_/A VPWR VGND sg13cmos5l_nor2_1
X_4761_ _4775_/B _5951_/Q _5950_/Q VPWR VGND sg13cmos5l_xnor2_1
X_3712_ _3712_/Y _3720_/A _3712_/B VPWR VGND sg13cmos5l_nand2_1
X_4692_ _4692_/Y _4692_/A _4692_/B _4692_/C VPWR VGND sg13cmos5l_nor3_1
X_3643_ _5426_/B _3744_/A _3643_/B VPWR VGND sg13cmos5l_nand2_1
X_5728__692 _5728_/RESET_B VPWR VGND sg13cmos5l_tiehi
X_3574_ _5778_/D _3611_/A1 _3580_/B _3573_/Y VPWR VGND sg13cmos5l_o21ai_1
X_5313_ _5449_/D _5370_/A1 _5313_/A1 _5313_/S VPWR VGND sg13cmos5l_mux2_1
X_5244_ _5245_/C _5244_/A _5244_/B _5244_/C VPWR VGND sg13cmos5l_and3_1
X_5175_ _6059_/D _5175_/A _5272_/A VPWR VGND sg13cmos5l_nor2_1
X_4126_ _4128_/D _4126_/A _4126_/B VPWR VGND sg13cmos5l_nor2_1
XFILLER_44_609 VPWR VGND sg13cmos5l_decap_8
X_4057_ _4063_/B _4057_/A _4057_/B VPWR VGND sg13cmos5l_nor2_1
X_5735__685 _5735_/RESET_B VPWR VGND sg13cmos5l_tiehi
XFILLER_36_171 VPWR VGND sg13cmos5l_fill_2
X_5868__305 _5868_/D VPWR VGND sg13cmos5l_tielo
XFILLER_12_528 VPWR VGND sg13cmos5l_fill_2
X_4959_ _6015_/D _5071_/A _4959_/B VPWR VGND sg13cmos5l_nor2_1
XFILLER_40_859 VPWR VGND sg13cmos5l_fill_1
X_5742__678 _5742_/RESET_B VPWR VGND sg13cmos5l_tiehi
XFILLER_48_915 VPWR VGND sg13cmos5l_decap_8
XFILLER_0_977 VPWR VGND sg13cmos5l_decap_8
XFILLER_47_469 VPWR VGND sg13cmos5l_decap_8
XFILLER_16_812 VPWR VGND sg13cmos5l_fill_2
XFILLER_16_845 VPWR VGND sg13cmos5l_fill_1
XFILLER_15_377 VPWR VGND sg13cmos5l_decap_4
XFILLER_31_859 VPWR VGND sg13cmos5l_decap_4
X_3290_ _5603_/D _5315_/A1 _3290_/A1 _3297_/S VPWR VGND sg13cmos5l_mux2_1
XFILLER_25_4 VPWR VGND sg13cmos5l_fill_2
XFILLER_39_948 VPWR VGND sg13cmos5l_decap_8
XFILLER_47_970 VPWR VGND sg13cmos5l_decap_8
XFILLER_19_661 VPWR VGND sg13cmos5l_fill_2
X_5931_ _5931_/Q _5994_/CLK _5931_/D _5931_/RESET_B VPWR VGND sg13cmos5l_dfrbpq_1
XFILLER_33_152 VPWR VGND sg13cmos5l_fill_1
X_5862_ _5862_/Q _5894_/CLK _5862_/D _5862_/RESET_B VPWR VGND sg13cmos5l_dfrbpq_1
X_5793_ _5793_/Q clkload7/A _5793_/D _5793_/RESET_B VPWR VGND sg13cmos5l_dfrbpq_1
X_4813_ _4813_/Y _4802_/Y _4809_/Y _4812_/Y VPWR VGND sg13cmos5l_a21oi_1
X_4744_ _4745_/B _4748_/S _4743_/Y _4742_/X VPWR VGND sg13cmos5l_a21o_1
XFILLER_31_19 VPWR VGND sg13cmos5l_fill_2
X_4675_ _4676_/A _5970_/Q _4685_/B _4695_/A VPWR VGND sg13cmos5l_o21ai_1
X_3626_ _5429_/B _3629_/B _5428_/C VPWR VGND sg13cmos5l_xnor2_1
X_3557_ _3566_/S _3569_/B _3607_/A _3557_/C VPWR VGND sg13cmos5l_nand3_1
Xoutput19 uo_out[5] _5814_/Q VPWR VGND sg13cmos5l_buf_1
X_5227_ _5227_/Y _5228_/A _5228_/B VPWR VGND sg13cmos5l_nand2_1
X_3488_ _3488_/Y _3488_/A _3490_/B VPWR VGND sg13cmos5l_nand2_1
X_5158_ _5159_/B _5140_/B _5158_/A1 _5162_/S VPWR VGND sg13cmos5l_mux2_1
XFILLER_29_425 VPWR VGND sg13cmos5l_fill_1
X_4109_ _4109_/Y _5482_/Q _4109_/B VPWR VGND sg13cmos5l_nand2b_1
X_5089_ _5089_/X _5089_/A _5089_/B VPWR VGND sg13cmos5l_xor2_1
XFILLER_17_609 VPWR VGND sg13cmos5l_fill_1
XFILLER_40_601 VPWR VGND sg13cmos5l_decap_4
XFILLER_4_513 VPWR VGND sg13cmos5l_fill_2
XFILLER_0_730 VPWR VGND sg13cmos5l_fill_1
XFILLER_43_1010 VPWR VGND sg13cmos5l_decap_8
XFILLER_44_973 VPWR VGND sg13cmos5l_decap_4
XFILLER_43_461 VPWR VGND sg13cmos5l_decap_8
XFILLER_16_697 VPWR VGND sg13cmos5l_fill_2
XFILLER_31_689 VPWR VGND sg13cmos5l_fill_1
X_4460_ _5925_/D _4460_/A _4460_/B VPWR VGND sg13cmos5l_nor2_1
X_4391_ _4392_/A _4395_/A _4388_/Y _4390_/Y VPWR VGND sg13cmos5l_o21ai_1
X_3411_ _3767_/A _6053_/Q _3411_/B VPWR VGND sg13cmos5l_nand2_1
X_5725__695 _5725_/RESET_B VPWR VGND sg13cmos5l_tiehi
X_3342_ _5649_/D _3342_/A0 _3382_/A _3346_/S VPWR VGND sg13cmos5l_mux2_1
X_3273_ _5588_/D _3273_/A0 _3320_/A1 _3279_/S VPWR VGND sg13cmos5l_mux2_1
X_6061_ _6061_/Q _6061_/CLK _6061_/D _6061_/RESET_B VPWR VGND sg13cmos5l_dfrbpq_1
Xhold1029 _3598_/A _5790_/Q VPWR VGND sg13cmos5l_dlygate4sd3_1
Xhold1007 _3517_/A _5752_/Q VPWR VGND sg13cmos5l_dlygate4sd3_1
X_5012_ _6035_/D _5012_/A _5071_/A VPWR VGND sg13cmos5l_nor2_1
Xhold1018 _4190_/B _5856_/Q VPWR VGND sg13cmos5l_dlygate4sd3_1
XFILLER_26_406 VPWR VGND sg13cmos5l_fill_1
X_5914_ _5914_/Q _5943_/CLK _5914_/D _5914_/RESET_B VPWR VGND sg13cmos5l_dfrbpq_1
X_5732__688 _5732_/RESET_B VPWR VGND sg13cmos5l_tiehi
X_5845_ _5845_/Q _5906_/CLK _5845_/D _5845_/RESET_B VPWR VGND sg13cmos5l_dfrbpq_1
X_5776_ _5776_/Q clkload7/A _5776_/D _5776_/RESET_B VPWR VGND sg13cmos5l_dfrbpq_1
X_4727_ _4727_/Y _4727_/A _4727_/B _4951_/A VPWR VGND sg13cmos5l_nand3_1
X_5448__902 _5448_/RESET_B VPWR VGND sg13cmos5l_tiehi
X_4658_ _4658_/Y _4657_/A _4657_/B _4657_/C _4657_/D VPWR VGND sg13cmos5l_a22oi_1
X_3609_ _5795_/D _3609_/A1 _3617_/B _3608_/Y VPWR VGND sg13cmos5l_o21ai_1
X_4589_ _4589_/X _4584_/Y _4588_/Y _4583_/Y VPWR VGND sg13cmos5l_a21o_1
X_5481__594 _5481_/RESET_B VPWR VGND sg13cmos5l_tiehi
Xhold1552 _3129_/A _5870_/Q VPWR VGND sg13cmos5l_dlygate4sd3_1
Xhold1530 _3206_/A2 _3205_/Y VPWR VGND sg13cmos5l_dlygate4sd3_1
Xhold1541 _4634_/B _4633_/Y VPWR VGND sg13cmos5l_dlygate4sd3_1
Xhold1585 _3771_/A _5816_/Q VPWR VGND sg13cmos5l_dlygate4sd3_1
Xhold1563 _5989_/D _4815_/Y VPWR VGND sg13cmos5l_dlygate4sd3_1
Xhold1574 _5926_/D _4462_/Y VPWR VGND sg13cmos5l_dlygate4sd3_1
Xhold1596 _4298_/B _4297_/X VPWR VGND sg13cmos5l_dlygate4sd3_1
XFILLER_25_461 VPWR VGND sg13cmos5l_decap_8
XFILLER_40_420 VPWR VGND sg13cmos5l_fill_1
XFILLER_13_656 VPWR VGND sg13cmos5l_fill_1
XFILLER_34_1009 VPWR VGND sg13cmos5l_fill_2
XFILLER_40_497 VPWR VGND sg13cmos5l_fill_2
XFILLER_48_586 VPWR VGND sg13cmos5l_decap_8
X_3960_ _3960_/Y _4091_/A1 _3959_/X _4067_/A VPWR VGND sg13cmos5l_a21oi_1
X_3891_ _3891_/Y _3892_/S _5490_/Q _3890_/Y VPWR VGND sg13cmos5l_o21ai_1
X_5630_ _5630_/Q clkload3/A _5630_/D _5630_/RESET_B VPWR VGND sg13cmos5l_dfrbpq_1
X_5561_ _5561_/Q clkload2/A _5561_/D _5561_/RESET_B VPWR VGND sg13cmos5l_dfrbpq_1
X_4512_ _4512_/X _4512_/A _4512_/B VPWR VGND sg13cmos5l_or2_1
X_5492_ _5492_/Q _5555_/CLK _5492_/D _5492_/RESET_B VPWR VGND sg13cmos5l_dfrbpq_1
X_4443_ _4443_/Y _4652_/A _5944_/Q VPWR VGND sg13cmos5l_nor2_1
X_4374_ _4381_/A _5943_/Q _4375_/B VPWR VGND sg13cmos5l_xnor2_1
X_3325_ _5635_/D _3325_/A0 _5322_/A1 _3325_/S VPWR VGND sg13cmos5l_mux2_1
X_6055__938 _6055_/RESET_B VPWR VGND sg13cmos5l_tiehi
X_6044_ _6044_/Q _6067_/CLK _6044_/D _6044_/RESET_B VPWR VGND sg13cmos5l_dfrbpq_1
X_3256_ _3266_/S _5361_/C _5380_/C _3317_/D VPWR VGND sg13cmos5l_nor3_1
X_3187_ _4122_/A _4126_/A _5432_/B VPWR VGND sg13cmos5l_nand2b_1
XFILLER_42_718 VPWR VGND sg13cmos5l_fill_2
XFILLER_41_206 VPWR VGND sg13cmos5l_fill_1
XFILLER_23_976 VPWR VGND sg13cmos5l_fill_2
X_5828_ _5828_/Q clkload3/A _5828_/D _5828_/RESET_B VPWR VGND sg13cmos5l_dfrbpq_1
XFILLER_22_486 VPWR VGND sg13cmos5l_decap_8
XFILLER_23_987 VPWR VGND sg13cmos5l_fill_2
XFILLER_6_608 VPWR VGND sg13cmos5l_fill_2
X_5759_ _5759_/Q _5834_/CLK _5759_/D _5759_/RESET_B VPWR VGND sg13cmos5l_dfrbpq_1
XFILLER_5_118 VPWR VGND sg13cmos5l_fill_2
XFILLER_49_339 VPWR VGND sg13cmos5l_fill_1
XFILLER_45_501 VPWR VGND sg13cmos5l_decap_8
Xhold1360 _3339_/A0 _5646_/Q VPWR VGND sg13cmos5l_dlygate4sd3_1
Xhold1393 _3381_/A0 _5682_/Q VPWR VGND sg13cmos5l_dlygate4sd3_1
Xhold1371 _3344_/A0 _5651_/Q VPWR VGND sg13cmos5l_dlygate4sd3_1
Xhold1382 _3292_/A1 _5605_/Q VPWR VGND sg13cmos5l_dlygate4sd3_1
XFILLER_33_729 VPWR VGND sg13cmos5l_fill_2
XFILLER_32_217 VPWR VGND sg13cmos5l_fill_2
XFILLER_4_140 VPWR VGND sg13cmos5l_fill_2
X_5894__301 _5894_/D VPWR VGND sg13cmos5l_tielo
XFILLER_4_33 VPWR VGND sg13cmos5l_fill_2
X_5722__698 _5722_/RESET_B VPWR VGND sg13cmos5l_tiehi
X_3110_ _3110_/Y _5166_/A VPWR VGND sg13cmos5l_inv_1
XFILLER_49_851 VPWR VGND sg13cmos5l_fill_1
X_4090_ _4090_/Y _4089_/B _5633_/Q _4089_/Y VPWR VGND sg13cmos5l_o21ai_1
X_5618__802 _5618_/RESET_B VPWR VGND sg13cmos5l_tiehi
XFILLER_48_383 VPWR VGND sg13cmos5l_decap_8
X_5438__912 _5438_/RESET_B VPWR VGND sg13cmos5l_tiehi
X_4992_ _4992_/Y _4992_/A _4992_/B VPWR VGND sg13cmos5l_nor2_1
X_3943_ _3943_/Y _3943_/A VPWR VGND sg13cmos5l_inv_1
XFILLER_17_1015 VPWR VGND sg13cmos5l_decap_8
X_3874_ _3874_/Y _3880_/A _3873_/X _3881_/A VPWR VGND sg13cmos5l_o21ai_1
X_5613_ _5613_/Q clkload3/A _5613_/D _5613_/RESET_B VPWR VGND sg13cmos5l_dfrbpq_1
XFILLER_32_795 VPWR VGND sg13cmos5l_fill_1
Xclkbuf_3_2__f_clk clkbuf_leaf_9_clk/A clkbuf_0_clk/X VPWR VGND sg13cmos5l_buf_8
X_5544_ _5544_/Q clkload2/A _5544_/D _5544_/RESET_B VPWR VGND sg13cmos5l_dfrbpq_1
X_5475_ _5475_/Q _5555_/CLK _5475_/D _5475_/RESET_B VPWR VGND sg13cmos5l_dfrbpq_1
X_5445__905 _5445_/RESET_B VPWR VGND sg13cmos5l_tiehi
X_4426_ _4426_/Y _4426_/A _4426_/B VPWR VGND sg13cmos5l_nor2_1
X_4357_ _4475_/B _5278_/A _4641_/B VPWR VGND sg13cmos5l_nor2_1
X_3308_ _3316_/S _5409_/C _5352_/D _3308_/C VPWR VGND sg13cmos5l_nand3_1
X_4288_ _4289_/B _4281_/Y _4286_/Y _4287_/Y _4282_/Y VPWR VGND sg13cmos5l_a22oi_1
X_3239_ _5566_/D _3239_/A0 _3215_/A _3241_/S VPWR VGND sg13cmos5l_mux2_1
X_6027_ _6027_/Q _6056_/CLK _6027_/D _6027_/RESET_B VPWR VGND sg13cmos5l_dfrbpq_1
Xfanout21 _4824_/A2 _4471_/A2 VPWR VGND sg13cmos5l_buf_1
Xfanout32 _3505_/B _3498_/B VPWR VGND sg13cmos5l_buf_1
Xfanout54 _3452_/B _3455_/B VPWR VGND sg13cmos5l_buf_1
Xfanout65 _3407_/S _3406_/S VPWR VGND sg13cmos5l_buf_1
Xfanout43 _5332_/S _5331_/S VPWR VGND sg13cmos5l_buf_1
Xfanout87 _4460_/A _4523_/A VPWR VGND sg13cmos5l_buf_1
XFILLER_7_906 VPWR VGND sg13cmos5l_decap_8
Xfanout98 _3501_/A1 _3066_/Y VPWR VGND sg13cmos5l_buf_1
Xfanout76 _3389_/A _5352_/C VPWR VGND sg13cmos5l_buf_1
XFILLER_7_939 VPWR VGND sg13cmos5l_fill_1
XFILLER_6_438 VPWR VGND sg13cmos5l_fill_1
XFILLER_2_600 VPWR VGND sg13cmos5l_fill_2
XFILLER_49_125 VPWR VGND sg13cmos5l_fill_2
XFILLER_46_810 VPWR VGND sg13cmos5l_decap_4
XFILLER_45_342 VPWR VGND sg13cmos5l_fill_1
Xhold1190 _3295_/A1 _5608_/Q VPWR VGND sg13cmos5l_dlygate4sd3_1
XFILLER_41_570 VPWR VGND sg13cmos5l_decap_4
X_3590_ _5786_/D _3615_/A1 _3591_/B _3589_/Y VPWR VGND sg13cmos5l_o21ai_1
Xclkload24 clkload24/Y _6080_/CLK VPWR VGND sg13cmos5l_inv_1
Xclkload13 clkload13/Y _5840_/CLK VPWR VGND sg13cmos5l_inv_1
XFILLER_6_972 VPWR VGND sg13cmos5l_decap_4
XFILLER_47_1019 VPWR VGND sg13cmos5l_decap_8
X_5260_ _5270_/C _5250_/Y _5257_/Y _5259_/Y VPWR VGND sg13cmos5l_o21ai_1
X_4211_ _4211_/Y _4211_/A _4211_/B VPWR VGND sg13cmos5l_nor2_1
X_5191_ _5192_/B _6061_/Q _5190_/B _5189_/Y _5253_/B VPWR VGND sg13cmos5l_a22oi_1
X_4142_ _4142_/Y _4261_/A _4138_/A _4153_/A _4312_/A _4141_/Y VPWR VGND sg13cmos5l_a221oi_1
X_4073_ _4074_/B _4071_/Y _4072_/Y _4063_/A VPWR VGND sg13cmos5l_o21ai_1
XFILLER_37_832 VPWR VGND sg13cmos5l_decap_8
XFILLER_37_843 VPWR VGND sg13cmos5l_fill_1
X_4975_ _4975_/Y _4975_/A _5177_/A _4977_/C VPWR VGND sg13cmos5l_nand3_1
X_3926_ _3926_/Y _3620_/B _3907_/Y _3908_/Y _3925_/Y _5843_/Q VPWR VGND sg13cmos5l_a221oi_1
Xclkload7 clkload7/Y clkload7/A VPWR VGND sg13cmos5l_inv_2
X_3857_ _5846_/D _3857_/A _3857_/B VPWR VGND sg13cmos5l_nor2_1
X_3788_ _3788_/Y _3409_/A _3787_/Y _3744_/A VPWR VGND sg13cmos5l_o21ai_1
X_5527_ _5527_/Q clkload2/A _5527_/D _5527_/RESET_B VPWR VGND sg13cmos5l_dfrbpq_1
X_5458_ _5458_/Q _5555_/CLK _5458_/D _5458_/RESET_B VPWR VGND sg13cmos5l_dfrbpq_1
X_4409_ _4409_/X _4413_/B _4426_/B VPWR VGND sg13cmos5l_and2_1
Xfanout222 _5410_/A0 input6/X VPWR VGND sg13cmos5l_buf_1
X_5389_ _5517_/D _5389_/A0 _5408_/A1 _5389_/S VPWR VGND sg13cmos5l_mux2_1
Xfanout200 _5278_/A _6074_/D VPWR VGND sg13cmos5l_buf_1
Xfanout211 _3392_/A0 _5412_/A0 VPWR VGND sg13cmos5l_buf_1
Xfanout244 _5357_/A0 _3394_/A0 VPWR VGND sg13cmos5l_buf_1
Xfanout233 _5359_/A0 fanout235/X VPWR VGND sg13cmos5l_buf_1
Xfanout255 _4358_/B _5166_/A VPWR VGND sg13cmos5l_buf_1
XFILLER_43_802 VPWR VGND sg13cmos5l_fill_1
XFILLER_11_743 VPWR VGND sg13cmos5l_fill_1
XFILLER_11_765 VPWR VGND sg13cmos5l_fill_2
XFILLER_7_736 VPWR VGND sg13cmos5l_fill_2
X_5608__812 _5608_/RESET_B VPWR VGND sg13cmos5l_tiehi
XFILLER_2_474 VPWR VGND sg13cmos5l_fill_2
XFILLER_1_45 VPWR VGND sg13cmos5l_fill_1
XFILLER_1_34 VPWR VGND sg13cmos5l_fill_1
XFILLER_18_320 VPWR VGND sg13cmos5l_fill_1
XFILLER_19_876 VPWR VGND sg13cmos5l_fill_1
X_5615__805 _5615_/RESET_B VPWR VGND sg13cmos5l_tiehi
X_5435__915 _5435_/RESET_B VPWR VGND sg13cmos5l_tiehi
XFILLER_33_378 VPWR VGND sg13cmos5l_fill_1
XFILLER_34_879 VPWR VGND sg13cmos5l_fill_2
X_4760_ _4760_/X _4759_/B _4759_/C _4759_/A VPWR VGND sg13cmos5l_a21o_1
X_3711_ _3712_/B _3708_/X _3710_/X _3707_/X _3709_/X _3139_/A _3718_/A1 VPWR VGND
+ sg13cmos5l_mux4_1
X_4691_ _4692_/C _4691_/A _4691_/B VPWR VGND sg13cmos5l_nor2_1
X_3642_ _3643_/B _3642_/A _3642_/B _5424_/C VPWR VGND sg13cmos5l_nand3_1
X_3573_ _3573_/Y _3573_/A _3580_/B VPWR VGND sg13cmos5l_nand2_1
X_5312_ _5448_/D _3217_/A _5312_/A1 _5313_/S VPWR VGND sg13cmos5l_mux2_1
XFILLER_46_0 VPWR VGND sg13cmos5l_fill_2
XFILLER_5_290 VPWR VGND sg13cmos5l_decap_8
X_5442__908 _5442_/RESET_B VPWR VGND sg13cmos5l_tiehi
X_5243_ _5243_/Y _5241_/X _5242_/Y _5261_/A VPWR VGND sg13cmos5l_o21ai_1
X_5174_ _6058_/D _5174_/A _5272_/A VPWR VGND sg13cmos5l_nor2_1
X_4125_ _4128_/C _4125_/A _4125_/B VPWR VGND sg13cmos5l_xnor2_1
X_4056_ _4057_/B _4065_/A _4055_/X _4102_/A VPWR VGND sg13cmos5l_o21ai_1
XFILLER_37_662 VPWR VGND sg13cmos5l_fill_1
X_4958_ _4959_/B _5015_/C VPWR VGND sg13cmos5l_inv_1
XFILLER_40_838 VPWR VGND sg13cmos5l_fill_1
X_3909_ _3909_/X _5599_/Q _5573_/Q _3910_/B VPWR VGND sg13cmos5l_mux2_1
X_4889_ _6005_/D _4865_/X _4890_/A _4888_/Y VPWR VGND sg13cmos5l_a21oi_1
XFILLER_10_32 VPWR VGND sg13cmos5l_fill_2
XFILLER_0_956 VPWR VGND sg13cmos5l_decap_8
XFILLER_47_448 VPWR VGND sg13cmos5l_decap_8
X_5491__574 _5491_/RESET_B VPWR VGND sg13cmos5l_tiehi
XFILLER_30_337 VPWR VGND sg13cmos5l_fill_1
XFILLER_2_271 VPWR VGND sg13cmos5l_fill_1
XFILLER_38_415 VPWR VGND sg13cmos5l_fill_2
XFILLER_39_938 VPWR VGND sg13cmos5l_fill_1
X_5930_ _5930_/Q _5994_/CLK _5930_/D _5930_/RESET_B VPWR VGND sg13cmos5l_dfrbpq_1
XFILLER_46_492 VPWR VGND sg13cmos5l_decap_8
XFILLER_34_621 VPWR VGND sg13cmos5l_fill_1
XFILLER_34_632 VPWR VGND sg13cmos5l_fill_1
XFILLER_34_643 VPWR VGND sg13cmos5l_fill_1
X_5861_ _5861_/Q _5894_/CLK _5861_/D _5861_/RESET_B VPWR VGND sg13cmos5l_dfrbpq_1
X_5792_ _5792_/Q _5825_/CLK _5792_/D _5792_/RESET_B VPWR VGND sg13cmos5l_dfrbpq_1
X_4812_ _4812_/Y _4812_/A1 _4809_/Y _4829_/B VPWR VGND sg13cmos5l_o21ai_1
X_4743_ _4743_/Y _4743_/A _4743_/B VPWR VGND sg13cmos5l_nor2_1
X_4674_ _4695_/A _5969_/Q _4685_/B _4688_/A VPWR VGND sg13cmos5l_a21o_1
X_3625_ _5801_/D _5428_/A _5428_/B _5428_/C VPWR VGND sg13cmos5l_nor3_1
X_3556_ _5770_/D _3618_/A1 _3555_/B _3555_/Y VPWR VGND sg13cmos5l_a21oi_1
X_6039__313 _6039_/RESET_B VPWR VGND sg13cmos5l_tiehi
X_3487_ _3487_/Y _5158_/A1 _3490_/B _3486_/Y VPWR VGND sg13cmos5l_o21ai_1
X_5226_ _5228_/B _5226_/A _5226_/B VPWR VGND sg13cmos5l_or2_1
X_5157_ _5157_/Y _5141_/A _5162_/S _5156_/Y VPWR VGND sg13cmos5l_a21oi_1
X_5088_ _5095_/B _6044_/Q _6043_/Q _6041_/Q _6042_/Q VPWR VGND sg13cmos5l_nor4_1
X_4108_ _4108_/Y _4109_/B _3125_/Y _4107_/Y VPWR VGND sg13cmos5l_a21oi_1
X_4039_ _4041_/B _4039_/A1 _4035_/X _4038_/Y VPWR VGND sg13cmos5l_a21oi_1
X_5813__603 _5813_/RESET_B VPWR VGND sg13cmos5l_tiehi
XFILLER_38_971 VPWR VGND sg13cmos5l_fill_1
X_5516__500 _5516_/RESET_B VPWR VGND sg13cmos5l_tiehi
XFILLER_37_481 VPWR VGND sg13cmos5l_decap_8
X_5605__815 _5605_/RESET_B VPWR VGND sg13cmos5l_tiehi
XFILLER_47_223 VPWR VGND sg13cmos5l_fill_1
XFILLER_44_930 VPWR VGND sg13cmos5l_fill_2
XFILLER_44_985 VPWR VGND sg13cmos5l_decap_8
XFILLER_16_654 VPWR VGND sg13cmos5l_fill_1
X_5612__808 _5612_/RESET_B VPWR VGND sg13cmos5l_tiehi
X_4390_ _4390_/Y _4395_/A _4383_/Y _4389_/Y VPWR VGND sg13cmos5l_o21ai_1
X_3410_ _3413_/B _6053_/Q _3411_/B VPWR VGND sg13cmos5l_and2_1
X_3341_ _5648_/D _3341_/A0 _5375_/A0 _3346_/S VPWR VGND sg13cmos5l_mux2_1
X_6060_ _6060_/Q _6061_/CLK _6060_/D _6060_/RESET_B VPWR VGND sg13cmos5l_dfrbpq_1
X_3272_ _5587_/D _3272_/A0 _3391_/A0 _3279_/S VPWR VGND sg13cmos5l_mux2_1
Xhold1008 _5752_/D _3518_/Y VPWR VGND sg13cmos5l_dlygate4sd3_1
X_5011_ _6034_/D _5011_/A _5011_/B VPWR VGND sg13cmos5l_and2_1
XFILLER_23_2 VPWR VGND sg13cmos5l_fill_1
Xhold1019 _4200_/B _5857_/Q VPWR VGND sg13cmos5l_dlygate4sd3_1
XFILLER_39_713 VPWR VGND sg13cmos5l_decap_4
X_5913_ _5913_/Q _5943_/CLK _5913_/D _5913_/RESET_B VPWR VGND sg13cmos5l_dfrbpq_1
X_5844_ _5844_/Q clkload6/A _5844_/D _5844_/RESET_B VPWR VGND sg13cmos5l_dfrbpq_1
XFILLER_34_462 VPWR VGND sg13cmos5l_decap_8
XFILLER_35_996 VPWR VGND sg13cmos5l_fill_1
XFILLER_10_808 VPWR VGND sg13cmos5l_decap_8
X_5775_ _5775_/Q clkload7/A _5775_/D _5775_/RESET_B VPWR VGND sg13cmos5l_dfrbpq_1
XFILLER_21_156 VPWR VGND sg13cmos5l_fill_1
X_4726_ _4726_/Y _5009_/A _4743_/A _4725_/Y _4723_/X VPWR VGND sg13cmos5l_a22oi_1
XFILLER_30_690 VPWR VGND sg13cmos5l_fill_1
X_4657_ _4657_/Y _4657_/A _4657_/B _4657_/C _4657_/D VPWR VGND sg13cmos5l_nand4_1
X_3608_ _3608_/Y _3608_/A _3617_/B VPWR VGND sg13cmos5l_nand2_1
X_4588_ _4588_/Y _4585_/X _4600_/C _4587_/X _4652_/A VPWR VGND sg13cmos5l_a22oi_1
X_3539_ _5761_/D _3613_/A1 _3543_/B _3538_/Y VPWR VGND sg13cmos5l_a21oi_1
X_5209_ _5209_/Y _5174_/A _5206_/X _5207_/X _5208_/X VPWR VGND sg13cmos5l_a22oi_1
Xhold1520 _3191_/A _6070_/Q VPWR VGND sg13cmos5l_dlygate4sd3_1
Xhold1531 _6076_/D _3206_/Y VPWR VGND sg13cmos5l_dlygate4sd3_1
Xhold1542 _4801_/B _6008_/Q VPWR VGND sg13cmos5l_dlygate4sd3_1
Xhold1553 _5870_/D _4179_/Y VPWR VGND sg13cmos5l_dlygate4sd3_1
Xhold1586 _4496_/A _5939_/Q VPWR VGND sg13cmos5l_dlygate4sd3_1
Xhold1575 _4635_/A1 _5956_/Q VPWR VGND sg13cmos5l_dlygate4sd3_1
Xhold1564 _4655_/A _5944_/Q VPWR VGND sg13cmos5l_dlygate4sd3_1
Xhold1597 _4239_/A _5913_/Q VPWR VGND sg13cmos5l_dlygate4sd3_1
XFILLER_13_624 VPWR VGND sg13cmos5l_fill_2
XFILLER_41_999 VPWR VGND sg13cmos5l_fill_2
XFILLER_40_476 VPWR VGND sg13cmos5l_decap_8
X_5900__472 _5900_/RESET_B VPWR VGND sg13cmos5l_tiehi
XFILLER_48_565 VPWR VGND sg13cmos5l_decap_8
XFILLER_35_215 VPWR VGND sg13cmos5l_fill_2
X_6029__323 _6029_/RESET_B VPWR VGND sg13cmos5l_tiehi
X_3890_ _3890_/Y _5473_/Q _3892_/S VPWR VGND sg13cmos5l_nand2b_1
X_5560_ _5560_/Q _5810_/CLK _5560_/D _5560_/RESET_B VPWR VGND sg13cmos5l_dfrbpq_1
X_4511_ _4511_/Y _4512_/B VPWR VGND sg13cmos5l_inv_1
XFILLER_8_683 VPWR VGND sg13cmos5l_fill_2
X_5491_ _5491_/Q _5853_/CLK _5491_/D _5491_/RESET_B VPWR VGND sg13cmos5l_dfrbpq_1
X_4442_ _4442_/Y _5898_/Q _4442_/B _4445_/C VPWR VGND sg13cmos5l_nor3_1
X_4373_ _4373_/X _4584_/A _4396_/A _4372_/Y VPWR VGND sg13cmos5l_a21o_1
X_3324_ _5634_/D _3324_/A0 _5359_/A0 _3326_/S VPWR VGND sg13cmos5l_mux2_1
X_6036__316 _6036_/RESET_B VPWR VGND sg13cmos5l_tiehi
X_3255_ _5576_/D _5302_/A _3255_/A1 _3255_/S VPWR VGND sg13cmos5l_mux2_1
X_6043_ _6043_/Q _6067_/CLK _6043_/D _6043_/RESET_B VPWR VGND sg13cmos5l_dfrbpq_1
X_3186_ _4126_/A _3185_/A _3185_/B _5284_/A VPWR VGND sg13cmos5l_a21oi_1
X_5513__525 _5513_/RESET_B VPWR VGND sg13cmos5l_tiehi
XFILLER_10_616 VPWR VGND sg13cmos5l_fill_1
X_5827_ _5827_/Q _6047_/CLK _5827_/D _5827_/RESET_B VPWR VGND sg13cmos5l_dfrbpq_1
XFILLER_22_465 VPWR VGND sg13cmos5l_decap_8
X_5758_ _5758_/Q clkload7/A _5758_/D _5758_/RESET_B VPWR VGND sg13cmos5l_dfrbpq_1
X_4709_ _4710_/C _4709_/A _4708_/A VPWR VGND sg13cmos5l_nor2b_1
X_5689_ _5689_/Q _5695_/CLK _5689_/D _5689_/RESET_B VPWR VGND sg13cmos5l_dfrbpq_1
X_5602__818 _5602_/RESET_B VPWR VGND sg13cmos5l_tiehi
Xhold1350 _5372_/A1 _5501_/Q VPWR VGND sg13cmos5l_dlygate4sd3_1
Xhold1361 _5331_/A0 _5465_/Q VPWR VGND sg13cmos5l_dlygate4sd3_1
Xhold1383 _3335_/A1 _5643_/Q VPWR VGND sg13cmos5l_dlygate4sd3_1
XFILLER_27_41 VPWR VGND sg13cmos5l_fill_2
Xhold1372 _3348_/A1 _5654_/Q VPWR VGND sg13cmos5l_dlygate4sd3_1
Xhold1394 _5306_/A1 _5442_/Q VPWR VGND sg13cmos5l_dlygate4sd3_1
XFILLER_45_579 VPWR VGND sg13cmos5l_decap_4
XFILLER_14_955 VPWR VGND sg13cmos5l_fill_2
XFILLER_9_425 VPWR VGND sg13cmos5l_fill_1
XFILLER_41_796 VPWR VGND sg13cmos5l_decap_8
XFILLER_49_841 VPWR VGND sg13cmos5l_fill_1
XFILLER_36_502 VPWR VGND sg13cmos5l_fill_2
X_4991_ _4992_/B _5137_/B _4987_/X _5011_/B VPWR VGND sg13cmos5l_o21ai_1
X_3942_ _3943_/A _5630_/Q _5613_/Q _5588_/Q _5579_/Q _3178_/A _4086_/A1 VPWR VGND
+ sg13cmos5l_mux4_1
XFILLER_17_793 VPWR VGND sg13cmos5l_fill_1
XFILLER_31_262 VPWR VGND sg13cmos5l_decap_4
X_3873_ _3873_/X _5552_/Q _5535_/Q _5518_/Q _5501_/Q _4100_/S0 _4100_/S1 VPWR VGND
+ sg13cmos5l_mux4_1
X_5612_ _5612_/Q clkload5/A _5612_/D _5612_/RESET_B VPWR VGND sg13cmos5l_dfrbpq_1
XFILLER_20_936 VPWR VGND sg13cmos5l_fill_2
X_5543_ _5543_/Q _5810_/CLK _5543_/D _5543_/RESET_B VPWR VGND sg13cmos5l_dfrbpq_1
X_5474_ _5474_/Q _5853_/CLK _5474_/D _5474_/RESET_B VPWR VGND sg13cmos5l_dfrbpq_1
X_4425_ _5920_/D _4460_/A _4425_/B VPWR VGND sg13cmos5l_nor2_1
X_4356_ _5912_/D _4330_/Y _4356_/A2 _4314_/B VPWR VGND sg13cmos5l_a21oi_1
X_3307_ _5619_/D _3307_/A0 _5408_/A1 _3307_/S VPWR VGND sg13cmos5l_mux2_1
XFILLER_24_1009 VPWR VGND sg13cmos5l_decap_4
X_4287_ _4287_/Y _5872_/Q _4287_/B VPWR VGND sg13cmos5l_nor2_1
X_3238_ _5565_/D _3238_/A0 _5423_/A1 _3241_/S VPWR VGND sg13cmos5l_mux2_1
X_6026_ _6026_/Q _6056_/CLK _6026_/D _6026_/RESET_B VPWR VGND sg13cmos5l_dfrbpq_1
X_3169_ _3169_/X _5568_/Q _5551_/Q _5534_/Q _5517_/Q _3172_/S _4076_/S1 VPWR VGND
+ sg13cmos5l_mux4_1
XFILLER_42_516 VPWR VGND sg13cmos5l_fill_2
XFILLER_42_505 VPWR VGND sg13cmos5l_decap_8
X_5517__480 _5517_/RESET_B VPWR VGND sg13cmos5l_tiehi
Xfanout22 _4471_/A2 _4186_/A2 VPWR VGND sg13cmos5l_buf_1
Xfanout33 _3498_/B _3495_/Y VPWR VGND sg13cmos5l_buf_1
Xfanout55 _3388_/S _3387_/S VPWR VGND sg13cmos5l_buf_1
Xfanout44 _5313_/S _5311_/S VPWR VGND sg13cmos5l_buf_1
XFILLER_10_424 VPWR VGND sg13cmos5l_fill_1
Xfanout99 _3615_/A1 _5162_/A1 VPWR VGND sg13cmos5l_buf_1
Xfanout66 _5399_/A _5361_/C VPWR VGND sg13cmos5l_buf_1
Xfanout77 _5352_/C _3221_/Y VPWR VGND sg13cmos5l_buf_1
Xfanout88 _4523_/A _4358_/Y VPWR VGND sg13cmos5l_buf_1
X_5821__587 _5821_/RESET_B VPWR VGND sg13cmos5l_tiehi
XFILLER_1_111 VPWR VGND sg13cmos5l_fill_1
XFILLER_46_833 VPWR VGND sg13cmos5l_decap_4
Xhold1180 _3063_/A _6025_/Q VPWR VGND sg13cmos5l_dlygate4sd3_1
Xhold1191 _5401_/A0 _5527_/Q VPWR VGND sg13cmos5l_dlygate4sd3_1
XFILLER_33_538 VPWR VGND sg13cmos5l_fill_2
XFILLER_14_774 VPWR VGND sg13cmos5l_fill_1
XFILLER_41_593 VPWR VGND sg13cmos5l_fill_2
XFILLER_13_284 VPWR VGND sg13cmos5l_fill_2
XFILLER_14_785 VPWR VGND sg13cmos5l_fill_2
Xclkload25 clkload25/Y _5973_/CLK VPWR VGND sg13cmos5l_inv_1
Xclkload14 clkload14/Y _5695_/CLK VPWR VGND sg13cmos5l_inv_1
XFILLER_48_4 VPWR VGND sg13cmos5l_fill_2
X_4210_ _4211_/B _4210_/A _4210_/B VPWR VGND sg13cmos5l_xnor2_1
X_5190_ _5253_/B _6060_/Q _5190_/B VPWR VGND sg13cmos5l_nand2_1
X_6033__319 _6033_/RESET_B VPWR VGND sg13cmos5l_tiehi
X_4141_ _4141_/Y _5884_/Q _5862_/Q _4139_/Y VPWR VGND sg13cmos5l_a21oi_1
XFILLER_49_660 VPWR VGND sg13cmos5l_fill_1
X_4072_ _4072_/Y _4065_/A _4069_/X _4102_/A VPWR VGND sg13cmos5l_o21ai_1
X_4974_ _4974_/Y _5989_/Q _4974_/B VPWR VGND sg13cmos5l_nand2_1
X_3925_ _3925_/Y _3918_/Y _3924_/Y _3916_/Y VPWR VGND sg13cmos5l_o21ai_1
XFILLER_32_571 VPWR VGND sg13cmos5l_fill_2
Xclkload8 clkload8/Y clkload8/A VPWR VGND sg13cmos5l_inv_4
X_3856_ _3856_/Y _3852_/A _3849_/A _3852_/Y _3847_/A _3851_/B VPWR VGND sg13cmos5l_a221oi_1
X_3787_ _3787_/Y _5818_/Q _3783_/B _3784_/Y VPWR VGND sg13cmos5l_a21oi_1
X_5526_ _5526_/Q clkload1/A _5526_/D _5526_/RESET_B VPWR VGND sg13cmos5l_dfrbpq_1
X_5457_ _5457_/Q _5853_/CLK _5457_/D _5457_/RESET_B VPWR VGND sg13cmos5l_dfrbpq_1
X_4408_ _4426_/B _5891_/Q _5892_/Q _5893_/Q VPWR VGND sg13cmos5l_o21ai_1
Xfanout223 _5408_/A1 _5370_/A1 VPWR VGND sg13cmos5l_buf_1
Xfanout201 _6074_/D _3110_/Y VPWR VGND sg13cmos5l_buf_1
X_5388_ _5516_/D _5388_/A0 _3217_/A _5388_/S VPWR VGND sg13cmos5l_mux2_1
Xfanout212 _5412_/A0 input8/X VPWR VGND sg13cmos5l_buf_1
Xfanout234 _3374_/A fanout235/X VPWR VGND sg13cmos5l_buf_1
X_4339_ _4339_/Y _4341_/A _4273_/B _4338_/Y VPWR VGND sg13cmos5l_o21ai_1
Xfanout245 _3394_/A0 input10/X VPWR VGND sg13cmos5l_buf_1
Xfanout256 _5007_/A _4998_/A VPWR VGND sg13cmos5l_buf_1
X_6009_ _6009_/Q _6061_/CLK _6009_/D _6009_/RESET_B VPWR VGND sg13cmos5l_dfrbpq_1
XFILLER_28_888 VPWR VGND sg13cmos5l_decap_8
XFILLER_42_335 VPWR VGND sg13cmos5l_decap_4
XFILLER_7_704 VPWR VGND sg13cmos5l_fill_1
XFILLER_6_247 VPWR VGND sg13cmos5l_fill_2
XFILLER_6_0 VPWR VGND sg13cmos5l_fill_1
XFILLER_3_932 VPWR VGND sg13cmos5l_decap_4
XFILLER_33_324 VPWR VGND sg13cmos5l_decap_4
X_3710_ _3710_/X _5750_/Q _5744_/Q _3710_/S VPWR VGND sg13cmos5l_mux2_1
X_4690_ _4692_/B _4697_/B _4688_/X VPWR VGND sg13cmos5l_nor2b_1
X_3641_ _3641_/Y _5821_/Q _5424_/C _3642_/A VPWR VGND sg13cmos5l_a21oi_1
X_3572_ _5777_/D _3609_/A1 _3580_/B _3571_/Y VPWR VGND sg13cmos5l_o21ai_1
X_5311_ _5447_/D _5416_/A0 _5311_/A1 _5311_/S VPWR VGND sg13cmos5l_mux2_1
X_5242_ _5242_/Y _5241_/B _5241_/C _5108_/A VPWR VGND sg13cmos5l_a21oi_1
X_5173_ _5173_/X _5173_/A _5176_/B VPWR VGND sg13cmos5l_and2_1
XFILLER_39_0 VPWR VGND sg13cmos5l_fill_2
X_4124_ _4128_/B _4124_/A _4124_/B VPWR VGND sg13cmos5l_nand2_1
Xinput1 input1/X rst_n VPWR VGND sg13cmos5l_buf_1
X_4055_ _4055_/X _5493_/Q _5476_/Q _5459_/Q _5442_/Q _4109_/B _4111_/A1 VPWR VGND
+ sg13cmos5l_mux4_1
X_4957_ _5015_/C _4949_/Y _4742_/B _4957_/S VPWR VGND sg13cmos5l_mux2_1
X_3908_ _3908_/Y _4003_/A _5842_/Q VPWR VGND sg13cmos5l_nor2b_1
X_4888_ _4888_/Y _4866_/A _4890_/A _4783_/A VPWR VGND sg13cmos5l_o21ai_1
X_3839_ _3840_/D _4003_/A _3838_/A _3839_/B1 VPWR VGND sg13cmos5l_a21oi_1
X_5509_ _5509_/Q _5810_/CLK _5509_/D _5509_/RESET_B VPWR VGND sg13cmos5l_dfrbpq_1
XFILLER_0_935 VPWR VGND sg13cmos5l_decap_8
XFILLER_47_427 VPWR VGND sg13cmos5l_decap_8
XFILLER_43_655 VPWR VGND sg13cmos5l_fill_2
XFILLER_31_817 VPWR VGND sg13cmos5l_fill_2
XFILLER_7_545 VPWR VGND sg13cmos5l_fill_1
X_5545__944 _5545_/RESET_B VPWR VGND sg13cmos5l_tiehi
XFILLER_25_6 VPWR VGND sg13cmos5l_fill_1
XFILLER_38_427 VPWR VGND sg13cmos5l_fill_2
XFILLER_18_140 VPWR VGND sg13cmos5l_fill_1
XFILLER_19_663 VPWR VGND sg13cmos5l_fill_1
XFILLER_46_471 VPWR VGND sg13cmos5l_decap_8
X_5860_ _5860_/Q _5860_/CLK _5860_/D _5860_/RESET_B VPWR VGND sg13cmos5l_dfrbpq_1
X_4811_ _4811_/Y _4794_/Y _4809_/Y _4810_/Y VPWR VGND sg13cmos5l_a21oi_1
X_5791_ _5791_/Q _5822_/CLK _5791_/D _5791_/RESET_B VPWR VGND sg13cmos5l_dfrbpq_1
X_4742_ _4742_/X _4742_/A _4742_/B VPWR VGND sg13cmos5l_and2_1
X_4673_ _4688_/A _4687_/A _4687_/B _4687_/C VPWR VGND sg13cmos5l_a21oi_1
X_3624_ _5428_/C _3624_/A _3798_/A VPWR VGND sg13cmos5l_and2_1
X_3555_ _3555_/Y _3555_/A _3555_/B VPWR VGND sg13cmos5l_nor2_1
X_3486_ _3486_/Y _3486_/A _3490_/B VPWR VGND sg13cmos5l_nand2_1
X_5225_ _5228_/A _5226_/B _5225_/B VPWR VGND sg13cmos5l_nand2_1
XFILLER_5_1028 VPWR VGND sg13cmos5l_fill_1
X_5156_ _5156_/Y _5141_/B _5162_/S _5176_/B VPWR VGND sg13cmos5l_o21ai_1
X_5087_ _5119_/A _5093_/B _5087_/B VPWR VGND sg13cmos5l_nand2b_1
X_4107_ _4107_/Y _4109_/B _5465_/Q _4107_/B1 VPWR VGND sg13cmos5l_o21ai_1
X_4038_ _4038_/Y _4040_/S1 _4037_/Y _4042_/A1 VPWR VGND sg13cmos5l_o21ai_1
XFILLER_37_460 VPWR VGND sg13cmos5l_decap_8
XFILLER_24_143 VPWR VGND sg13cmos5l_fill_2
X_5989_ _5989_/Q _6056_/CLK _5989_/D _5989_/RESET_B VPWR VGND sg13cmos5l_dfrbpq_1
XFILLER_0_710 VPWR VGND sg13cmos5l_fill_1
XFILLER_0_765 VPWR VGND sg13cmos5l_fill_2
XFILLER_29_961 VPWR VGND sg13cmos5l_decap_4
XFILLER_43_496 VPWR VGND sg13cmos5l_decap_8
XFILLER_16_699 VPWR VGND sg13cmos5l_fill_1
XFILLER_31_614 VPWR VGND sg13cmos5l_fill_2
XFILLER_30_179 VPWR VGND sg13cmos5l_fill_1
XFILLER_8_876 VPWR VGND sg13cmos5l_decap_4
X_3340_ _5647_/D _3340_/A0 _5420_/A1 _3346_/S VPWR VGND sg13cmos5l_mux2_1
X_3271_ _5586_/D _3271_/A0 _5353_/A0 _3279_/S VPWR VGND sg13cmos5l_mux2_1
X_5010_ _6033_/D _5010_/A _5071_/A VPWR VGND sg13cmos5l_nor2_1
Xhold1009 _3418_/A _5705_/Q VPWR VGND sg13cmos5l_dlygate4sd3_1
X_5912_ _5912_/Q _5936_/CLK _5912_/D _5912_/RESET_B VPWR VGND sg13cmos5l_dfrbpq_1
X_5843_ _5843_/Q clkload6/A _5843_/D _5843_/RESET_B VPWR VGND sg13cmos5l_dfrbpq_1
X_5774_ _5774_/Q _5834_/CLK _5774_/D _5774_/RESET_B VPWR VGND sg13cmos5l_dfrbpq_1
X_4725_ _4725_/Y _4785_/A _5978_/Q VPWR VGND sg13cmos5l_nand2_1
X_4656_ _4656_/Y _4656_/A _4656_/B _4656_/C _4656_/D VPWR VGND sg13cmos5l_nand4_1
X_4587_ _4587_/X _5940_/Q _5920_/Q _5919_/Q VPWR VGND sg13cmos5l_or3_1
X_3607_ _3616_/S _3607_/A _3607_/B VPWR VGND sg13cmos5l_nand2_1
X_3538_ _3538_/Y _3538_/A _3543_/B VPWR VGND sg13cmos5l_nor2_1
XFILLER_27_1007 VPWR VGND sg13cmos5l_fill_2
XFILLER_27_1018 VPWR VGND sg13cmos5l_fill_2
X_3469_ _5728_/D _3518_/A1 _3468_/B _3468_/Y VPWR VGND sg13cmos5l_o21ai_1
X_5208_ _5208_/X _6036_/Q _6014_/Q VPWR VGND sg13cmos5l_or2_1
Xhold1510 _5958_/D _4640_/Y VPWR VGND sg13cmos5l_dlygate4sd3_1
Xhold1532 _4456_/A1 _5924_/Q VPWR VGND sg13cmos5l_dlygate4sd3_1
X_5139_ _5140_/B _5137_/Y _5138_/Y _5148_/B VPWR VGND sg13cmos5l_mux2_1
Xhold1521 _5283_/A2 _5282_/Y VPWR VGND sg13cmos5l_dlygate4sd3_1
Xhold1543 _4615_/B _5974_/Q VPWR VGND sg13cmos5l_dlygate4sd3_1
Xhold1554 _4299_/B _5897_/Q VPWR VGND sg13cmos5l_dlygate4sd3_1
Xhold1565 _4812_/A1 _5988_/Q VPWR VGND sg13cmos5l_dlygate4sd3_1
Xhold1576 _5956_/D _4636_/Y VPWR VGND sg13cmos5l_dlygate4sd3_1
Xhold1587 _4524_/A2 _4495_/A VPWR VGND sg13cmos5l_dlygate4sd3_1
Xhold1598 _4334_/A _5907_/Q VPWR VGND sg13cmos5l_dlygate4sd3_1
X_5963__401 _5963_/RESET_B VPWR VGND sg13cmos5l_tiehi
XFILLER_40_455 VPWR VGND sg13cmos5l_decap_8
XFILLER_5_813 VPWR VGND sg13cmos5l_fill_2
XFILLER_10_1000 VPWR VGND sg13cmos5l_fill_2
XFILLER_4_334 VPWR VGND sg13cmos5l_fill_2
XFILLER_48_544 VPWR VGND sg13cmos5l_decap_8
XFILLER_36_706 VPWR VGND sg13cmos5l_decap_4
XFILLER_36_728 VPWR VGND sg13cmos5l_decap_8
XFILLER_36_739 VPWR VGND sg13cmos5l_fill_2
X_5831__567 _5831_/RESET_B VPWR VGND sg13cmos5l_tiehi
XFILLER_17_964 VPWR VGND sg13cmos5l_fill_1
XFILLER_44_794 VPWR VGND sg13cmos5l_fill_1
XFILLER_17_986 VPWR VGND sg13cmos5l_fill_2
X_4510_ _4512_/B _4510_/A _4510_/B _4510_/C VPWR VGND sg13cmos5l_nor3_1
X_5490_ _5490_/Q clkload6/A _5490_/D _5490_/RESET_B VPWR VGND sg13cmos5l_dfrbpq_1
X_4441_ _4441_/Y _5926_/Q _4441_/B VPWR VGND sg13cmos5l_nand2b_1
XFILLER_7_194 VPWR VGND sg13cmos5l_fill_2
X_4372_ _4372_/Y _5941_/Q _4370_/Y _4371_/Y _4369_/Y VPWR VGND sg13cmos5l_a22oi_1
X_3323_ _5633_/D _3323_/A0 _3384_/A _3326_/S VPWR VGND sg13cmos5l_mux2_1
X_5506__544 _5506_/RESET_B VPWR VGND sg13cmos5l_tiehi
X_3254_ _5575_/D _3114_/Y _3255_/S _3253_/Y VPWR VGND sg13cmos5l_a21oi_1
X_6042_ _6042_/Q _6067_/CLK _6042_/D _6042_/RESET_B VPWR VGND sg13cmos5l_dfrbpq_1
XFILLER_21_0 VPWR VGND sg13cmos5l_fill_2
XFILLER_39_500 VPWR VGND sg13cmos5l_fill_1
X_3185_ _5285_/C _3185_/A _3185_/B VPWR VGND sg13cmos5l_nand2_1
XFILLER_23_923 VPWR VGND sg13cmos5l_fill_2
XFILLER_35_783 VPWR VGND sg13cmos5l_fill_2
XFILLER_22_444 VPWR VGND sg13cmos5l_decap_8
XFILLER_23_956 VPWR VGND sg13cmos5l_fill_1
X_5826_ _5826_/Q _6047_/CLK _5826_/D _5826_/RESET_B VPWR VGND sg13cmos5l_dfrbpq_1
XFILLER_33_1011 VPWR VGND sg13cmos5l_decap_8
X_5757_ _5757_/Q _5834_/CLK _5757_/D _5757_/RESET_B VPWR VGND sg13cmos5l_dfrbpq_1
X_4708_ _4710_/B _4708_/A _4696_/Y VPWR VGND sg13cmos5l_nor2b_1
X_5688_ _5688_/Q _5840_/CLK _5688_/D _5688_/RESET_B VPWR VGND sg13cmos5l_dfrbpq_1
XFILLER_2_805 VPWR VGND sg13cmos5l_fill_2
X_4639_ _4639_/Y _4639_/A _4639_/B VPWR VGND sg13cmos5l_nand2_1
XFILLER_2_838 VPWR VGND sg13cmos5l_fill_2
Xhold1340 _3542_/A0 _5763_/Q VPWR VGND sg13cmos5l_dlygate4sd3_1
Xhold1351 _3258_/A0 _5578_/Q VPWR VGND sg13cmos5l_dlygate4sd3_1
XFILLER_27_20 VPWR VGND sg13cmos5l_fill_1
Xhold1373 _5382_/A0 _5510_/Q VPWR VGND sg13cmos5l_dlygate4sd3_1
Xhold1395 _5296_/A0 _5435_/Q VPWR VGND sg13cmos5l_dlygate4sd3_1
XFILLER_27_53 VPWR VGND sg13cmos5l_fill_1
Xhold1362 _5356_/A1 _5487_/Q VPWR VGND sg13cmos5l_dlygate4sd3_1
Xhold1384 _5362_/A0 _5492_/Q VPWR VGND sg13cmos5l_dlygate4sd3_1
XFILLER_27_64 VPWR VGND sg13cmos5l_fill_2
XFILLER_14_989 VPWR VGND sg13cmos5l_decap_8
XFILLER_4_142 VPWR VGND sg13cmos5l_fill_1
XFILLER_4_164 VPWR VGND sg13cmos5l_fill_2
XFILLER_4_197 VPWR VGND sg13cmos5l_fill_2
X_6054__940 _6054_/RESET_B VPWR VGND sg13cmos5l_tiehi
XFILLER_49_875 VPWR VGND sg13cmos5l_decap_4
X_4990_ _4992_/A _4990_/A _4987_/X VPWR VGND sg13cmos5l_nor2b_1
X_3941_ _3941_/Y _4065_/A _3940_/X _3931_/A VPWR VGND sg13cmos5l_o21ai_1
X_3872_ _3872_/Y _3872_/A VPWR VGND sg13cmos5l_inv_1
XFILLER_31_230 VPWR VGND sg13cmos5l_fill_1
X_5611_ _5611_/Q clkload3/A _5611_/D _5611_/RESET_B VPWR VGND sg13cmos5l_dfrbpq_1
X_5542_ _5542_/Q _5559_/CLK _5542_/D _5542_/RESET_B VPWR VGND sg13cmos5l_dfrbpq_1
X_5473_ _5473_/Q clkload6/A _5473_/D _5473_/RESET_B VPWR VGND sg13cmos5l_dfrbpq_1
X_4424_ _4425_/B _4407_/Y _4419_/B _4423_/X VPWR VGND sg13cmos5l_a21oi_1
X_4355_ _5911_/D _4355_/A1 _4350_/Y _4354_/Y VPWR VGND sg13cmos5l_a21oi_1
X_3306_ _5618_/D _3306_/A0 _5322_/A1 _3306_/S VPWR VGND sg13cmos5l_mux2_1
X_4286_ _4286_/Y _5913_/Q _5910_/Q VPWR VGND sg13cmos5l_nor2b_1
X_3237_ _5564_/D _3237_/A0 _3382_/A _3241_/S VPWR VGND sg13cmos5l_mux2_1
X_6025_ _6025_/Q _6077_/CLK _6025_/D _6025_/RESET_B VPWR VGND sg13cmos5l_dfrbpq_1
X_3168_ _3171_/A _4107_/B1 _3164_/X _3167_/Y VPWR VGND sg13cmos5l_a21oi_1
X_3099_ _5147_/A _6065_/Q VPWR VGND sg13cmos5l_inv_1
Xfanout34 _3481_/B _3480_/S VPWR VGND sg13cmos5l_buf_1
Xfanout45 _3617_/B _3616_/S VPWR VGND sg13cmos5l_buf_1
XFILLER_22_241 VPWR VGND sg13cmos5l_decap_8
Xfanout56 _3365_/S _3364_/S VPWR VGND sg13cmos5l_buf_1
Xfanout23 _4186_/A2 _3865_/Y VPWR VGND sg13cmos5l_buf_1
X_5809_ _5809_/Q clkload8/A _5809_/D _5809_/RESET_B VPWR VGND sg13cmos5l_dfrbpq_1
XFILLER_11_948 VPWR VGND sg13cmos5l_decap_4
Xfanout78 _5272_/A _5266_/A VPWR VGND sg13cmos5l_buf_1
Xfanout67 _5361_/C _3209_/Y VPWR VGND sg13cmos5l_buf_1
Xfanout89 _4314_/B _4298_/A VPWR VGND sg13cmos5l_buf_1
XFILLER_2_602 VPWR VGND sg13cmos5l_fill_1
X_5717__703 _5717_/RESET_B VPWR VGND sg13cmos5l_tiehi
X_5576__851 _5576_/RESET_B VPWR VGND sg13cmos5l_tiehi
Xhold1170 _3062_/A _6026_/Q VPWR VGND sg13cmos5l_dlygate4sd3_1
Xhold1181 _6054_/D _5168_/Y VPWR VGND sg13cmos5l_dlygate4sd3_1
XFILLER_18_547 VPWR VGND sg13cmos5l_fill_2
Xhold1192 _5341_/A0 _5474_/Q VPWR VGND sg13cmos5l_dlygate4sd3_1
XFILLER_45_366 VPWR VGND sg13cmos5l_decap_4
Xclkload26 clkload26/X _6005_/CLK VPWR VGND sg13cmos5l_buf_8
Xclkload15 clkload15/Y _5860_/CLK VPWR VGND sg13cmos5l_inv_1
X_5583__844 _5583_/RESET_B VPWR VGND sg13cmos5l_tiehi
XFILLER_6_996 VPWR VGND sg13cmos5l_fill_2
X_4140_ _4153_/A _5861_/Q _5862_/Q VPWR VGND sg13cmos5l_xor2_1
XFILLER_49_650 VPWR VGND sg13cmos5l_fill_2
X_4071_ _4071_/Y _4071_/A _4071_/B VPWR VGND sg13cmos5l_nor2_1
X_5536__334 _5536_/RESET_B VPWR VGND sg13cmos5l_tiehi
X_4973_ _4980_/B _4974_/B _4970_/Y _4977_/C _4972_/Y VPWR VGND sg13cmos5l_a22oi_1
X_3924_ _3924_/Y _3922_/Y _3923_/Y _3881_/A VPWR VGND sg13cmos5l_o21ai_1
XFILLER_32_583 VPWR VGND sg13cmos5l_fill_2
XFILLER_20_756 VPWR VGND sg13cmos5l_fill_1
Xclkload9 clkload9/Y clkload9/A VPWR VGND sg13cmos5l_inv_2
X_3855_ _3855_/Y _3850_/Y _4129_/A2 _3857_/A VPWR VGND sg13cmos5l_a21oi_1
X_3786_ _3786_/Y _3786_/A1 _3783_/Y _3785_/Y VPWR VGND sg13cmos5l_a21oi_1
X_5525_ _5525_/Q _5559_/CLK _5525_/D _5525_/RESET_B VPWR VGND sg13cmos5l_dfrbpq_1
X_5456_ _5456_/Q clkload6/A _5456_/D _5456_/RESET_B VPWR VGND sg13cmos5l_dfrbpq_1
X_4407_ _4407_/Y _4407_/A _4407_/B VPWR VGND sg13cmos5l_xnor2_1
Xfanout202 _5421_/A1 input9/X VPWR VGND sg13cmos5l_buf_1
Xfanout213 _5419_/A1 _5373_/A0 VPWR VGND sg13cmos5l_buf_1
X_5387_ _5515_/D _5387_/A0 _3215_/A _5389_/S VPWR VGND sg13cmos5l_mux2_1
Xfanout235 fanout235/X input12/X VPWR VGND sg13cmos5l_buf_1
X_4338_ _4338_/Y _4336_/B _4338_/B VPWR VGND sg13cmos5l_nand2b_1
Xfanout224 _3407_/A0 _5370_/A1 VPWR VGND sg13cmos5l_buf_1
Xfanout246 _3220_/C _3779_/B1 VPWR VGND sg13cmos5l_buf_1
X_4269_ _4343_/A _4269_/A _4269_/B VPWR VGND sg13cmos5l_and2_1
Xfanout257 _4998_/A _5006_/A VPWR VGND sg13cmos5l_buf_1
X_6008_ _6008_/Q _6037_/CLK _6008_/D _6008_/RESET_B VPWR VGND sg13cmos5l_dfrbpq_1
XFILLER_42_369 VPWR VGND sg13cmos5l_fill_1
XFILLER_10_244 VPWR VGND sg13cmos5l_fill_1
XFILLER_3_911 VPWR VGND sg13cmos5l_decap_8
XFILLER_3_988 VPWR VGND sg13cmos5l_decap_8
X_6032__320 _6032_/RESET_B VPWR VGND sg13cmos5l_tiehi
XFILLER_19_845 VPWR VGND sg13cmos5l_fill_2
XFILLER_46_675 VPWR VGND sg13cmos5l_decap_8
XFILLER_18_377 VPWR VGND sg13cmos5l_decap_4
XFILLER_42_892 VPWR VGND sg13cmos5l_decap_8
XFILLER_14_1009 VPWR VGND sg13cmos5l_decap_8
X_3640_ _5806_/D _5429_/A _5425_/B VPWR VGND sg13cmos5l_nor2_1
X_3571_ _3571_/Y _3571_/A _3580_/B VPWR VGND sg13cmos5l_nand2_1
X_5310_ _5446_/D _5367_/A1 _5310_/A1 _5313_/S VPWR VGND sg13cmos5l_mux2_1
X_5241_ _5241_/X _5241_/A _5241_/B _5241_/C VPWR VGND sg13cmos5l_and3_1
X_5172_ _6056_/D _3061_/Y _5172_/A2 _5171_/Y VPWR VGND sg13cmos5l_a21oi_1
X_4123_ _4126_/B _4124_/A _4124_/B VPWR VGND sg13cmos5l_nor2_1
X_4054_ _4057_/A _4061_/A _4054_/B VPWR VGND sg13cmos5l_nor2_1
XFILLER_28_119 VPWR VGND sg13cmos5l_fill_2
Xinput2 input2/X ui_in[0] VPWR VGND sg13cmos5l_buf_1
XFILLER_25_804 VPWR VGND sg13cmos5l_decap_8
XFILLER_36_130 VPWR VGND sg13cmos5l_fill_2
X_4956_ _6014_/D _5071_/A _4956_/B VPWR VGND sg13cmos5l_nor2_1
X_4887_ _6004_/D _4844_/X _4890_/A _4886_/Y VPWR VGND sg13cmos5l_a21oi_1
X_3907_ _3907_/Y _3894_/Y _3895_/Y _3906_/Y VPWR VGND sg13cmos5l_o21ai_1
X_3838_ _3843_/A _3838_/A _3838_/B VPWR VGND sg13cmos5l_nor2_1
X_5707__713 _5707_/RESET_B VPWR VGND sg13cmos5l_tiehi
X_5508_ _5508_/Q _5692_/CLK _5508_/D _5508_/RESET_B VPWR VGND sg13cmos5l_dfrbpq_1
X_3769_ _3769_/Y _3772_/A _3773_/A _3220_/C VPWR VGND sg13cmos5l_o21ai_1
X_5566__861 _5566_/RESET_B VPWR VGND sg13cmos5l_tiehi
X_5439_ _5439_/Q clkload6/A _5439_/D _5439_/RESET_B VPWR VGND sg13cmos5l_dfrbpq_1
XFILLER_48_929 VPWR VGND sg13cmos5l_decap_8
XFILLER_47_406 VPWR VGND sg13cmos5l_decap_8
X_5714__706 _5714_/RESET_B VPWR VGND sg13cmos5l_tiehi
X_5573__854 _5573_/RESET_B VPWR VGND sg13cmos5l_tiehi
XFILLER_15_347 VPWR VGND sg13cmos5l_fill_2
XFILLER_35_64 VPWR VGND sg13cmos5l_fill_1
XFILLER_11_564 VPWR VGND sg13cmos5l_fill_1
X_5580__847 _5580_/RESET_B VPWR VGND sg13cmos5l_tiehi
XFILLER_47_984 VPWR VGND sg13cmos5l_decap_8
XFILLER_46_450 VPWR VGND sg13cmos5l_decap_8
XFILLER_19_697 VPWR VGND sg13cmos5l_fill_1
X_4810_ _4810_/Y _4810_/A1 _4809_/Y _4829_/B VPWR VGND sg13cmos5l_o21ai_1
X_5790_ _5790_/Q clkload7/A _5790_/D _5790_/RESET_B VPWR VGND sg13cmos5l_dfrbpq_1
X_6067__279 _6067_/D VPWR VGND sg13cmos5l_tielo
X_4741_ _4742_/B _5009_/A _4750_/A VPWR VGND sg13cmos5l_and2_1
X_4672_ _4687_/C _5969_/Q _4685_/B VPWR VGND sg13cmos5l_xnor2_1
X_3623_ _5428_/B _3624_/A _3798_/A VPWR VGND sg13cmos5l_nor2_1
X_3554_ _3554_/X _3554_/A0 _3591_/A _3554_/S VPWR VGND sg13cmos5l_mux2_1
X_5841__547 _5841_/RESET_B VPWR VGND sg13cmos5l_tiehi
X_3485_ _3485_/Y _3509_/A1 _3490_/B _3484_/Y VPWR VGND sg13cmos5l_o21ai_1
X_5224_ _5225_/B _5204_/Y _5231_/C _5218_/B VPWR VGND sg13cmos5l_o21ai_1
X_5155_ _5162_/S _5151_/Y _5153_/Y _5154_/Y VPWR VGND sg13cmos5l_a21oi_1
XFILLER_5_1007 VPWR VGND sg13cmos5l_decap_8
X_5086_ _5087_/B _6064_/Q _5138_/B _6065_/Q VPWR VGND sg13cmos5l_o21ai_1
X_4106_ _4106_/Y _4107_/B1 _4105_/X _3918_/A VPWR VGND sg13cmos5l_a21oi_1
XFILLER_38_984 VPWR VGND sg13cmos5l_fill_1
X_4037_ _4037_/Y _4036_/B _5627_/Q _4036_/Y VPWR VGND sg13cmos5l_o21ai_1
XFILLER_24_100 VPWR VGND sg13cmos5l_fill_2
X_5988_ _5988_/Q _6037_/CLK _5988_/D _5988_/RESET_B VPWR VGND sg13cmos5l_dfrbpq_1
X_4939_ _6012_/D _4964_/A _5053_/A VPWR VGND sg13cmos5l_nor2_1
XFILLER_24_188 VPWR VGND sg13cmos5l_fill_1
XFILLER_21_66 VPWR VGND sg13cmos5l_fill_1
X_5957__409 _5957_/RESET_B VPWR VGND sg13cmos5l_tiehi
XFILLER_43_1024 VPWR VGND sg13cmos5l_decap_4
X_5959__291 _5959_/D VPWR VGND sg13cmos5l_tielo
XFILLER_16_623 VPWR VGND sg13cmos5l_fill_2
XFILLER_15_144 VPWR VGND sg13cmos5l_fill_2
XFILLER_43_475 VPWR VGND sg13cmos5l_decap_8
XFILLER_8_855 VPWR VGND sg13cmos5l_decap_8
XFILLER_7_332 VPWR VGND sg13cmos5l_fill_1
XFILLER_12_884 VPWR VGND sg13cmos5l_fill_2
X_3270_ _3278_/S _5361_/C _3317_/D _5399_/C VPWR VGND sg13cmos5l_nor3_1
XFILLER_19_461 VPWR VGND sg13cmos5l_fill_1
X_5911_ _5911_/Q _5936_/CLK _5911_/D _5911_/RESET_B VPWR VGND sg13cmos5l_dfrbpq_1
X_5556__871 _5556_/RESET_B VPWR VGND sg13cmos5l_tiehi
X_5842_ _5842_/Q clkload6/A _5842_/D _5842_/RESET_B VPWR VGND sg13cmos5l_dfrbpq_1
X_5773_ _5773_/Q _6074_/CLK _5773_/D _5773_/RESET_B VPWR VGND sg13cmos5l_dfrbpq_1
X_4724_ _4743_/A _5978_/Q _5977_/Q VPWR VGND sg13cmos5l_xor2_1
X_4655_ _5971_/D _4655_/A _4655_/B VPWR VGND sg13cmos5l_and2_1
X_4586_ _4600_/C _5920_/Q _5919_/Q VPWR VGND sg13cmos5l_xor2_1
X_3606_ _5794_/D _3618_/A1 _3605_/B _3605_/Y VPWR VGND sg13cmos5l_o21ai_1
X_5704__716 _5704_/RESET_B VPWR VGND sg13cmos5l_tiehi
X_5563__864 _5563_/RESET_B VPWR VGND sg13cmos5l_tiehi
X_3537_ _5760_/D _3611_/A1 _3543_/B _3536_/Y VPWR VGND sg13cmos5l_a21oi_1
X_3468_ _3468_/Y _3468_/A _3468_/B VPWR VGND sg13cmos5l_nand2_1
X_3399_ _5696_/D _5418_/A1 _3399_/A1 _3407_/S VPWR VGND sg13cmos5l_mux2_1
X_5207_ _5207_/X _6014_/Q _6015_/Q VPWR VGND sg13cmos5l_xor2_1
Xhold1500 _3071_/A _6019_/Q VPWR VGND sg13cmos5l_dlygate4sd3_1
X_5138_ _5138_/Y _6067_/Q _5138_/B VPWR VGND sg13cmos5l_nand2b_1
Xhold1511 _4975_/A _6038_/Q VPWR VGND sg13cmos5l_dlygate4sd3_1
Xhold1522 _6070_/D _5283_/Y VPWR VGND sg13cmos5l_dlygate4sd3_1
Xhold1544 _3860_/B _5849_/Q VPWR VGND sg13cmos5l_dlygate4sd3_1
Xhold1533 _4457_/B _4456_/Y VPWR VGND sg13cmos5l_dlygate4sd3_1
Xhold1577 _5173_/A _6036_/Q VPWR VGND sg13cmos5l_dlygate4sd3_1
Xhold1566 _5988_/D _4813_/Y VPWR VGND sg13cmos5l_dlygate4sd3_1
Xhold1555 _4439_/A1 _4299_/Y VPWR VGND sg13cmos5l_dlygate4sd3_1
Xhold1588 _3068_/A _6047_/Q VPWR VGND sg13cmos5l_dlygate4sd3_1
X_5069_ _5071_/B _5069_/A _5057_/B VPWR VGND sg13cmos5l_nor2b_1
Xhold1599 _4335_/B _4334_/X VPWR VGND sg13cmos5l_dlygate4sd3_1
XFILLER_38_781 VPWR VGND sg13cmos5l_fill_2
X_5711__709 _5711_/RESET_B VPWR VGND sg13cmos5l_tiehi
XFILLER_26_976 VPWR VGND sg13cmos5l_fill_1
XFILLER_41_935 VPWR VGND sg13cmos5l_fill_1
XFILLER_13_626 VPWR VGND sg13cmos5l_fill_1
XFILLER_25_475 VPWR VGND sg13cmos5l_decap_8
XFILLER_26_998 VPWR VGND sg13cmos5l_fill_2
X_5570__857 _5570_/RESET_B VPWR VGND sg13cmos5l_tiehi
XFILLER_12_136 VPWR VGND sg13cmos5l_fill_2
XFILLER_48_523 VPWR VGND sg13cmos5l_decap_8
XFILLER_36_718 VPWR VGND sg13cmos5l_fill_2
XFILLER_17_932 VPWR VGND sg13cmos5l_decap_8
XFILLER_29_781 VPWR VGND sg13cmos5l_fill_1
XFILLER_35_217 VPWR VGND sg13cmos5l_fill_1
XFILLER_44_773 VPWR VGND sg13cmos5l_fill_1
XFILLER_32_968 VPWR VGND sg13cmos5l_decap_8
XFILLER_7_184 VPWR VGND sg13cmos5l_fill_1
XFILLER_7_162 VPWR VGND sg13cmos5l_decap_4
X_4440_ _4440_/Y _4441_/B VPWR VGND sg13cmos5l_inv_1
X_6040__282 _6040_/D VPWR VGND sg13cmos5l_tielo
X_4371_ _4371_/Y _5914_/Q _5915_/Q VPWR VGND sg13cmos5l_xnor2_1
X_3322_ _5632_/D _3322_/A0 _5298_/A _3326_/S VPWR VGND sg13cmos5l_mux2_1
X_3253_ _3253_/Y _3374_/A _3253_/B VPWR VGND sg13cmos5l_nor2_1
X_6041_ _6041_/Q _6067_/CLK _6041_/D _6041_/RESET_B VPWR VGND sg13cmos5l_dfrbpq_1
X_3184_ _3185_/B _3622_/A _3194_/B VPWR VGND sg13cmos5l_nor2b_1
XFILLER_14_0 VPWR VGND sg13cmos5l_fill_2
XFILLER_39_556 VPWR VGND sg13cmos5l_fill_1
XFILLER_22_401 VPWR VGND sg13cmos5l_fill_2
X_5947__419 _5947_/RESET_B VPWR VGND sg13cmos5l_tiehi
X_5825_ _5825_/Q _5825_/CLK _5825_/D _5825_/RESET_B VPWR VGND sg13cmos5l_dfrbpq_1
X_5756_ _5756_/Q _5834_/CLK _5756_/D _5756_/RESET_B VPWR VGND sg13cmos5l_dfrbpq_1
X_5687_ _5687_/Q clkload3/A _5687_/D _5687_/RESET_B VPWR VGND sg13cmos5l_dfrbpq_1
X_4707_ _5974_/D _4710_/A _4707_/B VPWR VGND sg13cmos5l_nor2_1
X_4638_ _5957_/D _4638_/A _4638_/B VPWR VGND sg13cmos5l_nor2_1
X_4569_ _4570_/A _4567_/Y _4568_/X _4569_/S VPWR VGND sg13cmos5l_mux2_1
Xhold1341 _5763_/D _3542_/X VPWR VGND sg13cmos5l_dlygate4sd3_1
Xhold1352 _5315_/A0 _5450_/Q VPWR VGND sg13cmos5l_dlygate4sd3_1
Xhold1330 _3248_/A1 _5571_/Q VPWR VGND sg13cmos5l_dlygate4sd3_1
Xhold1363 _5368_/A0 _5498_/Q VPWR VGND sg13cmos5l_dlygate4sd3_1
XFILLER_45_515 VPWR VGND sg13cmos5l_decap_8
Xhold1385 _3362_/A0 _5667_/Q VPWR VGND sg13cmos5l_dlygate4sd3_1
XFILLER_17_228 VPWR VGND sg13cmos5l_fill_2
XFILLER_27_43 VPWR VGND sg13cmos5l_fill_1
Xhold1374 _5360_/A1 _5491_/Q VPWR VGND sg13cmos5l_dlygate4sd3_1
Xhold1396 _3255_/A1 _5576_/Q VPWR VGND sg13cmos5l_dlygate4sd3_1
XFILLER_14_902 VPWR VGND sg13cmos5l_fill_2
XFILLER_14_957 VPWR VGND sg13cmos5l_fill_1
XFILLER_25_283 VPWR VGND sg13cmos5l_fill_2
XFILLER_40_253 VPWR VGND sg13cmos5l_fill_2
XFILLER_40_264 VPWR VGND sg13cmos5l_fill_1
XFILLER_36_504 VPWR VGND sg13cmos5l_fill_1
XFILLER_48_397 VPWR VGND sg13cmos5l_decap_8
XFILLER_17_740 VPWR VGND sg13cmos5l_fill_2
X_3940_ _3940_/X _5494_/Q _5477_/Q _5460_/Q _5443_/Q _4105_/S _4107_/B1 VPWR VGND
+ sg13cmos5l_mux4_1
X_5553__874 _5553_/RESET_B VPWR VGND sg13cmos5l_tiehi
X_3871_ _3872_/A _5484_/Q _5467_/Q _5450_/Q _5433_/Q _4045_/B _4049_/A1 VPWR VGND
+ sg13cmos5l_mux4_1
XFILLER_20_938 VPWR VGND sg13cmos5l_fill_1
X_5610_ _5610_/Q _5864_/CLK _5610_/D _5610_/RESET_B VPWR VGND sg13cmos5l_dfrbpq_1
X_5541_ _5541_/Q _5692_/CLK _5541_/D _5541_/RESET_B VPWR VGND sg13cmos5l_dfrbpq_1
XFILLER_9_950 VPWR VGND sg13cmos5l_fill_2
X_5472_ _5472_/Q _5840_/CLK _5472_/D _5472_/RESET_B VPWR VGND sg13cmos5l_dfrbpq_1
X_4423_ _4423_/X _4476_/A _4423_/B _4423_/C VPWR VGND sg13cmos5l_and3_1
X_5701__719 _5701_/RESET_B VPWR VGND sg13cmos5l_tiehi
X_4354_ _4354_/Y _4342_/Y _4350_/Y _4313_/B VPWR VGND sg13cmos5l_o21ai_1
X_5560__867 _5560_/RESET_B VPWR VGND sg13cmos5l_tiehi
X_3305_ _5617_/D _3305_/A0 _5359_/A0 _3307_/S VPWR VGND sg13cmos5l_mux2_1
X_4285_ _4285_/Y _5896_/Q _4285_/B VPWR VGND sg13cmos5l_nor2_1
X_6024_ _6024_/Q _6077_/CLK _6024_/D _6024_/RESET_B VPWR VGND sg13cmos5l_dfrbpq_1
X_3236_ _5563_/D _3236_/A0 _5421_/A1 _3241_/S VPWR VGND sg13cmos5l_mux2_1
X_3167_ _3167_/Y _4107_/B1 _3166_/Y _3918_/A VPWR VGND sg13cmos5l_o21ai_1
X_3098_ _4312_/A _3098_/A VPWR VGND sg13cmos5l_inv_1
Xfanout35 _3440_/B _3442_/B VPWR VGND sg13cmos5l_buf_1
Xfanout46 _3593_/B _3582_/Y VPWR VGND sg13cmos5l_buf_1
XFILLER_23_765 VPWR VGND sg13cmos5l_fill_1
Xfanout24 _4304_/A2 _4307_/A2 VPWR VGND sg13cmos5l_buf_1
XFILLER_10_404 VPWR VGND sg13cmos5l_fill_2
Xfanout79 _5266_/A _5177_/B VPWR VGND sg13cmos5l_buf_1
X_5808_ _5808_/Q _5822_/CLK _5808_/D _5808_/RESET_B VPWR VGND sg13cmos5l_dfrbpq_1
Xfanout57 _3346_/S _3345_/S VPWR VGND sg13cmos5l_buf_1
Xfanout68 _3374_/B _3376_/S VPWR VGND sg13cmos5l_buf_1
X_5739_ _5739_/Q _6047_/CLK _5739_/D _5739_/RESET_B VPWR VGND sg13cmos5l_dfrbpq_1
X_6073__838 _6073_/RESET_B VPWR VGND sg13cmos5l_tiehi
Xhold1160 _3624_/A _5833_/Q VPWR VGND sg13cmos5l_dlygate4sd3_1
XFILLER_38_75 VPWR VGND sg13cmos5l_fill_2
Xhold1193 _3378_/A0 _5679_/Q VPWR VGND sg13cmos5l_dlygate4sd3_1
Xhold1171 _6055_/D _5170_/Y VPWR VGND sg13cmos5l_dlygate4sd3_1
Xhold1182 _3351_/A1 _5657_/Q VPWR VGND sg13cmos5l_dlygate4sd3_1
XFILLER_46_879 VPWR VGND sg13cmos5l_decap_4
XFILLER_13_275 VPWR VGND sg13cmos5l_decap_4
X_6026__328 _6026_/RESET_B VPWR VGND sg13cmos5l_tiehi
XFILLER_13_286 VPWR VGND sg13cmos5l_fill_1
XFILLER_6_931 VPWR VGND sg13cmos5l_fill_1
Xclkload16 clkload16/Y _6074_/CLK VPWR VGND sg13cmos5l_inv_1
X_5937__429 _5937_/RESET_B VPWR VGND sg13cmos5l_tiehi
X_4070_ _4071_/B _5563_/Q _5546_/Q _5529_/Q _5512_/Q _3172_/S _4076_/S1 VPWR VGND
+ sg13cmos5l_mux4_1
XFILLER_0_190 VPWR VGND sg13cmos5l_fill_2
XFILLER_49_673 VPWR VGND sg13cmos5l_decap_8
X_4972_ _4972_/Y _4978_/B _6036_/Q VPWR VGND sg13cmos5l_nor2b_1
XFILLER_17_581 VPWR VGND sg13cmos5l_fill_1
X_3923_ _3923_/Y _4098_/A1 _3920_/Y _3111_/A VPWR VGND sg13cmos5l_o21ai_1
X_3854_ _4207_/B _4193_/A _4192_/A VPWR VGND sg13cmos5l_nor2_1
X_3785_ _3785_/Y _3786_/A1 _3783_/Y _3744_/A VPWR VGND sg13cmos5l_o21ai_1
X_5524_ _5524_/Q _5692_/CLK _5524_/D _5524_/RESET_B VPWR VGND sg13cmos5l_dfrbpq_1
X_5455_ _5455_/Q _5853_/CLK _5455_/D _5455_/RESET_B VPWR VGND sg13cmos5l_dfrbpq_1
X_4406_ _4410_/B _5910_/Q _5891_/Q VPWR VGND sg13cmos5l_nor2_1
X_5386_ _5514_/D _5386_/A0 _5423_/A1 _5389_/S VPWR VGND sg13cmos5l_mux2_1
Xfanout214 _5373_/A0 _5411_/A0 VPWR VGND sg13cmos5l_buf_1
Xfanout203 _5413_/A0 input9/X VPWR VGND sg13cmos5l_buf_1
X_4337_ _4337_/Y _4269_/A _4269_/B _4273_/B _4341_/A _4246_/B VPWR VGND sg13cmos5l_a221oi_1
Xfanout247 _3744_/A _3779_/B1 VPWR VGND sg13cmos5l_buf_1
Xfanout236 _3384_/A _5423_/A1 VPWR VGND sg13cmos5l_buf_1
Xfanout225 _5370_/A1 input5/X VPWR VGND sg13cmos5l_buf_1
X_4268_ _4269_/B _4268_/A _4268_/B VPWR VGND sg13cmos5l_nand2_1
Xfanout258 _4649_/A _5006_/A VPWR VGND sg13cmos5l_buf_1
X_3219_ _5551_/D _3219_/A0 _5408_/A1 _5423_/S VPWR VGND sg13cmos5l_mux2_1
X_6007_ _6007_/Q _6007_/CLK _6007_/D _6007_/RESET_B VPWR VGND sg13cmos5l_dfrbpq_1
X_4199_ _4202_/A _4205_/A _4205_/B VPWR VGND sg13cmos5l_nor2_1
XFILLER_42_304 VPWR VGND sg13cmos5l_fill_2
XFILLER_15_529 VPWR VGND sg13cmos5l_fill_1
XFILLER_24_33 VPWR VGND sg13cmos5l_fill_2
XFILLER_23_584 VPWR VGND sg13cmos5l_fill_1
XFILLER_6_205 VPWR VGND sg13cmos5l_fill_1
XFILLER_6_249 VPWR VGND sg13cmos5l_fill_1
XFILLER_46_1011 VPWR VGND sg13cmos5l_decap_8
XFILLER_49_52 VPWR VGND sg13cmos5l_fill_1
XFILLER_46_665 VPWR VGND sg13cmos5l_decap_4
X_5867__512 _5867_/RESET_B VPWR VGND sg13cmos5l_tiehi
X_5550__877 _5550_/RESET_B VPWR VGND sg13cmos5l_tiehi
X_3570_ _3577_/B _3793_/A _3607_/B VPWR VGND sg13cmos5l_nand2_1
X_5240_ _5240_/Y _5249_/B _5249_/C _5264_/B VPWR VGND sg13cmos5l_o21ai_1
XFILLER_5_282 VPWR VGND sg13cmos5l_decap_4
XFILLER_5_271 VPWR VGND sg13cmos5l_fill_2
XFILLER_5_260 VPWR VGND sg13cmos5l_fill_1
X_5171_ _5171_/Y _5171_/A1 _5172_/A2 _5007_/A VPWR VGND sg13cmos5l_o21ai_1
X_5874__505 _5874_/RESET_B VPWR VGND sg13cmos5l_tiehi
X_4122_ _5856_/D _4122_/A _4125_/B VPWR VGND sg13cmos5l_nor2b_1
X_4053_ _4054_/B _5561_/Q _5544_/Q _5527_/Q _5510_/Q _3979_/S _4053_/S1 VPWR VGND
+ sg13cmos5l_mux4_1
XFILLER_49_492 VPWR VGND sg13cmos5l_decap_8
Xinput3 input3/X ui_in[1] VPWR VGND sg13cmos5l_buf_1
X_4955_ _4956_/B _4955_/A0 _4714_/Y _4957_/S VPWR VGND sg13cmos5l_mux2_1
X_3906_ _3906_/Y _3901_/Y _3904_/Y _3905_/Y VPWR VGND sg13cmos5l_o21ai_1
X_4886_ _4886_/Y _4886_/A1 _4890_/A _4783_/A VPWR VGND sg13cmos5l_o21ai_1
X_3837_ _5841_/D _4003_/A _3838_/A _3836_/Y VPWR VGND sg13cmos5l_a21oi_1
X_3768_ _3773_/A _3782_/D _3776_/C VPWR VGND sg13cmos5l_nand2b_1
X_5507_ _5507_/Q _5692_/CLK _5507_/D _5507_/RESET_B VPWR VGND sg13cmos5l_dfrbpq_1
X_3699_ _3699_/Y _5807_/Q _3699_/B _3699_/C VPWR VGND sg13cmos5l_nor3_1
XFILLER_10_57 VPWR VGND sg13cmos5l_fill_2
X_5438_ _5438_/Q _5853_/CLK _5438_/D _5438_/RESET_B VPWR VGND sg13cmos5l_dfrbpq_1
X_5369_ _5499_/D _5369_/A0 _5398_/A0 _5369_/S VPWR VGND sg13cmos5l_mux2_1
XFILLER_48_908 VPWR VGND sg13cmos5l_decap_8
XFILLER_43_613 VPWR VGND sg13cmos5l_fill_2
XFILLER_31_808 VPWR VGND sg13cmos5l_decap_4
XFILLER_3_797 VPWR VGND sg13cmos5l_fill_2
XFILLER_47_963 VPWR VGND sg13cmos5l_decap_8
XFILLER_18_175 VPWR VGND sg13cmos5l_fill_2
XFILLER_42_690 VPWR VGND sg13cmos5l_fill_1
X_4740_ _5977_/D _4740_/A _4892_/A VPWR VGND sg13cmos5l_nor2_1
X_4671_ _4687_/B _5963_/Q _5935_/Q _5968_/Q VPWR VGND sg13cmos5l_nand3_1
X_3622_ _3798_/A _3622_/A _3841_/B VPWR VGND sg13cmos5l_nor2_1
X_3553_ _3553_/Y _3565_/A1 _3554_/S _3553_/B1 VPWR VGND sg13cmos5l_a21oi_1
X_3484_ _3484_/Y _3484_/A _3490_/B VPWR VGND sg13cmos5l_nand2_1
X_5223_ _5223_/Y _5114_/B _5238_/A _5241_/A _5108_/A VPWR VGND sg13cmos5l_a22oi_1
X_5154_ _5154_/Y _5164_/B _5152_/Y _3064_/Y VPWR VGND sg13cmos5l_o21ai_1
X_4105_ _4105_/X _5533_/Q _5516_/Q _4105_/S VPWR VGND sg13cmos5l_mux2_1
X_5085_ _5093_/B _6065_/Q _6064_/Q _5138_/B VPWR VGND sg13cmos5l_nor3_1
X_4036_ _4036_/Y _5610_/Q _4036_/B VPWR VGND sg13cmos5l_nand2b_1
XFILLER_37_495 VPWR VGND sg13cmos5l_decap_8
X_5987_ _5987_/Q _6056_/CLK _5987_/D _5987_/RESET_B VPWR VGND sg13cmos5l_dfrbpq_1
X_4938_ _5053_/A _5232_/A _4938_/B VPWR VGND sg13cmos5l_nor2_1
X_4869_ _4869_/Y _4869_/A _4869_/B _4869_/C VPWR VGND sg13cmos5l_nor3_1
X_5720__700 _5720_/RESET_B VPWR VGND sg13cmos5l_tiehi
XFILLER_43_1003 VPWR VGND sg13cmos5l_decap_8
X_5857__522 _5857_/RESET_B VPWR VGND sg13cmos5l_tiehi
XFILLER_28_473 VPWR VGND sg13cmos5l_fill_2
XFILLER_29_996 VPWR VGND sg13cmos5l_decap_4
XFILLER_44_966 VPWR VGND sg13cmos5l_decap_8
XFILLER_44_999 VPWR VGND sg13cmos5l_decap_8
XFILLER_43_454 VPWR VGND sg13cmos5l_decap_8
XFILLER_31_649 VPWR VGND sg13cmos5l_fill_2
X_5864__515 _5864_/RESET_B VPWR VGND sg13cmos5l_tiehi
XFILLER_7_344 VPWR VGND sg13cmos5l_fill_1
X_5871__508 _5871_/RESET_B VPWR VGND sg13cmos5l_tiehi
XFILLER_38_237 VPWR VGND sg13cmos5l_fill_1
X_5910_ _5910_/Q _5936_/CLK _5910_/D _5910_/RESET_B VPWR VGND sg13cmos5l_dfrbpq_1
X_5841_ _5841_/Q clkload6/A _5841_/D _5841_/RESET_B VPWR VGND sg13cmos5l_dfrbpq_1
XFILLER_34_476 VPWR VGND sg13cmos5l_fill_2
X_5772_ _5772_/Q _5834_/CLK _5772_/D _5772_/RESET_B VPWR VGND sg13cmos5l_dfrbpq_1
XFILLER_34_498 VPWR VGND sg13cmos5l_fill_2
X_4723_ _4723_/X _6004_/Q _5977_/Q VPWR VGND sg13cmos5l_and2_1
X_4654_ _5970_/D _4654_/A _4655_/B VPWR VGND sg13cmos5l_and2_1
X_4585_ _4585_/X _5940_/Q _5919_/Q VPWR VGND sg13cmos5l_or2_1
X_3605_ _3605_/Y _3605_/A _3605_/B VPWR VGND sg13cmos5l_nand2_1
X_3536_ _3536_/Y _3536_/A _3543_/B VPWR VGND sg13cmos5l_nor2_1
X_5956__410 _5956_/RESET_B VPWR VGND sg13cmos5l_tiehi
XFILLER_27_1009 VPWR VGND sg13cmos5l_fill_1
X_5206_ _5206_/X _6036_/Q _6014_/Q _6015_/Q VPWR VGND sg13cmos5l_or3_1
X_3467_ _5727_/D _3440_/A _3467_/A1 _3467_/S VPWR VGND sg13cmos5l_mux2_1
Xhold1501 _4989_/B1 _4988_/Y VPWR VGND sg13cmos5l_dlygate4sd3_1
X_3398_ _3406_/S _5304_/C _3824_/C _5352_/D _3398_/D VPWR VGND sg13cmos5l_nand4_1
X_5137_ _5137_/Y _6023_/Q _5137_/B VPWR VGND sg13cmos5l_nand2b_1
Xhold1512 _4810_/A1 _5987_/Q VPWR VGND sg13cmos5l_dlygate4sd3_1
Xhold1534 _4620_/A _5976_/Q VPWR VGND sg13cmos5l_dlygate4sd3_1
Xhold1523 _4463_/B _5927_/Q VPWR VGND sg13cmos5l_dlygate4sd3_1
Xhold1556 _5897_/D _4300_/Y VPWR VGND sg13cmos5l_dlygate4sd3_1
Xhold1567 _3162_/D _5828_/Q VPWR VGND sg13cmos5l_dlygate4sd3_1
X_5068_ _6038_/D _5050_/Y _5069_/A _5067_/Y VPWR VGND sg13cmos5l_a21oi_1
Xhold1545 _3863_/A2 _3860_/Y VPWR VGND sg13cmos5l_dlygate4sd3_1
X_4019_ _4019_/Y _4024_/A1 _4018_/X _4011_/A VPWR VGND sg13cmos5l_a21oi_1
Xhold1578 _6057_/D _5173_/X VPWR VGND sg13cmos5l_dlygate4sd3_1
Xhold1589 _6047_/D _5157_/Y VPWR VGND sg13cmos5l_dlygate4sd3_1
XFILLER_13_605 VPWR VGND sg13cmos5l_fill_2
XFILLER_25_454 VPWR VGND sg13cmos5l_decap_8
XFILLER_5_804 VPWR VGND sg13cmos5l_decap_4
XFILLER_20_170 VPWR VGND sg13cmos5l_fill_1
XFILLER_20_192 VPWR VGND sg13cmos5l_fill_2
XFILLER_10_1024 VPWR VGND sg13cmos5l_decap_4
XFILLER_48_502 VPWR VGND sg13cmos5l_decap_8
XFILLER_48_579 VPWR VGND sg13cmos5l_decap_8
XFILLER_17_911 VPWR VGND sg13cmos5l_fill_2
XFILLER_31_402 VPWR VGND sg13cmos5l_fill_1
XFILLER_32_936 VPWR VGND sg13cmos5l_decap_4
X_4370_ _4370_/Y _5915_/Q _5914_/Q _5940_/Q VPWR VGND sg13cmos5l_nand3b_1
X_3321_ _5631_/D _3321_/A0 _5375_/A0 _3326_/S VPWR VGND sg13cmos5l_mux2_1
XFILLER_4_892 VPWR VGND sg13cmos5l_fill_2
X_3252_ _5574_/D _3120_/Y _3253_/B _3251_/Y VPWR VGND sg13cmos5l_a21oi_1
X_6040_ _6040_/Q _6061_/CLK _6040_/D _6040_/RESET_B VPWR VGND sg13cmos5l_dfrbpq_1
X_3183_ _3194_/B _3176_/Y _3182_/Y _3171_/Y VPWR VGND sg13cmos5l_a21oi_1
XFILLER_35_741 VPWR VGND sg13cmos5l_fill_2
X_5810__609 _5810_/RESET_B VPWR VGND sg13cmos5l_tiehi
XFILLER_35_752 VPWR VGND sg13cmos5l_decap_8
X_5824_ _5824_/Q _5825_/CLK _5824_/D _5824_/RESET_B VPWR VGND sg13cmos5l_dfrbpq_1
X_5710__710 _5710_/RESET_B VPWR VGND sg13cmos5l_tiehi
X_5755_ _5755_/Q _6074_/CLK _5755_/D _5755_/RESET_B VPWR VGND sg13cmos5l_dfrbpq_1
XFILLER_22_479 VPWR VGND sg13cmos5l_decap_8
X_5686_ _5686_/Q clkload9/A _5686_/D _5686_/RESET_B VPWR VGND sg13cmos5l_dfrbpq_1
X_4706_ _4707_/B _4688_/X _4697_/B _4708_/A VPWR VGND sg13cmos5l_mux2_1
X_4637_ _4637_/X _4618_/A _4617_/Y _4637_/S VPWR VGND sg13cmos5l_mux2_1
XFILLER_2_807 VPWR VGND sg13cmos5l_fill_1
X_4568_ _4568_/X _4769_/A _4759_/A VPWR VGND sg13cmos5l_and2_1
X_3519_ _3557_/C _3519_/A _4131_/A VPWR VGND sg13cmos5l_nor2_1
X_4499_ _4500_/B _4505_/A _4505_/B _4485_/Y VPWR VGND sg13cmos5l_a21oi_1
Xhold1342 _3396_/A1 _5694_/Q VPWR VGND sg13cmos5l_dlygate4sd3_1
Xhold1320 _3388_/A0 _5687_/Q VPWR VGND sg13cmos5l_dlygate4sd3_1
Xhold1331 _5365_/A0 _5495_/Q VPWR VGND sg13cmos5l_dlygate4sd3_1
XFILLER_40_1028 VPWR VGND sg13cmos5l_fill_1
Xhold1386 _5416_/A1 _5541_/Q VPWR VGND sg13cmos5l_dlygate4sd3_1
Xhold1375 _5379_/A1 _5508_/Q VPWR VGND sg13cmos5l_dlygate4sd3_1
XFILLER_45_527 VPWR VGND sg13cmos5l_fill_1
Xhold1353 _5319_/A0 _5454_/Q VPWR VGND sg13cmos5l_dlygate4sd3_1
Xhold1364 _5309_/A1 _5445_/Q VPWR VGND sg13cmos5l_dlygate4sd3_1
Xhold1397 _3316_/A1 _5627_/Q VPWR VGND sg13cmos5l_dlygate4sd3_1
XFILLER_26_763 VPWR VGND sg13cmos5l_fill_1
XFILLER_43_43 VPWR VGND sg13cmos5l_fill_1
XFILLER_25_295 VPWR VGND sg13cmos5l_decap_8
XFILLER_22_980 VPWR VGND sg13cmos5l_fill_2
Xclkbuf_leaf_20_clk _6005_/CLK clkload0/A VPWR VGND sg13cmos5l_buf_8
X_5861__518 _5861_/RESET_B VPWR VGND sg13cmos5l_tiehi
XFILLER_49_800 VPWR VGND sg13cmos5l_fill_1
XFILLER_36_516 VPWR VGND sg13cmos5l_decap_8
XFILLER_36_538 VPWR VGND sg13cmos5l_fill_2
XFILLER_44_582 VPWR VGND sg13cmos5l_decap_8
X_5946__420 _5946_/RESET_B VPWR VGND sg13cmos5l_tiehi
X_3870_ _3876_/B _3881_/A _3870_/B _3870_/C VPWR VGND sg13cmos5l_nor3_1
Xclkbuf_leaf_11_clk _5692_/CLK clkbuf_leaf_9_clk/A VPWR VGND sg13cmos5l_buf_8
X_5540_ _5540_/Q _5692_/CLK _5540_/D _5540_/RESET_B VPWR VGND sg13cmos5l_dfrbpq_1
XFILLER_9_940 VPWR VGND sg13cmos5l_fill_2
X_5471_ _5471_/Q clkload6/A _5471_/D _5471_/RESET_B VPWR VGND sg13cmos5l_dfrbpq_1
X_4422_ _5919_/D _4421_/A _4421_/B _4460_/A VPWR VGND sg13cmos5l_a21oi_1
X_4353_ _5910_/D _4353_/A _4353_/B VPWR VGND sg13cmos5l_and2_1
X_3304_ _5616_/D _3304_/A0 _3384_/A _3307_/S VPWR VGND sg13cmos5l_mux2_1
X_4284_ _4285_/B _4238_/Y _4281_/Y _4282_/Y _4283_/Y VPWR VGND sg13cmos5l_a22oi_1
X_3235_ _5562_/D _3235_/A0 _5420_/A1 _3241_/S VPWR VGND sg13cmos5l_mux2_1
X_6023_ _6023_/Q _6056_/CLK _6023_/D _6023_/RESET_B VPWR VGND sg13cmos5l_dfrbpq_1
X_5953__413 _5953_/RESET_B VPWR VGND sg13cmos5l_tiehi
X_3166_ _3166_/Y _4105_/S _5483_/Q _3165_/Y VPWR VGND sg13cmos5l_a21oi_1
X_3097_ _4314_/A _3097_/A VPWR VGND sg13cmos5l_inv_1
Xfanout47 _3591_/B _3582_/Y VPWR VGND sg13cmos5l_buf_1
Xfanout36 _3442_/B _3431_/Y VPWR VGND sg13cmos5l_buf_1
X_5986__288 _5986_/D VPWR VGND sg13cmos5l_tielo
Xfanout25 _5004_/A2 _5003_/A2 VPWR VGND sg13cmos5l_buf_1
X_5807_ _5807_/Q _5822_/CLK _5807_/D _5807_/RESET_B VPWR VGND sg13cmos5l_dfrbpq_1
Xfanout58 _3326_/S _3325_/S VPWR VGND sg13cmos5l_buf_1
X_3999_ _3999_/Y _3999_/A VPWR VGND sg13cmos5l_inv_1
Xfanout69 _3253_/B _3255_/S VPWR VGND sg13cmos5l_buf_1
X_5738_ _5738_/Q _5825_/CLK _5738_/D _5738_/RESET_B VPWR VGND sg13cmos5l_dfrbpq_1
XFILLER_22_287 VPWR VGND sg13cmos5l_fill_1
X_5960__406 _5960_/RESET_B VPWR VGND sg13cmos5l_tiehi
X_5669_ _5669_/Q clkload9/A _5669_/D _5669_/RESET_B VPWR VGND sg13cmos5l_dfrbpq_1
X_5487__582 _5487_/RESET_B VPWR VGND sg13cmos5l_tiehi
Xhold1150 _3162_/A _5831_/Q VPWR VGND sg13cmos5l_dlygate4sd3_1
XFILLER_18_549 VPWR VGND sg13cmos5l_fill_1
Xhold1183 _5338_/A0 _5471_/Q VPWR VGND sg13cmos5l_dlygate4sd3_1
Xhold1172 _5001_/A1 _5994_/Q VPWR VGND sg13cmos5l_dlygate4sd3_1
Xhold1161 _3073_/A _5962_/Q VPWR VGND sg13cmos5l_dlygate4sd3_1
Xhold1194 _3297_/A1 _5610_/Q VPWR VGND sg13cmos5l_dlygate4sd3_1
XFILLER_10_961 VPWR VGND sg13cmos5l_decap_8
XFILLER_10_972 VPWR VGND sg13cmos5l_fill_1
Xclkload17 clkload17/X _6037_/CLK VPWR VGND sg13cmos5l_buf_8
XFILLER_6_976 VPWR VGND sg13cmos5l_fill_2
XFILLER_6_965 VPWR VGND sg13cmos5l_decap_8
X_5700__720 _5700_/RESET_B VPWR VGND sg13cmos5l_tiehi
Xclkbuf_leaf_0_clk _5810_/CLK clkbuf_leaf_2_clk/A VPWR VGND sg13cmos5l_buf_8
XFILLER_37_825 VPWR VGND sg13cmos5l_decap_8
X_4971_ _4977_/C _4978_/B _4816_/A _4974_/B VPWR VGND sg13cmos5l_o21ai_1
X_3922_ _3922_/Y _3892_/S _3112_/Y _3921_/Y VPWR VGND sg13cmos5l_a21oi_1
XFILLER_20_703 VPWR VGND sg13cmos5l_fill_1
X_3853_ _3853_/Y _3849_/A _3851_/Y _3852_/Y _3847_/A VPWR VGND sg13cmos5l_a22oi_1
XFILLER_32_585 VPWR VGND sg13cmos5l_fill_1
X_5809__611 _5809_/RESET_B VPWR VGND sg13cmos5l_tiehi
X_3784_ _3784_/Y _5818_/Q _3784_/B VPWR VGND sg13cmos5l_nor2_1
X_5523_ _5523_/Q _5692_/CLK _5523_/D _5523_/RESET_B VPWR VGND sg13cmos5l_dfrbpq_1
X_5454_ _5454_/Q clkload6/A _5454_/D _5454_/RESET_B VPWR VGND sg13cmos5l_dfrbpq_1
X_4405_ _4405_/Y _4426_/A _4413_/B VPWR VGND sg13cmos5l_nand2b_1
X_5385_ _5513_/D _5385_/A0 _3382_/A _5389_/S VPWR VGND sg13cmos5l_mux2_1
X_4336_ _4336_/Y _4338_/B _4336_/B VPWR VGND sg13cmos5l_nand2b_1
XFILLER_5_80 VPWR VGND sg13cmos5l_fill_1
Xfanout204 _5356_/A0 _5375_/A0 VPWR VGND sg13cmos5l_buf_1
Xfanout215 _3391_/A0 _5411_/A0 VPWR VGND sg13cmos5l_buf_1
XFILLER_8_1028 VPWR VGND sg13cmos5l_fill_1
Xfanout237 _5423_/A1 input11/X VPWR VGND sg13cmos5l_buf_1
Xfanout226 _3217_/A _5398_/A0 VPWR VGND sg13cmos5l_buf_1
X_4267_ _4268_/B _4267_/A _4271_/A VPWR VGND sg13cmos5l_nor2_1
Xfanout248 _3779_/B1 _5304_/C VPWR VGND sg13cmos5l_buf_1
Xfanout259 _4827_/A _5006_/A VPWR VGND sg13cmos5l_buf_1
X_3218_ _5550_/D _3124_/Y _5422_/S _3217_/Y VPWR VGND sg13cmos5l_o21ai_1
X_6006_ _6006_/Q _6007_/CLK _6006_/D _6006_/RESET_B VPWR VGND sg13cmos5l_dfrbpq_1
XFILLER_28_814 VPWR VGND sg13cmos5l_decap_4
X_4198_ _4198_/Y _4203_/A _4205_/B VPWR VGND sg13cmos5l_nand2_1
X_3149_ _3149_/Y _5958_/Q VPWR VGND sg13cmos5l_inv_1
XFILLER_40_44 VPWR VGND sg13cmos5l_fill_2
XFILLER_3_968 VPWR VGND sg13cmos5l_fill_2
X_5936__430 _5936_/RESET_B VPWR VGND sg13cmos5l_tiehi
XFILLER_46_600 VPWR VGND sg13cmos5l_fill_1
X_6051__945 _6051_/RESET_B VPWR VGND sg13cmos5l_tiehi
XFILLER_19_825 VPWR VGND sg13cmos5l_fill_2
XFILLER_19_847 VPWR VGND sg13cmos5l_fill_1
XFILLER_18_368 VPWR VGND sg13cmos5l_decap_4
XFILLER_42_850 VPWR VGND sg13cmos5l_fill_1
XFILLER_42_861 VPWR VGND sg13cmos5l_fill_1
X_5943__423 _5943_/RESET_B VPWR VGND sg13cmos5l_tiehi
X_5170_ _5170_/Y _3062_/Y _5172_/A2 _5169_/Y VPWR VGND sg13cmos5l_a21oi_1
X_4121_ _5855_/D _4122_/A _4124_/B VPWR VGND sg13cmos5l_nor2b_1
X_4052_ _4052_/Y _3908_/Y _4034_/Y _4051_/Y _3620_/B _5843_/Q VPWR VGND sg13cmos5l_a221oi_1
XFILLER_49_471 VPWR VGND sg13cmos5l_decap_8
Xinput4 input4/X ui_in[2] VPWR VGND sg13cmos5l_buf_1
X_5950__416 _5950_/RESET_B VPWR VGND sg13cmos5l_tiehi
X_4954_ _4957_/S _4944_/Y _4952_/Y _4953_/Y VPWR VGND sg13cmos5l_o21ai_1
X_3905_ _3905_/Y _3897_/Y _3899_/Y _3881_/A VPWR VGND sg13cmos5l_a21oi_1
X_4885_ _4890_/A _4876_/Y _4882_/Y _4884_/Y VPWR VGND sg13cmos5l_o21ai_1
X_3836_ _3836_/Y _4003_/A _3835_/Y _5304_/C VPWR VGND sg13cmos5l_o21ai_1
X_3767_ _3776_/C _3767_/A _3767_/B _3767_/C VPWR VGND sg13cmos5l_nand3_1
X_5506_ _5506_/Q _5692_/CLK _5506_/D _5506_/RESET_B VPWR VGND sg13cmos5l_dfrbpq_1
X_3698_ _3699_/C _3760_/A1 _3692_/X _3697_/Y VPWR VGND sg13cmos5l_a21oi_1
X_5437_ _5437_/Q _5853_/CLK _5437_/D _5437_/RESET_B VPWR VGND sg13cmos5l_dfrbpq_1
X_5368_ _5498_/D _5368_/A0 _5416_/A0 _5370_/S VPWR VGND sg13cmos5l_mux2_1
XFILLER_0_949 VPWR VGND sg13cmos5l_decap_8
X_5299_ _5437_/D _3112_/Y _5301_/S _5298_/Y VPWR VGND sg13cmos5l_o21ai_1
X_4319_ _4328_/A _4327_/A _4327_/B VPWR VGND sg13cmos5l_nand2_1
XFILLER_27_143 VPWR VGND sg13cmos5l_fill_2
XFILLER_27_154 VPWR VGND sg13cmos5l_fill_2
XFILLER_15_349 VPWR VGND sg13cmos5l_fill_1
XFILLER_3_732 VPWR VGND sg13cmos5l_fill_2
XFILLER_2_264 VPWR VGND sg13cmos5l_decap_8
XFILLER_47_942 VPWR VGND sg13cmos5l_decap_8
XFILLER_18_8 VPWR VGND sg13cmos5l_fill_1
XFILLER_46_485 VPWR VGND sg13cmos5l_decap_8
X_4670_ _4687_/A _5967_/Q _4685_/B VPWR VGND sg13cmos5l_nand2_1
X_5806__614 _5806_/RESET_B VPWR VGND sg13cmos5l_tiehi
X_3621_ _3841_/B _3621_/A _3840_/B VPWR VGND sg13cmos5l_nand2_1
X_3552_ _3552_/Y _3552_/A _3554_/S VPWR VGND sg13cmos5l_nor2_1
X_3483_ _3493_/B _5825_/Q _3582_/B _3507_/B VPWR VGND sg13cmos5l_nand3_1
X_5222_ _5241_/A _6036_/Q _5221_/Y _5226_/B VPWR VGND sg13cmos5l_mux2_1
X_5153_ _5153_/Y _6050_/Q _5149_/Y _5152_/Y _5164_/B VPWR VGND sg13cmos5l_a22oi_1
XFILLER_37_0 VPWR VGND sg13cmos5l_fill_1
X_4104_ _4104_/Y _4105_/S _5567_/Q _4103_/Y VPWR VGND sg13cmos5l_o21ai_1
X_5084_ _5084_/Y _5116_/A _5077_/X _5080_/Y _5083_/A _5081_/Y VPWR VGND sg13cmos5l_a221oi_1
X_4035_ _4035_/X _5602_/Q _5576_/Q _4036_/B VPWR VGND sg13cmos5l_mux2_1
XFILLER_37_474 VPWR VGND sg13cmos5l_decap_8
X_5986_ _5986_/Q _6037_/CLK _5986_/D _5986_/RESET_B VPWR VGND sg13cmos5l_dfrbpq_1
X_4937_ _4938_/B _4928_/A _4914_/X _4917_/Y VPWR VGND sg13cmos5l_o21ai_1
X_4868_ _4869_/C _4880_/A _4868_/B VPWR VGND sg13cmos5l_nor2_1
X_3819_ _3819_/Y _3163_/A _3818_/Y _3220_/C VPWR VGND sg13cmos5l_o21ai_1
XFILLER_20_363 VPWR VGND sg13cmos5l_fill_1
X_4799_ _4799_/Y _4799_/A _4799_/B VPWR VGND sg13cmos5l_nand2_1
XFILLER_48_706 VPWR VGND sg13cmos5l_fill_1
X_5933__433 _5933_/RESET_B VPWR VGND sg13cmos5l_tiehi
XFILLER_28_452 VPWR VGND sg13cmos5l_decap_8
XFILLER_15_113 VPWR VGND sg13cmos5l_fill_1
XFILLER_16_669 VPWR VGND sg13cmos5l_fill_1
XFILLER_8_813 VPWR VGND sg13cmos5l_decap_4
XFILLER_12_864 VPWR VGND sg13cmos5l_fill_2
XFILLER_11_363 VPWR VGND sg13cmos5l_decap_4
XFILLER_12_886 VPWR VGND sg13cmos5l_fill_1
X_5940__426 _5940_/RESET_B VPWR VGND sg13cmos5l_tiehi
XFILLER_39_717 VPWR VGND sg13cmos5l_fill_2
XFILLER_4_1020 VPWR VGND sg13cmos5l_decap_8
XFILLER_19_430 VPWR VGND sg13cmos5l_fill_2
XFILLER_47_772 VPWR VGND sg13cmos5l_fill_2
XFILLER_34_433 VPWR VGND sg13cmos5l_fill_2
X_5840_ _5840_/Q _5840_/CLK _5840_/D _5840_/RESET_B VPWR VGND sg13cmos5l_dfrbpq_1
XFILLER_34_455 VPWR VGND sg13cmos5l_decap_8
X_5771_ _5771_/Q _5834_/CLK _5771_/D _5771_/RESET_B VPWR VGND sg13cmos5l_dfrbpq_1
X_4722_ _4722_/Y _4727_/A _4727_/B _4951_/A VPWR VGND sg13cmos5l_a21oi_1
X_4653_ _5969_/D _4653_/A _4710_/A VPWR VGND sg13cmos5l_nor2_1
X_4584_ _4584_/Y _4584_/A _4584_/B _4584_/C VPWR VGND sg13cmos5l_nand3_1
X_3604_ _3604_/X _3591_/A _3604_/A1 _3605_/B VPWR VGND sg13cmos5l_mux2_1
X_3535_ _5759_/D _3609_/A1 _3543_/B _3534_/Y VPWR VGND sg13cmos5l_a21oi_1
X_3466_ _3466_/Y _3615_/A1 _3467_/S _3466_/B1 VPWR VGND sg13cmos5l_o21ai_1
X_5205_ _5205_/Y _6017_/Q _5201_/B _5202_/X _6016_/Q VPWR VGND sg13cmos5l_a22oi_1
X_3397_ _5695_/D _5322_/A1 _3397_/A1 _3397_/S VPWR VGND sg13cmos5l_mux2_1
X_5136_ _5141_/B _5134_/Y _5136_/B VPWR VGND sg13cmos5l_nand2b_1
Xhold1502 _6019_/D _4989_/Y VPWR VGND sg13cmos5l_dlygate4sd3_1
Xhold1513 _5987_/D _4811_/Y VPWR VGND sg13cmos5l_dlygate4sd3_1
Xhold1524 _4464_/A2 _4463_/Y VPWR VGND sg13cmos5l_dlygate4sd3_1
Xhold1535 _4654_/A _5943_/Q VPWR VGND sg13cmos5l_dlygate4sd3_1
Xhold1557 _5137_/B _6020_/Q VPWR VGND sg13cmos5l_dlygate4sd3_1
X_5067_ _5067_/Y _5046_/Y _5069_/A _5011_/B VPWR VGND sg13cmos5l_o21ai_1
Xhold1546 _4994_/A1 _6021_/Q VPWR VGND sg13cmos5l_dlygate4sd3_1
Xhold1568 _3160_/B _6078_/Q VPWR VGND sg13cmos5l_dlygate4sd3_1
X_4018_ _4018_/X _5659_/Q _5642_/Q _4022_/B VPWR VGND sg13cmos5l_mux2_1
Xhold1579 _4459_/A1 _5925_/Q VPWR VGND sg13cmos5l_dlygate4sd3_1
XFILLER_38_783 VPWR VGND sg13cmos5l_fill_1
X_5817__595 _5817_/RESET_B VPWR VGND sg13cmos5l_tiehi
XFILLER_16_35 VPWR VGND sg13cmos5l_fill_1
X_5969_ _5969_/Q _6005_/CLK _5969_/D _5969_/RESET_B VPWR VGND sg13cmos5l_dfrbpq_1
XFILLER_40_469 VPWR VGND sg13cmos5l_decap_8
X_5497__562 _5497_/RESET_B VPWR VGND sg13cmos5l_tiehi
XFILLER_48_558 VPWR VGND sg13cmos5l_decap_8
XFILLER_17_923 VPWR VGND sg13cmos5l_fill_1
XFILLER_44_720 VPWR VGND sg13cmos5l_decap_4
X_5803__617 _5803_/RESET_B VPWR VGND sg13cmos5l_tiehi
XFILLER_4_871 VPWR VGND sg13cmos5l_fill_1
X_3320_ _5630_/D _3320_/A0 _3320_/A1 _3326_/S VPWR VGND sg13cmos5l_mux2_1
X_3251_ _3251_/Y _3251_/A _3253_/B VPWR VGND sg13cmos5l_nor2_1
X_3182_ _3182_/Y _3931_/A _3182_/B VPWR VGND sg13cmos5l_nor2_1
XFILLER_14_2 VPWR VGND sg13cmos5l_fill_1
XFILLER_26_208 VPWR VGND sg13cmos5l_decap_4
XFILLER_34_230 VPWR VGND sg13cmos5l_fill_1
X_5823_ _5823_/Q clkload8/A _5823_/D _5823_/RESET_B VPWR VGND sg13cmos5l_dfrbpq_1
XFILLER_22_458 VPWR VGND sg13cmos5l_decap_8
X_5754_ _5754_/Q _5834_/CLK _5754_/D _5754_/RESET_B VPWR VGND sg13cmos5l_dfrbpq_1
XFILLER_33_1025 VPWR VGND sg13cmos5l_decap_4
X_5685_ _5685_/Q clkload1/A _5685_/D _5685_/RESET_B VPWR VGND sg13cmos5l_dfrbpq_1
X_4705_ _5973_/D _4691_/B _4708_/A _4704_/Y VPWR VGND sg13cmos5l_a21oi_1
X_4636_ _4636_/Y _4621_/Y _4637_/S _4635_/Y VPWR VGND sg13cmos5l_a21oi_1
X_4567_ _4567_/Y _4539_/A _4539_/B _4573_/B VPWR VGND sg13cmos5l_a21oi_1
X_4498_ _4510_/B _4510_/A _4497_/X _4496_/Y VPWR VGND sg13cmos5l_o21ai_1
X_3518_ _3518_/Y _3518_/A1 _3517_/B _3517_/Y VPWR VGND sg13cmos5l_o21ai_1
XFILLER_1_318 VPWR VGND sg13cmos5l_fill_2
X_3449_ _5718_/D _5158_/A1 _3452_/B _3448_/Y VPWR VGND sg13cmos5l_a21oi_1
X_5854__526 _5854_/RESET_B VPWR VGND sg13cmos5l_tiehi
Xhold1310 _3402_/A1 _5699_/Q VPWR VGND sg13cmos5l_dlygate4sd3_1
X_5119_ _5119_/Y _5119_/A _5119_/B VPWR VGND sg13cmos5l_nand2_1
Xhold1332 _3307_/A0 _5619_/Q VPWR VGND sg13cmos5l_dlygate4sd3_1
Xhold1321 _3260_/A0 _5580_/Q VPWR VGND sg13cmos5l_dlygate4sd3_1
XFILLER_18_709 VPWR VGND sg13cmos5l_fill_2
Xhold1343 _5357_/A1 _5488_/Q VPWR VGND sg13cmos5l_dlygate4sd3_1
Xhold1354 _3365_/A0 _5670_/Q VPWR VGND sg13cmos5l_dlygate4sd3_1
Xheichips26_dna_sequencer_270 uio_out[1] VPWR VGND sg13cmos5l_tielo
Xhold1376 _3324_/A0 _5634_/Q VPWR VGND sg13cmos5l_dlygate4sd3_1
Xhold1365 _3322_/A0 _5632_/Q VPWR VGND sg13cmos5l_dlygate4sd3_1
Xhold1387 _5334_/A0 _5467_/Q VPWR VGND sg13cmos5l_dlygate4sd3_1
XFILLER_26_720 VPWR VGND sg13cmos5l_fill_2
Xhold1398 _5410_/A1 _5535_/Q VPWR VGND sg13cmos5l_dlygate4sd3_1
XFILLER_41_723 VPWR VGND sg13cmos5l_fill_1
XFILLER_25_252 VPWR VGND sg13cmos5l_fill_1
XFILLER_25_285 VPWR VGND sg13cmos5l_fill_1
X_5898__475 _5898_/RESET_B VPWR VGND sg13cmos5l_tiehi
XFILLER_1_1023 VPWR VGND sg13cmos5l_decap_4
XFILLER_32_712 VPWR VGND sg13cmos5l_fill_1
XFILLER_31_244 VPWR VGND sg13cmos5l_fill_2
XFILLER_8_473 VPWR VGND sg13cmos5l_fill_2
X_5470_ _5470_/Q _5840_/CLK _5470_/D _5470_/RESET_B VPWR VGND sg13cmos5l_dfrbpq_1
X_4421_ _4421_/Y _4421_/A _4421_/B VPWR VGND sg13cmos5l_nand2_1
X_4352_ _4353_/B _4328_/Y _4350_/Y _4314_/B VPWR VGND sg13cmos5l_a21oi_1
X_4283_ _4283_/Y _5872_/Q _4283_/B VPWR VGND sg13cmos5l_nor2_1
X_3303_ _5615_/D _3303_/A0 _5298_/A _3307_/S VPWR VGND sg13cmos5l_mux2_1
X_6022_ _6022_/Q _6061_/CLK _6022_/D _6022_/RESET_B VPWR VGND sg13cmos5l_dfrbpq_1
X_3234_ _5561_/D _3234_/A0 _5419_/A1 _3241_/S VPWR VGND sg13cmos5l_mux2_1
XFILLER_27_506 VPWR VGND sg13cmos5l_decap_4
X_3165_ _3165_/Y _4105_/S _5500_/Q VPWR VGND sg13cmos5l_nor2b_1
X_3096_ _3096_/Y _3096_/A VPWR VGND sg13cmos5l_inv_1
Xfanout37 _3427_/B _3418_/B VPWR VGND sg13cmos5l_buf_1
Xfanout26 _5003_/A2 _4307_/A2 VPWR VGND sg13cmos5l_buf_1
X_5806_ _5806_/Q _5822_/CLK _5806_/D _5806_/RESET_B VPWR VGND sg13cmos5l_dfrbpq_1
Xfanout48 _3567_/B _3566_/S VPWR VGND sg13cmos5l_buf_1
Xfanout59 _3307_/S _3306_/S VPWR VGND sg13cmos5l_buf_1
X_3998_ _3999_/A _5485_/Q _5468_/Q _5451_/Q _5434_/Q _3998_/S0 _4049_/A1 VPWR VGND
+ sg13cmos5l_mux4_1
X_5737_ _5737_/Q _5825_/CLK _5737_/D _5737_/RESET_B VPWR VGND sg13cmos5l_dfrbpq_1
X_5668_ _5668_/Q clkload2/A _5668_/D _5668_/RESET_B VPWR VGND sg13cmos5l_dfrbpq_1
X_5599_ _5599_/Q _5695_/CLK _5599_/D _5599_/RESET_B VPWR VGND sg13cmos5l_dfrbpq_1
X_4619_ _4619_/X _5925_/Q _4622_/B VPWR VGND sg13cmos5l_and2_1
X_5997__363 _5997_/RESET_B VPWR VGND sg13cmos5l_tiehi
XFILLER_46_826 VPWR VGND sg13cmos5l_decap_8
Xhold1151 _5831_/D _3817_/Y VPWR VGND sg13cmos5l_dlygate4sd3_1
Xhold1140 _3112_/A _5437_/Q VPWR VGND sg13cmos5l_dlygate4sd3_1
XFILLER_46_837 VPWR VGND sg13cmos5l_fill_1
Xhold1173 _5340_/A0 _5473_/Q VPWR VGND sg13cmos5l_dlygate4sd3_1
Xhold1162 _5994_/D _4822_/Y VPWR VGND sg13cmos5l_dlygate4sd3_1
Xhold1184 _4304_/A1 _5875_/Q VPWR VGND sg13cmos5l_dlygate4sd3_1
XFILLER_26_550 VPWR VGND sg13cmos5l_decap_4
XFILLER_33_509 VPWR VGND sg13cmos5l_fill_2
Xhold1195 _3296_/A1 _5609_/Q VPWR VGND sg13cmos5l_dlygate4sd3_1
XFILLER_41_531 VPWR VGND sg13cmos5l_fill_1
XFILLER_16_1020 VPWR VGND sg13cmos5l_decap_8
XFILLER_41_586 VPWR VGND sg13cmos5l_fill_2
XFILLER_10_951 VPWR VGND sg13cmos5l_fill_1
Xclkload18 clkload18/X _6061_/CLK VPWR VGND sg13cmos5l_buf_8
X_4970_ _4970_/Y _5991_/Q _4970_/B VPWR VGND sg13cmos5l_nor2_1
X_3921_ _3921_/Y _3971_/S _5454_/Q _4098_/A1 VPWR VGND sg13cmos5l_o21ai_1
X_3852_ _3852_/Y _3852_/A _5846_/Q VPWR VGND sg13cmos5l_nor2_1
X_5522_ _5522_/Q _5559_/CLK _5522_/D _5522_/RESET_B VPWR VGND sg13cmos5l_dfrbpq_1
X_3783_ _3783_/Y _3784_/B _3783_/B VPWR VGND sg13cmos5l_nand2b_1
X_5453_ _5453_/Q _5840_/CLK _5453_/D _5453_/RESET_B VPWR VGND sg13cmos5l_dfrbpq_1
X_4404_ _4413_/B _5893_/Q _5891_/Q _5892_/Q VPWR VGND sg13cmos5l_or3_1
X_5384_ _5512_/D _5384_/A0 _5421_/A1 _5389_/S VPWR VGND sg13cmos5l_mux2_1
X_5599__821 _5599_/RESET_B VPWR VGND sg13cmos5l_tiehi
X_4335_ _4335_/Y _4335_/A _4335_/B VPWR VGND sg13cmos5l_nand2_1
Xfanout205 _3393_/A0 _5375_/A0 VPWR VGND sg13cmos5l_buf_1
Xfanout238 _3251_/A _5367_/A1 VPWR VGND sg13cmos5l_buf_1
Xfanout227 _5398_/A0 _5417_/A0 VPWR VGND sg13cmos5l_buf_1
Xfanout216 _5354_/A0 _5411_/A0 VPWR VGND sg13cmos5l_buf_1
X_4266_ _4268_/A _4266_/A _4266_/B VPWR VGND sg13cmos5l_or2_1
Xfanout249 _5304_/C input1/X VPWR VGND sg13cmos5l_buf_1
X_3217_ _3217_/Y _3217_/A _5423_/S VPWR VGND sg13cmos5l_nand2_1
X_4197_ _4205_/B _4195_/Y _4196_/Y _4194_/Y VPWR VGND sg13cmos5l_a21oi_1
X_6005_ _6005_/Q _6005_/CLK _6005_/D _6005_/RESET_B VPWR VGND sg13cmos5l_dfrbpq_1
X_3148_ _4639_/A _5959_/Q VPWR VGND sg13cmos5l_inv_1
XFILLER_39_174 VPWR VGND sg13cmos5l_fill_1
X_3079_ _4442_/B _3079_/A VPWR VGND sg13cmos5l_inv_1
XFILLER_42_339 VPWR VGND sg13cmos5l_fill_1
X_6025__330 _6025_/RESET_B VPWR VGND sg13cmos5l_tiehi
XFILLER_3_947 VPWR VGND sg13cmos5l_fill_1
XFILLER_3_936 VPWR VGND sg13cmos5l_fill_1
XFILLER_3_925 VPWR VGND sg13cmos5l_decap_8
XFILLER_2_446 VPWR VGND sg13cmos5l_fill_2
XFILLER_49_76 VPWR VGND sg13cmos5l_fill_2
XFILLER_46_689 VPWR VGND sg13cmos5l_fill_1
XFILLER_33_328 VPWR VGND sg13cmos5l_fill_2
XFILLER_14_597 VPWR VGND sg13cmos5l_fill_1
X_4120_ _5854_/D _4120_/A VPWR VGND sg13cmos5l_inv_1
XFILLER_49_450 VPWR VGND sg13cmos5l_decap_8
X_4051_ _4051_/Y _4044_/Y _4050_/Y _4042_/Y VPWR VGND sg13cmos5l_o21ai_1
Xinput5 input5/X ui_in[3] VPWR VGND sg13cmos5l_buf_1
XFILLER_36_177 VPWR VGND sg13cmos5l_fill_1
X_4953_ _4953_/Y _4953_/A _4953_/B VPWR VGND sg13cmos5l_xnor2_1
X_3904_ _3904_/Y _4040_/S1 _3903_/Y _3880_/A VPWR VGND sg13cmos5l_o21ai_1
XFILLER_20_501 VPWR VGND sg13cmos5l_fill_1
X_4884_ _4884_/Y _4849_/Y _4857_/X _4883_/Y VPWR VGND sg13cmos5l_a21oi_1
X_3835_ _3835_/Y _3844_/A VPWR VGND sg13cmos5l_inv_1
XFILLER_20_534 VPWR VGND sg13cmos5l_fill_1
X_3766_ _3782_/D _3767_/B _3767_/C _3767_/A VPWR VGND sg13cmos5l_a21oi_1
X_5505_ _5505_/Q _5692_/CLK _5505_/D _5505_/RESET_B VPWR VGND sg13cmos5l_dfrbpq_1
X_3697_ _3697_/Y _3760_/A1 _3694_/Y _3139_/A VPWR VGND sg13cmos5l_o21ai_1
X_5436_ _5436_/Q _5840_/CLK _5436_/D _5436_/RESET_B VPWR VGND sg13cmos5l_dfrbpq_1
XFILLER_10_59 VPWR VGND sg13cmos5l_fill_1
X_5367_ _5497_/D _5367_/A0 _5367_/A1 _5370_/S VPWR VGND sg13cmos5l_mux2_1
X_5298_ _5298_/Y _5298_/A _5301_/S VPWR VGND sg13cmos5l_nand2_1
X_4318_ _4327_/B _4316_/Y _4317_/Y _4315_/Y VPWR VGND sg13cmos5l_a21oi_1
X_4249_ _5888_/D _4313_/B _4341_/A VPWR VGND sg13cmos5l_and2_1
XFILLER_28_601 VPWR VGND sg13cmos5l_fill_1
XFILLER_35_34 VPWR VGND sg13cmos5l_fill_2
XFILLER_43_648 VPWR VGND sg13cmos5l_decap_8
XFILLER_43_637 VPWR VGND sg13cmos5l_decap_8
X_5827__575 _5827_/RESET_B VPWR VGND sg13cmos5l_tiehi
XFILLER_47_921 VPWR VGND sg13cmos5l_decap_8
XFILLER_19_601 VPWR VGND sg13cmos5l_fill_2
XFILLER_19_645 VPWR VGND sg13cmos5l_fill_2
XFILLER_47_998 VPWR VGND sg13cmos5l_decap_8
XFILLER_46_464 VPWR VGND sg13cmos5l_decap_8
XFILLER_18_177 VPWR VGND sg13cmos5l_fill_1
XFILLER_15_840 VPWR VGND sg13cmos5l_fill_2
X_5589__831 _5589_/RESET_B VPWR VGND sg13cmos5l_tiehi
XFILLER_14_361 VPWR VGND sg13cmos5l_decap_8
XFILLER_15_884 VPWR VGND sg13cmos5l_decap_8
XFILLER_15_895 VPWR VGND sg13cmos5l_decap_4
XFILLER_41_180 VPWR VGND sg13cmos5l_fill_1
X_3620_ _3840_/B _3838_/A _3620_/B VPWR VGND sg13cmos5l_and2_1
X_3551_ _5767_/D _3613_/A1 _3555_/B _3550_/Y VPWR VGND sg13cmos5l_a21oi_1
X_5509__534 _5509_/RESET_B VPWR VGND sg13cmos5l_tiehi
XFILLER_6_582 VPWR VGND sg13cmos5l_fill_1
X_3482_ _5734_/D _3518_/A1 _3481_/B _3481_/Y VPWR VGND sg13cmos5l_o21ai_1
X_5221_ _5221_/Y _6014_/Q _5218_/B VPWR VGND sg13cmos5l_nor2b_1
X_5152_ _5152_/Y _6067_/Q _6066_/Q VPWR VGND sg13cmos5l_nand2b_1
X_4103_ _4103_/Y _4105_/S _3124_/Y _4107_/B1 VPWR VGND sg13cmos5l_a21oi_1
X_5596__824 _5596_/RESET_B VPWR VGND sg13cmos5l_tiehi
X_5083_ _5083_/Y _5083_/A VPWR VGND sg13cmos5l_inv_1
XFILLER_2_60 VPWR VGND sg13cmos5l_fill_1
XFILLER_2_93 VPWR VGND sg13cmos5l_fill_2
X_4034_ _4034_/Y _4031_/Y _4033_/Y _4026_/Y VPWR VGND sg13cmos5l_o21ai_1
XFILLER_37_453 VPWR VGND sg13cmos5l_decap_8
X_5985_ _5985_/Q _6037_/CLK _5985_/D _5985_/RESET_B VPWR VGND sg13cmos5l_dfrbpq_1
X_4936_ _5232_/A _4936_/A _5201_/B VPWR VGND sg13cmos5l_nor2_1
X_4867_ _4868_/B _4867_/A _4867_/B VPWR VGND sg13cmos5l_xnor2_1
X_3818_ _3818_/Y _5831_/Q _3812_/Y _3815_/Y VPWR VGND sg13cmos5l_a21oi_1
X_4798_ _4798_/Y _4799_/B VPWR VGND sg13cmos5l_inv_1
X_3749_ _3749_/Y _5758_/Q _3749_/B VPWR VGND sg13cmos5l_nand2b_1
X_5419_ _5544_/D _5419_/A0 _5419_/A1 _5422_/S VPWR VGND sg13cmos5l_mux2_1
XFILLER_29_965 VPWR VGND sg13cmos5l_fill_2
XFILLER_46_88 VPWR VGND sg13cmos5l_fill_1
XFILLER_43_489 VPWR VGND sg13cmos5l_decap_8
XFILLER_23_191 VPWR VGND sg13cmos5l_fill_1
XFILLER_8_869 VPWR VGND sg13cmos5l_decap_8
XFILLER_11_80 VPWR VGND sg13cmos5l_fill_2
XFILLER_47_751 VPWR VGND sg13cmos5l_fill_1
X_5770_ _5770_/Q clkload7/A _5770_/D _5770_/RESET_B VPWR VGND sg13cmos5l_dfrbpq_1
X_4721_ _4951_/A _6006_/Q _4785_/A VPWR VGND sg13cmos5l_xnor2_1
X_4652_ _5968_/D _4652_/A _4710_/A VPWR VGND sg13cmos5l_nor2_1
X_3603_ _3603_/Y _3615_/A1 _3602_/B _3602_/Y VPWR VGND sg13cmos5l_o21ai_1
XFILLER_30_684 VPWR VGND sg13cmos5l_fill_2
XFILLER_30_695 VPWR VGND sg13cmos5l_fill_2
X_4583_ _4583_/Y _4584_/B _4584_/C _4584_/A VPWR VGND sg13cmos5l_a21oi_1
X_3534_ _3534_/Y _3534_/A _3543_/B VPWR VGND sg13cmos5l_nor2_1
X_3465_ _3465_/Y _3465_/A _3467_/S VPWR VGND sg13cmos5l_nand2_1
X_5204_ _5204_/Y _5204_/A VPWR VGND sg13cmos5l_inv_1
X_3396_ _5694_/D _3374_/A _3396_/A1 _3397_/S VPWR VGND sg13cmos5l_mux2_1
Xhold1503 _4438_/C _5942_/Q VPWR VGND sg13cmos5l_dlygate4sd3_1
Xhold1514 _3803_/A _5829_/Q VPWR VGND sg13cmos5l_dlygate4sd3_1
X_5135_ _5136_/B _6067_/Q _5148_/B _6062_/Q VPWR VGND sg13cmos5l_nand3b_1
Xhold1525 _5927_/D _4464_/Y VPWR VGND sg13cmos5l_dlygate4sd3_1
Xhold1536 _3412_/A _5824_/Q VPWR VGND sg13cmos5l_dlygate4sd3_1
Xhold1558 _6020_/D _4992_/Y VPWR VGND sg13cmos5l_dlygate4sd3_1
X_5066_ _6037_/D _5051_/B _5069_/A _5065_/Y VPWR VGND sg13cmos5l_a21oi_1
Xhold1547 _6021_/D _4995_/Y VPWR VGND sg13cmos5l_dlygate4sd3_1
X_4017_ _4017_/Y _4022_/B _5693_/Q _4016_/Y VPWR VGND sg13cmos5l_o21ai_1
Xhold1569 _5284_/B _5279_/B VPWR VGND sg13cmos5l_dlygate4sd3_1
XFILLER_37_250 VPWR VGND sg13cmos5l_fill_1
XFILLER_37_272 VPWR VGND sg13cmos5l_fill_1
XFILLER_38_795 VPWR VGND sg13cmos5l_fill_2
XFILLER_26_968 VPWR VGND sg13cmos5l_decap_4
X_5968_ _5968_/Q _6007_/CLK _5968_/D _5968_/RESET_B VPWR VGND sg13cmos5l_dfrbpq_1
X_4919_ _4919_/Y _4913_/Y _4914_/X _4932_/B VPWR VGND sg13cmos5l_o21ai_1
XFILLER_40_448 VPWR VGND sg13cmos5l_decap_8
XFILLER_21_662 VPWR VGND sg13cmos5l_fill_1
X_5899_ _5899_/Q _6080_/CLK _5899_/D _5899_/RESET_B VPWR VGND sg13cmos5l_dfrbpq_1
XFILLER_48_537 VPWR VGND sg13cmos5l_decap_8
XFILLER_44_732 VPWR VGND sg13cmos5l_fill_2
XFILLER_17_957 VPWR VGND sg13cmos5l_decap_8
XFILLER_28_272 VPWR VGND sg13cmos5l_fill_2
XFILLER_44_743 VPWR VGND sg13cmos5l_decap_4
XFILLER_16_445 VPWR VGND sg13cmos5l_fill_2
XFILLER_44_787 VPWR VGND sg13cmos5l_decap_8
X_5586__834 _5586_/RESET_B VPWR VGND sg13cmos5l_tiehi
XFILLER_4_861 VPWR VGND sg13cmos5l_fill_1
X_3250_ _5573_/D _5357_/A0 _3250_/A1 _3253_/B VPWR VGND sg13cmos5l_mux2_1
XFILLER_26_1000 VPWR VGND sg13cmos5l_fill_1
X_3181_ _3182_/B _4086_/A1 _3177_/X _3180_/Y VPWR VGND sg13cmos5l_a21oi_1
XFILLER_39_537 VPWR VGND sg13cmos5l_fill_2
X_5593__827 _5593_/RESET_B VPWR VGND sg13cmos5l_tiehi
XFILLER_47_581 VPWR VGND sg13cmos5l_decap_8
X_5822_ _5822_/Q _5822_/CLK _5822_/D _5822_/RESET_B VPWR VGND sg13cmos5l_dfrbpq_1
XFILLER_23_949 VPWR VGND sg13cmos5l_decap_8
X_5753_ _5753_/Q _5834_/CLK _5753_/D _5753_/RESET_B VPWR VGND sg13cmos5l_dfrbpq_1
X_5949__293 _5949_/D VPWR VGND sg13cmos5l_tielo
XFILLER_31_982 VPWR VGND sg13cmos5l_decap_8
X_4704_ _4704_/Y _4691_/A _4708_/A _4655_/B VPWR VGND sg13cmos5l_o21ai_1
X_5684_ _5684_/Q clkload1/A _5684_/D _5684_/RESET_B VPWR VGND sg13cmos5l_dfrbpq_1
X_4635_ _4635_/Y _4635_/A1 _4637_/S _4655_/B VPWR VGND sg13cmos5l_o21ai_1
X_4566_ _5946_/D _4638_/A _4566_/B VPWR VGND sg13cmos5l_nor2_1
X_3517_ _3517_/Y _3517_/A _3517_/B VPWR VGND sg13cmos5l_nand2_1
X_4497_ _4497_/X _5938_/Q _4505_/B _4494_/B VPWR VGND sg13cmos5l_a21o_1
X_3448_ _3448_/Y _3448_/A _3452_/B VPWR VGND sg13cmos5l_nor2_1
X_3379_ _5680_/D _3379_/A0 _5373_/A0 _3388_/S VPWR VGND sg13cmos5l_mux2_1
Xhold1300 _3387_/A0 _5686_/Q VPWR VGND sg13cmos5l_dlygate4sd3_1
Xhold1311 _5395_/A1 _5522_/Q VPWR VGND sg13cmos5l_dlygate4sd3_1
Xhold1333 _3315_/A1 _5626_/Q VPWR VGND sg13cmos5l_dlygate4sd3_1
Xhold1322 _3273_/A0 _5588_/Q VPWR VGND sg13cmos5l_dlygate4sd3_1
X_5118_ _6043_/D _5272_/A _5118_/B VPWR VGND sg13cmos5l_nor2_1
Xhold1377 _3480_/A1 _5733_/Q VPWR VGND sg13cmos5l_dlygate4sd3_1
Xhold1355 _3320_/A0 _5630_/Q VPWR VGND sg13cmos5l_dlygate4sd3_1
Xhold1344 _3271_/A0 _5586_/Q VPWR VGND sg13cmos5l_dlygate4sd3_1
Xheichips26_dna_sequencer_271 uio_out[2] VPWR VGND sg13cmos5l_tielo
Xhold1366 _3276_/A0 _5591_/Q VPWR VGND sg13cmos5l_dlygate4sd3_1
Xhold1388 _5330_/A0 _5464_/Q VPWR VGND sg13cmos5l_dlygate4sd3_1
X_5049_ _5049_/X _4935_/B _5048_/B _5048_/Y VPWR VGND sg13cmos5l_a21o_1
Xhold1399 _5407_/A0 _5533_/Q VPWR VGND sg13cmos5l_dlygate4sd3_1
XFILLER_13_437 VPWR VGND sg13cmos5l_fill_2
XFILLER_22_982 VPWR VGND sg13cmos5l_fill_1
XFILLER_21_492 VPWR VGND sg13cmos5l_decap_4
XFILLER_49_1022 VPWR VGND sg13cmos5l_decap_8
XFILLER_48_301 VPWR VGND sg13cmos5l_fill_1
XFILLER_49_868 VPWR VGND sg13cmos5l_decap_8
XFILLER_49_879 VPWR VGND sg13cmos5l_fill_2
XFILLER_1_1002 VPWR VGND sg13cmos5l_decap_8
XFILLER_13_993 VPWR VGND sg13cmos5l_fill_1
X_4420_ _4421_/B _4475_/A _4420_/B _4423_/C VPWR VGND sg13cmos5l_nand3_1
X_4351_ _4353_/A _4350_/Y _4351_/B VPWR VGND sg13cmos5l_nand2b_1
X_3302_ _5614_/D _3302_/A0 _5375_/A0 _3307_/S VPWR VGND sg13cmos5l_mux2_1
X_4282_ _4282_/Y _4478_/A _5872_/Q _4281_/Y VPWR VGND sg13cmos5l_o21ai_1
X_3233_ _5560_/D _3233_/A0 _5418_/A1 _3241_/S VPWR VGND sg13cmos5l_mux2_1
X_6021_ _6021_/Q _6056_/CLK _6021_/D _6021_/RESET_B VPWR VGND sg13cmos5l_dfrbpq_1
X_3164_ _3164_/X _5466_/Q _5449_/Q _4105_/S VPWR VGND sg13cmos5l_mux2_1
X_3095_ _4478_/A _4239_/A VPWR VGND sg13cmos5l_inv_1
XFILLER_39_378 VPWR VGND sg13cmos5l_fill_2
XFILLER_22_201 VPWR VGND sg13cmos5l_fill_2
Xfanout38 _3418_/B _3417_/Y VPWR VGND sg13cmos5l_buf_1
XFILLER_22_212 VPWR VGND sg13cmos5l_fill_2
Xfanout27 _4307_/A2 _3864_/X VPWR VGND sg13cmos5l_buf_1
X_5805_ _5805_/Q clkload8/A _5805_/D _5805_/RESET_B VPWR VGND sg13cmos5l_dfrbpq_1
Xfanout49 _3555_/B _3554_/S VPWR VGND sg13cmos5l_buf_1
X_3997_ _4003_/B _4041_/A _3997_/B _3997_/C VPWR VGND sg13cmos5l_nor3_1
X_5736_ _5736_/Q _5825_/CLK _5736_/D _5736_/RESET_B VPWR VGND sg13cmos5l_dfrbpq_1
X_5667_ _5667_/Q clkload1/A _5667_/D _5667_/RESET_B VPWR VGND sg13cmos5l_dfrbpq_1
X_4618_ _4618_/Y _4618_/A _4618_/B VPWR VGND sg13cmos5l_nand2_1
X_5923__296 _5923_/D VPWR VGND sg13cmos5l_tielo
X_5598_ _5598_/Q _5840_/CLK _5598_/D _5598_/RESET_B VPWR VGND sg13cmos5l_dfrbpq_1
X_4549_ _4573_/B _5949_/Q _4549_/B VPWR VGND sg13cmos5l_xor2_1
XFILLER_2_617 VPWR VGND sg13cmos5l_fill_2
Xhold1141 _3637_/A _5820_/Q VPWR VGND sg13cmos5l_dlygate4sd3_1
Xhold1130 _3116_/A _5581_/Q VPWR VGND sg13cmos5l_dlygate4sd3_1
Xhold1185 _3305_/A0 _5617_/Q VPWR VGND sg13cmos5l_dlygate4sd3_1
Xhold1163 _4998_/B _5992_/Q VPWR VGND sg13cmos5l_dlygate4sd3_1
Xhold1152 _3074_/A _5961_/Q VPWR VGND sg13cmos5l_dlygate4sd3_1
Xhold1174 _3294_/A1 _5607_/Q VPWR VGND sg13cmos5l_dlygate4sd3_1
Xhold1196 _4999_/A1 _5993_/Q VPWR VGND sg13cmos5l_dlygate4sd3_1
XFILLER_13_223 VPWR VGND sg13cmos5l_fill_2
XFILLER_41_521 VPWR VGND sg13cmos5l_fill_2
XFILLER_9_205 VPWR VGND sg13cmos5l_fill_2
XFILLER_41_554 VPWR VGND sg13cmos5l_fill_2
XFILLER_9_238 VPWR VGND sg13cmos5l_fill_2
XFILLER_6_912 VPWR VGND sg13cmos5l_decap_8
Xclkload19 clkload19/Y _6067_/CLK VPWR VGND sg13cmos5l_inv_2
XFILLER_10_996 VPWR VGND sg13cmos5l_decap_4
XFILLER_6_989 VPWR VGND sg13cmos5l_decap_8
XFILLER_49_643 VPWR VGND sg13cmos5l_decap_8
XFILLER_49_665 VPWR VGND sg13cmos5l_decap_4
XFILLER_48_131 VPWR VGND sg13cmos5l_fill_1
X_5837__555 _5837_/RESET_B VPWR VGND sg13cmos5l_tiehi
XFILLER_37_805 VPWR VGND sg13cmos5l_fill_1
XFILLER_37_816 VPWR VGND sg13cmos5l_decap_4
XFILLER_49_698 VPWR VGND sg13cmos5l_fill_1
XFILLER_37_849 VPWR VGND sg13cmos5l_fill_2
XFILLER_36_337 VPWR VGND sg13cmos5l_decap_4
X_3920_ _3920_/Y _3971_/S _5488_/Q _3919_/Y VPWR VGND sg13cmos5l_o21ai_1
X_3851_ _3851_/Y _5845_/Q _3851_/B VPWR VGND sg13cmos5l_nor2_1
X_3782_ _3783_/B _3782_/A _5816_/Q _5815_/Q _3782_/D VPWR VGND sg13cmos5l_nand4_1
X_5521_ _5521_/Q _5674_/CLK _5521_/D _5521_/RESET_B VPWR VGND sg13cmos5l_dfrbpq_1
X_5452_ _5452_/Q clkload6/A _5452_/D _5452_/RESET_B VPWR VGND sg13cmos5l_dfrbpq_1
X_4403_ _5917_/D _4460_/A _4403_/B VPWR VGND sg13cmos5l_nor2_1
X_5383_ _5511_/D _5383_/A0 _5420_/A1 _5389_/S VPWR VGND sg13cmos5l_mux2_1
X_4334_ _4334_/X _4334_/A _4334_/B VPWR VGND sg13cmos5l_xor2_1
Xfanout228 _5302_/A _5322_/A1 VPWR VGND sg13cmos5l_buf_1
Xfanout217 _5411_/A0 input7/X VPWR VGND sg13cmos5l_buf_1
Xfanout206 _5375_/A0 input9/X VPWR VGND sg13cmos5l_buf_1
Xfanout239 _3372_/A _5367_/A1 VPWR VGND sg13cmos5l_buf_1
X_4265_ _4266_/B _4265_/A _4271_/A VPWR VGND sg13cmos5l_nor2_1
X_6004_ _6004_/Q _6005_/CLK _6004_/D _6004_/RESET_B VPWR VGND sg13cmos5l_dfrbpq_1
X_3216_ _5549_/D _3117_/Y _5423_/S _3215_/Y VPWR VGND sg13cmos5l_o21ai_1
X_4196_ _4196_/Y _5875_/Q _5856_/Q VPWR VGND sg13cmos5l_xnor2_1
X_3147_ _3147_/Y _6018_/Q VPWR VGND sg13cmos5l_inv_1
X_3078_ _3078_/Y _4200_/A VPWR VGND sg13cmos5l_inv_1
XFILLER_11_705 VPWR VGND sg13cmos5l_fill_1
X_5719_ _5719_/Q _6074_/CLK _5719_/D _5719_/RESET_B VPWR VGND sg13cmos5l_dfrbpq_1
XFILLER_40_46 VPWR VGND sg13cmos5l_fill_1
XFILLER_46_1025 VPWR VGND sg13cmos5l_decap_4
XFILLER_34_808 VPWR VGND sg13cmos5l_fill_1
XFILLER_42_885 VPWR VGND sg13cmos5l_decap_8
XFILLER_2_992 VPWR VGND sg13cmos5l_decap_8
X_4050_ _4050_/Y _4048_/Y _4049_/Y _3881_/A VPWR VGND sg13cmos5l_o21ai_1
Xinput6 input6/X uio_in[0] VPWR VGND sg13cmos5l_buf_1
XFILLER_18_882 VPWR VGND sg13cmos5l_fill_1
X_4952_ _4952_/Y _4750_/B _4943_/A _4946_/X _4950_/Y _4951_/X VPWR VGND sg13cmos5l_a221oi_1
X_3903_ _3903_/Y _4036_/B _5626_/Q _3902_/Y VPWR VGND sg13cmos5l_o21ai_1
X_4883_ _4883_/Y _4883_/A _4883_/B VPWR VGND sg13cmos5l_nor2_1
X_3834_ _3844_/A _3838_/A _3838_/B VPWR VGND sg13cmos5l_nor2b_1
XFILLER_20_557 VPWR VGND sg13cmos5l_fill_1
XFILLER_9_580 VPWR VGND sg13cmos5l_fill_1
X_3765_ _5814_/D _5429_/A _3765_/B VPWR VGND sg13cmos5l_nor2_1
X_3696_ _3699_/B _3714_/A _3696_/B VPWR VGND sg13cmos5l_nor2_1
X_5504_ _5504_/Q _5674_/CLK _5504_/D _5504_/RESET_B VPWR VGND sg13cmos5l_dfrbpq_1
X_5435_ _5435_/Q _5853_/CLK _5435_/D _5435_/RESET_B VPWR VGND sg13cmos5l_dfrbpq_1
X_5366_ _5496_/D _5366_/A0 _5414_/A0 _5370_/S VPWR VGND sg13cmos5l_mux2_1
XFILLER_0_907 VPWR VGND sg13cmos5l_fill_1
X_5297_ _5436_/D _5297_/A0 _5356_/A0 _5301_/S VPWR VGND sg13cmos5l_mux2_1
X_4317_ _4317_/Y _5901_/Q _5878_/Q VPWR VGND sg13cmos5l_xnor2_1
X_4248_ _4341_/A _4235_/B _4247_/Y _4248_/S VPWR VGND sg13cmos5l_mux2_1
X_4179_ _4179_/Y _4283_/B _4175_/Y _4178_/Y VPWR VGND sg13cmos5l_a21oi_1
XFILLER_27_156 VPWR VGND sg13cmos5l_fill_1
XFILLER_27_167 VPWR VGND sg13cmos5l_fill_2
XFILLER_11_535 VPWR VGND sg13cmos5l_fill_1
Xclkbuf_3_3__f_clk clkbuf_leaf_6_clk/A clkbuf_0_clk/X VPWR VGND sg13cmos5l_buf_8
XFILLER_46_443 VPWR VGND sg13cmos5l_decap_8
XFILLER_18_123 VPWR VGND sg13cmos5l_fill_1
XFILLER_47_977 VPWR VGND sg13cmos5l_decap_8
XFILLER_41_170 VPWR VGND sg13cmos5l_fill_1
X_3550_ _3550_/Y _3550_/A _3555_/B VPWR VGND sg13cmos5l_nor2_1
X_5220_ _5238_/A _5220_/A VPWR VGND sg13cmos5l_inv_1
X_3481_ _3481_/Y _3481_/A _3481_/B VPWR VGND sg13cmos5l_nand2_1
X_5151_ _5151_/Y _6050_/Q _5149_/Y _5150_/Y VPWR VGND sg13cmos5l_o21ai_1
X_5082_ _5083_/A _6041_/Q _5082_/B VPWR VGND sg13cmos5l_xor2_1
X_4102_ _4102_/Y _4102_/A _4102_/B VPWR VGND sg13cmos5l_nor2_1
X_4033_ _4033_/Y _4101_/A _4032_/X _4012_/A VPWR VGND sg13cmos5l_o21ai_1
X_5984_ _5984_/Q _6005_/CLK _5984_/D _5984_/RESET_B VPWR VGND sg13cmos5l_dfrbpq_1
X_4935_ _6011_/D _5011_/B _4935_/B VPWR VGND sg13cmos5l_and2_1
XFILLER_21_800 VPWR VGND sg13cmos5l_fill_1
XFILLER_36_1024 VPWR VGND sg13cmos5l_decap_4
X_4866_ _4866_/Y _4866_/A _4866_/B _4866_/C VPWR VGND sg13cmos5l_nand3_1
X_3817_ _3817_/Y _3162_/A _3814_/Y _3816_/Y VPWR VGND sg13cmos5l_a21oi_1
X_4797_ _4799_/B _5959_/Q _4795_/Y _4796_/Y VPWR VGND sg13cmos5l_o21ai_1
X_3748_ _3748_/Y _3755_/S _5716_/Q _3747_/Y VPWR VGND sg13cmos5l_o21ai_1
X_3679_ _3681_/B _3714_/A _3679_/B VPWR VGND sg13cmos5l_nor2_1
X_5418_ _5543_/D _5418_/A0 _5418_/A1 _5423_/S VPWR VGND sg13cmos5l_mux2_1
X_5349_ _5481_/D _5349_/A0 _5416_/A0 _5351_/S VPWR VGND sg13cmos5l_mux2_1
XFILLER_43_1028 VPWR VGND sg13cmos5l_fill_1
XFILLER_43_1017 VPWR VGND sg13cmos5l_decap_8
XFILLER_43_402 VPWR VGND sg13cmos5l_fill_2
XFILLER_43_468 VPWR VGND sg13cmos5l_decap_8
XFILLER_7_314 VPWR VGND sg13cmos5l_fill_2
XFILLER_8_848 VPWR VGND sg13cmos5l_decap_8
XFILLER_19_432 VPWR VGND sg13cmos5l_fill_1
XFILLER_47_774 VPWR VGND sg13cmos5l_fill_1
XFILLER_19_454 VPWR VGND sg13cmos5l_decap_8
XFILLER_35_914 VPWR VGND sg13cmos5l_fill_2
XFILLER_47_785 VPWR VGND sg13cmos5l_decap_4
XFILLER_46_262 VPWR VGND sg13cmos5l_fill_1
XFILLER_15_671 VPWR VGND sg13cmos5l_fill_2
XFILLER_14_192 VPWR VGND sg13cmos5l_fill_1
X_4720_ _4727_/B _5978_/Q _5977_/Q _5979_/Q VPWR VGND sg13cmos5l_o21ai_1
X_4651_ _5967_/D _4651_/A _4655_/B VPWR VGND sg13cmos5l_and2_1
X_3602_ _3602_/Y _3602_/A _3602_/B VPWR VGND sg13cmos5l_nand2_1
X_4582_ _4582_/X _4584_/B _4584_/C VPWR VGND sg13cmos5l_and2_1
X_3533_ _3542_/S _3533_/A _3545_/C VPWR VGND sg13cmos5l_nor2_1
XFILLER_42_0 VPWR VGND sg13cmos5l_fill_2
X_3464_ _5725_/D _3501_/A1 _3468_/B _3463_/Y VPWR VGND sg13cmos5l_o21ai_1
X_5203_ _5204_/A _6014_/Q _6015_/Q _6016_/Q VPWR VGND sg13cmos5l_o21ai_1
X_3395_ _5693_/D _3372_/A _3395_/A1 _3397_/S VPWR VGND sg13cmos5l_mux2_1
X_5134_ _5134_/Y _6023_/Q _5134_/B _5148_/B VPWR VGND sg13cmos5l_nor3_1
Xhold1515 _5829_/D _3806_/Y VPWR VGND sg13cmos5l_dlygate4sd3_1
Xhold1526 _4996_/B _6022_/Q VPWR VGND sg13cmos5l_dlygate4sd3_1
Xhold1504 _3128_/A _5871_/Q VPWR VGND sg13cmos5l_dlygate4sd3_1
Xhold1537 _3791_/B _3790_/Y VPWR VGND sg13cmos5l_dlygate4sd3_1
X_5065_ _5065_/Y _5051_/A _5069_/A _5011_/B VPWR VGND sg13cmos5l_o21ai_1
Xhold1548 _3839_/B1 _5842_/Q VPWR VGND sg13cmos5l_dlygate4sd3_1
Xhold1559 _4651_/A _5940_/Q VPWR VGND sg13cmos5l_dlygate4sd3_1
X_4016_ _4016_/Y _4022_/B _3119_/Y _4024_/A1 VPWR VGND sg13cmos5l_a21oi_1
XFILLER_38_763 VPWR VGND sg13cmos5l_fill_2
XFILLER_26_936 VPWR VGND sg13cmos5l_fill_1
XFILLER_37_295 VPWR VGND sg13cmos5l_fill_1
XFILLER_25_468 VPWR VGND sg13cmos5l_decap_8
X_5967_ _5967_/Q _5994_/CLK _5967_/D _5967_/RESET_B VPWR VGND sg13cmos5l_dfrbpq_1
X_4918_ _4932_/B _4978_/B _4918_/B VPWR VGND sg13cmos5l_xnor2_1
Xclkbuf_leaf_32_clk _6074_/CLK clkbuf_3_4__f_clk/X VPWR VGND sg13cmos5l_buf_8
X_5898_ _5898_/Q _5936_/CLK _5898_/D _5898_/RESET_B VPWR VGND sg13cmos5l_dfrbpq_1
XFILLER_21_685 VPWR VGND sg13cmos5l_fill_2
X_4849_ _4849_/Y _6003_/Q _4867_/B VPWR VGND sg13cmos5l_nor2_1
XFILLER_48_516 VPWR VGND sg13cmos5l_decap_8
XFILLER_29_774 VPWR VGND sg13cmos5l_fill_2
XFILLER_28_251 VPWR VGND sg13cmos5l_decap_4
XFILLER_17_969 VPWR VGND sg13cmos5l_fill_1
Xclkbuf_leaf_23_clk _6080_/CLK clkbuf_3_6__f_clk/X VPWR VGND sg13cmos5l_buf_8
X_3180_ _3180_/Y _4086_/A1 _3179_/Y _4067_/A VPWR VGND sg13cmos5l_o21ai_1
X_5476__604 _5476_/RESET_B VPWR VGND sg13cmos5l_tiehi
XFILLER_47_560 VPWR VGND sg13cmos5l_decap_8
X_5821_ _5821_/Q _5822_/CLK _5821_/D _5821_/RESET_B VPWR VGND sg13cmos5l_dfrbpq_1
X_5752_ _5752_/Q _6063_/CLK _5752_/D _5752_/RESET_B VPWR VGND sg13cmos5l_dfrbpq_1
Xclkbuf_leaf_14_clk _5860_/CLK clkbuf_leaf_6_clk/A VPWR VGND sg13cmos5l_buf_8
X_4703_ _5972_/D _4703_/A _4703_/B VPWR VGND sg13cmos5l_and2_1
X_5683_ _5683_/Q clkload1/A _5683_/D _5683_/RESET_B VPWR VGND sg13cmos5l_dfrbpq_1
XFILLER_30_460 VPWR VGND sg13cmos5l_decap_4
X_4634_ _5955_/D _4710_/A _4634_/B VPWR VGND sg13cmos5l_nor2_1
X_4565_ _4566_/B _4657_/A _4657_/B VPWR VGND sg13cmos5l_and2_1
X_3516_ _5751_/D _3440_/A _3516_/A1 _3517_/B VPWR VGND sg13cmos5l_mux2_1
X_4496_ _4496_/Y _4496_/A _4505_/B VPWR VGND sg13cmos5l_nand2_1
X_5541__952 _5541_/RESET_B VPWR VGND sg13cmos5l_tiehi
X_3447_ _5717_/D _3509_/A1 _3452_/B _3446_/Y VPWR VGND sg13cmos5l_a21oi_1
X_3378_ _5679_/D _3378_/A0 _5418_/A1 _3388_/S VPWR VGND sg13cmos5l_mux2_1
Xhold1323 _3492_/A1 _5739_/Q VPWR VGND sg13cmos5l_dlygate4sd3_1
X_5117_ _5118_/B _5120_/S _5116_/Y _5115_/Y VPWR VGND sg13cmos5l_a21o_1
Xhold1301 _5332_/A0 _5466_/Q VPWR VGND sg13cmos5l_dlygate4sd3_1
Xhold1312 _5316_/A0 _5451_/Q VPWR VGND sg13cmos5l_dlygate4sd3_1
Xhold1334 _3314_/A1 _5625_/Q VPWR VGND sg13cmos5l_dlygate4sd3_1
Xhold1345 _3333_/A1 _5641_/Q VPWR VGND sg13cmos5l_dlygate4sd3_1
XFILLER_45_508 VPWR VGND sg13cmos5l_decap_8
Xhold1356 _3318_/A0 _5628_/Q VPWR VGND sg13cmos5l_dlygate4sd3_1
X_5048_ _5048_/Y _5048_/A _5048_/B VPWR VGND sg13cmos5l_nor2_1
Xheichips26_dna_sequencer_272 uio_out[3] VPWR VGND sg13cmos5l_tielo
Xhold1367 _5393_/A1 _5520_/Q VPWR VGND sg13cmos5l_dlygate4sd3_1
Xhold1389 _5417_/A1 _5542_/Q VPWR VGND sg13cmos5l_dlygate4sd3_1
Xhold1378 _5733_/D _3480_/X VPWR VGND sg13cmos5l_dlygate4sd3_1
XFILLER_21_471 VPWR VGND sg13cmos5l_decap_8
XFILLER_49_1001 VPWR VGND sg13cmos5l_decap_8
XFILLER_0_320 VPWR VGND sg13cmos5l_fill_1
XFILLER_0_353 VPWR VGND sg13cmos5l_fill_1
XFILLER_29_560 VPWR VGND sg13cmos5l_fill_1
XFILLER_29_582 VPWR VGND sg13cmos5l_fill_2
XFILLER_44_596 VPWR VGND sg13cmos5l_fill_2
XFILLER_8_420 VPWR VGND sg13cmos5l_fill_2
XFILLER_9_965 VPWR VGND sg13cmos5l_decap_4
X_4350_ _4350_/Y _4330_/A _4332_/Y _4349_/Y VPWR VGND sg13cmos5l_o21ai_1
X_3301_ _5613_/D _3301_/A0 _3320_/A1 _3307_/S VPWR VGND sg13cmos5l_mux2_1
X_4281_ _4281_/Y _4278_/Y _4279_/Y _4280_/Y VPWR VGND sg13cmos5l_o21ai_1
X_6020_ _6020_/Q _6056_/CLK _6020_/D _6020_/RESET_B VPWR VGND sg13cmos5l_dfrbpq_1
Xclkbuf_leaf_3_clk clkload5/A clkbuf_leaf_4_clk/A VPWR VGND sg13cmos5l_buf_8
X_3232_ _3240_/S _5371_/A _5371_/B _5399_/A _5399_/B VPWR VGND sg13cmos5l_nor4_1
X_3163_ _3622_/A _3163_/A _3162_/Y VPWR VGND sg13cmos5l_nor2b_1
XFILLER_48_880 VPWR VGND sg13cmos5l_fill_1
X_3094_ _4476_/A _4247_/A VPWR VGND sg13cmos5l_inv_1
Xfanout28 _3605_/B _3602_/B VPWR VGND sg13cmos5l_buf_1
X_5804_ _5804_/Q _5834_/CLK _5804_/D _5804_/RESET_B VPWR VGND sg13cmos5l_dfrbpq_1
XFILLER_35_585 VPWR VGND sg13cmos5l_fill_2
Xfanout39 _5408_/S _5407_/S VPWR VGND sg13cmos5l_buf_1
X_3996_ _3997_/C _4011_/A _3996_/B VPWR VGND sg13cmos5l_nor2_1
X_5735_ _5735_/Q _5825_/CLK _5735_/D _5735_/RESET_B VPWR VGND sg13cmos5l_dfrbpq_1
X_5666_ _5666_/Q clkload2/A _5666_/D _5666_/RESET_B VPWR VGND sg13cmos5l_dfrbpq_1
X_4617_ _4617_/Y _4618_/B VPWR VGND sg13cmos5l_inv_1
X_5597_ _5597_/Q _5860_/CLK _5597_/D _5597_/RESET_B VPWR VGND sg13cmos5l_dfrbpq_1
X_4548_ _4548_/X _4550_/A _4550_/B _4540_/Y VPWR VGND sg13cmos5l_a21o_1
X_4479_ _4479_/Y _4421_/A _4421_/B _4425_/B _4392_/A _4387_/B VPWR VGND sg13cmos5l_a221oi_1
Xhold1142 _3642_/B _5821_/Q VPWR VGND sg13cmos5l_dlygate4sd3_1
Xhold1131 _3144_/A _5715_/Q VPWR VGND sg13cmos5l_dlygate4sd3_1
Xhold1120 _3123_/A _5582_/Q VPWR VGND sg13cmos5l_dlygate4sd3_1
Xhold1164 _3190_/A _6068_/Q VPWR VGND sg13cmos5l_dlygate4sd3_1
Xhold1153 _5993_/D _4820_/Y VPWR VGND sg13cmos5l_dlygate4sd3_1
Xhold1175 _5370_/A0 _5500_/Q VPWR VGND sg13cmos5l_dlygate4sd3_1
Xhold1186 _3303_/A0 _5615_/Q VPWR VGND sg13cmos5l_dlygate4sd3_1
Xhold1197 _5318_/A0 _5453_/Q VPWR VGND sg13cmos5l_dlygate4sd3_1
XFILLER_41_588 VPWR VGND sg13cmos5l_fill_1
XFILLER_13_279 VPWR VGND sg13cmos5l_fill_2
XFILLER_5_401 VPWR VGND sg13cmos5l_fill_1
XFILLER_49_611 VPWR VGND sg13cmos5l_decap_4
XFILLER_23_1026 VPWR VGND sg13cmos5l_fill_2
XFILLER_37_839 VPWR VGND sg13cmos5l_decap_4
XFILLER_45_894 VPWR VGND sg13cmos5l_decap_8
X_3850_ _3850_/Y _3851_/B _3849_/Y _3108_/A VPWR VGND sg13cmos5l_o21ai_1
X_3781_ _3784_/B _3782_/A _3776_/Y VPWR VGND sg13cmos5l_nor2b_1
X_6046__281 _6046_/D VPWR VGND sg13cmos5l_tielo
X_5520_ _5520_/Q _5555_/CLK _5520_/D _5520_/RESET_B VPWR VGND sg13cmos5l_dfrbpq_1
X_5451_ _5451_/Q _5853_/CLK _5451_/D _5451_/RESET_B VPWR VGND sg13cmos5l_dfrbpq_1
X_4402_ _4402_/Y _4403_/B VPWR VGND sg13cmos5l_inv_1
X_5382_ _5510_/D _5382_/A0 _5419_/A1 _5389_/S VPWR VGND sg13cmos5l_mux2_1
X_4333_ _4334_/B _5906_/Q _4327_/B _4315_/Y VPWR VGND sg13cmos5l_a21oi_1
Xfanout229 _5322_/A1 _5417_/A0 VPWR VGND sg13cmos5l_buf_1
X_4264_ _4269_/A _4264_/A _4266_/A VPWR VGND sg13cmos5l_or2_1
Xfanout207 _5420_/A1 _5374_/A0 VPWR VGND sg13cmos5l_buf_1
Xfanout218 _5418_/A1 _5372_/A0 VPWR VGND sg13cmos5l_buf_1
X_3215_ _3215_/Y _3215_/A _5423_/S VPWR VGND sg13cmos5l_nand2_1
X_6003_ _6003_/Q _6005_/CLK _6003_/D _6003_/RESET_B VPWR VGND sg13cmos5l_dfrbpq_1
X_4195_ _4195_/Y _5874_/Q _5855_/Q VPWR VGND sg13cmos5l_xnor2_1
X_3146_ _5231_/A _6017_/Q VPWR VGND sg13cmos5l_inv_1
XFILLER_27_316 VPWR VGND sg13cmos5l_fill_2
X_3077_ _3077_/Y _3077_/A VPWR VGND sg13cmos5l_inv_1
XFILLER_11_728 VPWR VGND sg13cmos5l_fill_1
X_5929__440 _5929_/RESET_B VPWR VGND sg13cmos5l_tiehi
X_5718_ _5718_/Q _6077_/CLK _5718_/D _5718_/RESET_B VPWR VGND sg13cmos5l_dfrbpq_1
X_3979_ _3979_/X _5532_/Q _5515_/Q _3979_/S VPWR VGND sg13cmos5l_mux2_1
X_5649_ _5649_/Q clkload2/A _5649_/D _5649_/RESET_B VPWR VGND sg13cmos5l_dfrbpq_1
XFILLER_46_1004 VPWR VGND sg13cmos5l_decap_8
XFILLER_49_78 VPWR VGND sg13cmos5l_fill_1
X_5502__552 _5502_/RESET_B VPWR VGND sg13cmos5l_tiehi
XFILLER_46_669 VPWR VGND sg13cmos5l_fill_2
XFILLER_14_511 VPWR VGND sg13cmos5l_fill_2
XFILLER_10_772 VPWR VGND sg13cmos5l_decap_4
XFILLER_6_732 VPWR VGND sg13cmos5l_fill_2
XFILLER_5_297 VPWR VGND sg13cmos5l_fill_2
X_5698__722 _5698_/RESET_B VPWR VGND sg13cmos5l_tiehi
XFILLER_2_971 VPWR VGND sg13cmos5l_decap_8
XFILLER_49_485 VPWR VGND sg13cmos5l_decap_8
Xinput7 input7/X uio_in[1] VPWR VGND sg13cmos5l_buf_1
X_4951_ _4951_/X _4951_/A _4951_/B _4951_/C VPWR VGND sg13cmos5l_and3_1
X_4882_ _4882_/Y _4871_/X _4891_/A _4881_/Y VPWR VGND sg13cmos5l_o21ai_1
X_3902_ _3902_/Y _5609_/Q _3910_/B VPWR VGND sg13cmos5l_nand2b_1
X_3833_ _3838_/B _5274_/B _3199_/A _3832_/Y _3185_/B VPWR VGND sg13cmos5l_a22oi_1
X_3764_ _3765_/B _3764_/A1 _3724_/A _3762_/X _3763_/Y VPWR VGND sg13cmos5l_a22oi_1
X_3695_ _3696_/B _5797_/Q _5791_/Q _5785_/Q _5779_/Q _3734_/S _3736_/A1 VPWR VGND
+ sg13cmos5l_mux4_1
X_5503_ _5503_/Q _5674_/CLK _5503_/D _5503_/RESET_B VPWR VGND sg13cmos5l_dfrbpq_1
X_5434_ _5434_/Q _5906_/CLK _5434_/D _5434_/RESET_B VPWR VGND sg13cmos5l_dfrbpq_1
X_5484__588 _5484_/RESET_B VPWR VGND sg13cmos5l_tiehi
X_5365_ _5495_/D _5365_/A0 _5413_/A0 _5370_/S VPWR VGND sg13cmos5l_mux2_1
X_5296_ _5435_/D _5296_/A0 _5355_/A0 _5301_/S VPWR VGND sg13cmos5l_mux2_1
X_5994__368 _5994_/RESET_B VPWR VGND sg13cmos5l_tiehi
X_4316_ _4316_/Y _5900_/Q _5877_/Q VPWR VGND sg13cmos5l_xnor2_1
X_4247_ _4247_/Y _4247_/A _4247_/B VPWR VGND sg13cmos5l_nor2_1
X_4178_ _4178_/Y _4171_/A _4175_/Y _4193_/B VPWR VGND sg13cmos5l_o21ai_1
XFILLER_28_636 VPWR VGND sg13cmos5l_fill_1
XFILLER_43_606 VPWR VGND sg13cmos5l_decap_8
X_3129_ _4283_/B _3129_/A VPWR VGND sg13cmos5l_inv_1
XFILLER_24_886 VPWR VGND sg13cmos5l_decap_4
XFILLER_7_529 VPWR VGND sg13cmos5l_fill_2
XFILLER_13_1025 VPWR VGND sg13cmos5l_decap_4
XFILLER_3_757 VPWR VGND sg13cmos5l_fill_1
XFILLER_47_956 VPWR VGND sg13cmos5l_decap_8
XFILLER_46_422 VPWR VGND sg13cmos5l_decap_8
XFILLER_19_647 VPWR VGND sg13cmos5l_fill_1
XFILLER_19_669 VPWR VGND sg13cmos5l_fill_2
XFILLER_46_499 VPWR VGND sg13cmos5l_decap_8
X_3480_ _3480_/X _3440_/A _3480_/A1 _3480_/S VPWR VGND sg13cmos5l_mux2_1
X_5150_ _5150_/Y _3066_/Y _5145_/A _5146_/Y VPWR VGND sg13cmos5l_a21oi_1
X_5919__450 _5919_/RESET_B VPWR VGND sg13cmos5l_tiehi
X_5081_ _5081_/Y _6063_/Q _5081_/B VPWR VGND sg13cmos5l_nor2_1
XFILLER_2_790 VPWR VGND sg13cmos5l_fill_1
X_4101_ _4102_/B _4101_/A _4101_/B VPWR VGND sg13cmos5l_nor2_1
X_4032_ _4032_/X _5557_/Q _5540_/Q _5523_/Q _5506_/Q _4100_/S0 _4100_/S1 VPWR VGND
+ sg13cmos5l_mux4_1
XFILLER_2_95 VPWR VGND sg13cmos5l_fill_1
X_5983_ _5983_/Q _6007_/CLK _5983_/D _5983_/RESET_B VPWR VGND sg13cmos5l_dfrbpq_1
XFILLER_37_488 VPWR VGND sg13cmos5l_decap_8
X_4934_ _4935_/B _4904_/X _4922_/Y _4933_/Y VPWR VGND sg13cmos5l_o21ai_1
XFILLER_40_609 VPWR VGND sg13cmos5l_fill_2
X_4865_ _4865_/X _4866_/B _4866_/C VPWR VGND sg13cmos5l_and2_1
X_3816_ _3816_/Y _3162_/A _3814_/Y _3220_/C VPWR VGND sg13cmos5l_o21ai_1
X_4796_ _4796_/Y _4796_/A _5012_/A _4796_/C VPWR VGND sg13cmos5l_nand3_1
X_5926__443 _5926_/RESET_B VPWR VGND sg13cmos5l_tiehi
X_3747_ _3747_/Y _5710_/Q _3755_/S VPWR VGND sg13cmos5l_nand2b_1
X_6022__335 _6022_/RESET_B VPWR VGND sg13cmos5l_tiehi
X_3678_ _3679_/B _5796_/Q _5790_/Q _5784_/Q _5778_/Q _3749_/B _3752_/A VPWR VGND sg13cmos5l_mux4_1
X_5417_ _5542_/D _5417_/A0 _5417_/A1 _5417_/S VPWR VGND sg13cmos5l_mux2_1
X_5348_ _5480_/D _5348_/A0 _5367_/A1 _5351_/S VPWR VGND sg13cmos5l_mux2_1
X_5279_ _5279_/Y _6076_/Q _5279_/B _5279_/C VPWR VGND sg13cmos5l_nand3_1
XFILLER_29_945 VPWR VGND sg13cmos5l_decap_4
XFILLER_28_466 VPWR VGND sg13cmos5l_decap_8
XFILLER_29_989 VPWR VGND sg13cmos5l_decap_8
XFILLER_44_959 VPWR VGND sg13cmos5l_decap_8
XFILLER_43_447 VPWR VGND sg13cmos5l_decap_8
X_5688__732 _5688_/RESET_B VPWR VGND sg13cmos5l_tiehi
XFILLER_7_337 VPWR VGND sg13cmos5l_fill_2
XFILLER_7_326 VPWR VGND sg13cmos5l_fill_2
XFILLER_2_0 VPWR VGND sg13cmos5l_fill_2
XFILLER_11_82 VPWR VGND sg13cmos5l_fill_1
XFILLER_3_565 VPWR VGND sg13cmos5l_fill_2
X_5695__725 _5695_/RESET_B VPWR VGND sg13cmos5l_tiehi
XFILLER_43_970 VPWR VGND sg13cmos5l_fill_2
XFILLER_34_469 VPWR VGND sg13cmos5l_decap_8
XFILLER_42_491 VPWR VGND sg13cmos5l_decap_8
X_4650_ _5966_/D _4827_/A _4650_/B VPWR VGND sg13cmos5l_and2_1
X_3601_ _3601_/Y _3613_/A1 _3602_/B _3600_/Y VPWR VGND sg13cmos5l_o21ai_1
Xinput10 input10/X uio_in[4] VPWR VGND sg13cmos5l_buf_1
XFILLER_30_697 VPWR VGND sg13cmos5l_fill_1
X_4581_ _4584_/C _5920_/Q _5919_/Q _4581_/B1 VPWR VGND sg13cmos5l_o21ai_1
X_3532_ _5758_/D _3618_/A1 _3531_/B _3531_/Y VPWR VGND sg13cmos5l_o21ai_1
X_3463_ _3463_/Y _3463_/A _3468_/B VPWR VGND sg13cmos5l_nand2_1
X_5202_ _5202_/X _6014_/Q _6015_/Q VPWR VGND sg13cmos5l_or2_1
X_3394_ _5692_/D _3394_/A0 _3394_/A1 _3397_/S VPWR VGND sg13cmos5l_mux2_1
X_5133_ _5148_/B _6067_/Q _5132_/Y _5131_/Y VPWR VGND sg13cmos5l_o21ai_1
XFILLER_35_0 VPWR VGND sg13cmos5l_fill_2
Xhold1516 _5287_/B _6072_/Q VPWR VGND sg13cmos5l_dlygate4sd3_1
Xhold1505 _4181_/B _4180_/Y VPWR VGND sg13cmos5l_dlygate4sd3_1
Xhold1538 _5824_/D _3791_/Y VPWR VGND sg13cmos5l_dlygate4sd3_1
Xhold1549 _3066_/A _6049_/Q VPWR VGND sg13cmos5l_dlygate4sd3_1
Xhold1527 _4997_/A2 _5148_/A VPWR VGND sg13cmos5l_dlygate4sd3_1
X_5064_ _6036_/D _5064_/A _5064_/B VPWR VGND sg13cmos5l_and2_1
X_4015_ _4015_/Y _4012_/Y _4013_/Y _4014_/Y VPWR VGND sg13cmos5l_o21ai_1
XFILLER_38_775 VPWR VGND sg13cmos5l_fill_2
XFILLER_38_797 VPWR VGND sg13cmos5l_fill_1
XFILLER_25_447 VPWR VGND sg13cmos5l_decap_8
X_5966_ _5966_/Q _6007_/CLK _5966_/D _5966_/RESET_B VPWR VGND sg13cmos5l_dfrbpq_1
X_5897_ _5897_/Q _5943_/CLK _5897_/D _5897_/RESET_B VPWR VGND sg13cmos5l_dfrbpq_1
X_4917_ _4917_/Y _4978_/B _4918_/B VPWR VGND sg13cmos5l_nand2_1
X_4848_ _4878_/B _4846_/Y _4847_/Y _4845_/Y VPWR VGND sg13cmos5l_a21oi_1
XFILLER_20_152 VPWR VGND sg13cmos5l_decap_8
XFILLER_5_808 VPWR VGND sg13cmos5l_fill_1
X_4779_ _4779_/Y _4759_/B _4759_/C _4774_/B _4769_/A _4771_/B VPWR VGND sg13cmos5l_a221oi_1
XFILLER_10_1028 VPWR VGND sg13cmos5l_fill_1
XFILLER_44_712 VPWR VGND sg13cmos5l_fill_2
XFILLER_16_447 VPWR VGND sg13cmos5l_fill_1
XFILLER_43_255 VPWR VGND sg13cmos5l_fill_2
X_5909__460 _5909_/RESET_B VPWR VGND sg13cmos5l_tiehi
X_5916__453 _5916_/RESET_B VPWR VGND sg13cmos5l_tiehi
X_5820_ _5820_/Q clkload8/A _5820_/D _5820_/RESET_B VPWR VGND sg13cmos5l_dfrbpq_1
X_5751_ _5751_/Q _6047_/CLK _5751_/D _5751_/RESET_B VPWR VGND sg13cmos5l_dfrbpq_1
XFILLER_33_1006 VPWR VGND sg13cmos5l_fill_1
X_4702_ _4703_/B _4664_/X _4708_/A _4710_/A VPWR VGND sg13cmos5l_a21oi_1
X_5682_ _5682_/Q _5810_/CLK _5682_/D _5682_/RESET_B VPWR VGND sg13cmos5l_dfrbpq_1
XFILLER_8_83 VPWR VGND sg13cmos5l_fill_1
X_4633_ _4633_/Y _4633_/A1 _4637_/S _4632_/Y VPWR VGND sg13cmos5l_o21ai_1
X_5923__446 _5923_/RESET_B VPWR VGND sg13cmos5l_tiehi
X_4564_ _4657_/B _4555_/A _4555_/B _4563_/Y VPWR VGND sg13cmos5l_o21ai_1
X_3515_ _3515_/Y _5162_/A1 _3514_/B _3514_/Y VPWR VGND sg13cmos5l_o21ai_1
X_4495_ _4495_/Y _4495_/A VPWR VGND sg13cmos5l_inv_1
X_6075__840 _6075_/RESET_B VPWR VGND sg13cmos5l_tiehi
X_3446_ _3446_/Y _3446_/A _3452_/B VPWR VGND sg13cmos5l_nor2_1
X_5678__742 _5678_/RESET_B VPWR VGND sg13cmos5l_tiehi
X_3377_ _3387_/S _5304_/A _5304_/B _5399_/A _5342_/B VPWR VGND sg13cmos5l_nor4_1
Xhold1313 _3230_/A1 _5558_/Q VPWR VGND sg13cmos5l_dlygate4sd3_1
Xhold1302 _3579_/A1 _5781_/Q VPWR VGND sg13cmos5l_dlygate4sd3_1
Xhold1324 _5739_/D _3492_/X VPWR VGND sg13cmos5l_dlygate4sd3_1
X_5116_ _5116_/Y _5116_/A _5119_/B VPWR VGND sg13cmos5l_nand2_1
Xhold1357 _3228_/A1 _5556_/Q VPWR VGND sg13cmos5l_dlygate4sd3_1
Xhold1346 _5367_/A0 _5497_/Q VPWR VGND sg13cmos5l_dlygate4sd3_1
Xheichips26_dna_sequencer_273 uio_out[4] VPWR VGND sg13cmos5l_tielo
X_5047_ _5047_/Y _5047_/A _5047_/B VPWR VGND sg13cmos5l_nand2_1
Xheichips26_dna_sequencer_262 uio_oe[1] VPWR VGND sg13cmos5l_tielo
Xhold1368 _3345_/A0 _5652_/Q VPWR VGND sg13cmos5l_dlygate4sd3_1
Xhold1335 _3395_/A1 _5693_/Q VPWR VGND sg13cmos5l_dlygate4sd3_1
X_5930__439 _5930_/RESET_B VPWR VGND sg13cmos5l_tiehi
Xhold1379 _5337_/A0 _5470_/Q VPWR VGND sg13cmos5l_dlygate4sd3_1
XFILLER_38_583 VPWR VGND sg13cmos5l_fill_2
X_5949_ _5949_/Q _5973_/CLK _5949_/D _5949_/RESET_B VPWR VGND sg13cmos5l_dfrbpq_1
X_6047__953 _6047_/RESET_B VPWR VGND sg13cmos5l_tiehi
X_5685__735 _5685_/RESET_B VPWR VGND sg13cmos5l_tiehi
XFILLER_21_450 VPWR VGND sg13cmos5l_decap_8
XFILLER_4_148 VPWR VGND sg13cmos5l_fill_2
X_5692__728 _5692_/RESET_B VPWR VGND sg13cmos5l_tiehi
XFILLER_36_509 VPWR VGND sg13cmos5l_decap_8
XFILLER_44_575 VPWR VGND sg13cmos5l_decap_8
X_3300_ _5612_/D _3300_/A0 _5373_/A0 _3307_/S VPWR VGND sg13cmos5l_mux2_1
X_4280_ _4280_/Y _4478_/A _5872_/Q _3128_/Y _5912_/Q VPWR VGND sg13cmos5l_a22oi_1
X_3231_ _5559_/D _3217_/A _3231_/A1 _3231_/S VPWR VGND sg13cmos5l_mux2_1
X_3162_ _3162_/Y _3162_/A _3162_/B _3803_/A _3162_/D VPWR VGND sg13cmos5l_nor4_1
X_3093_ _4477_/A _3093_/A VPWR VGND sg13cmos5l_inv_1
Xfanout29 _3580_/B _3577_/B VPWR VGND sg13cmos5l_buf_1
X_5803_ _5803_/Q clkload7/A _5803_/D _5803_/RESET_B VPWR VGND sg13cmos5l_dfrbpq_1
XFILLER_23_737 VPWR VGND sg13cmos5l_fill_1
X_5847__311 _5847_/D VPWR VGND sg13cmos5l_tielo
X_3995_ _3996_/B _5689_/Q _5672_/Q _5655_/Q _5638_/Q _4029_/S _4031_/A1 VPWR VGND
+ sg13cmos5l_mux4_1
X_5734_ _5734_/Q _5825_/CLK _5734_/D _5734_/RESET_B VPWR VGND sg13cmos5l_dfrbpq_1
X_5665_ _5665_/Q _5810_/CLK _5665_/D _5665_/RESET_B VPWR VGND sg13cmos5l_dfrbpq_1
X_4616_ _4618_/B _5928_/Q _4613_/Y _4615_/Y VPWR VGND sg13cmos5l_o21ai_1
X_5596_ _5596_/Q _5864_/CLK _5596_/D _5596_/RESET_B VPWR VGND sg13cmos5l_dfrbpq_1
X_4547_ _4547_/Y _4550_/A _4550_/B _4540_/Y VPWR VGND sg13cmos5l_a21oi_1
X_4478_ _5939_/D _4478_/A _4523_/A VPWR VGND sg13cmos5l_nor2_1
X_3429_ _3582_/B _3457_/B _3767_/A VPWR VGND sg13cmos5l_nor2_1
Xhold1132 _3122_/A _5684_/Q VPWR VGND sg13cmos5l_dlygate4sd3_1
Xhold1121 _3115_/A _5683_/Q VPWR VGND sg13cmos5l_dlygate4sd3_1
Xhold1110 _4665_/A _5963_/Q VPWR VGND sg13cmos5l_dlygate4sd3_1
Xhold1154 _3629_/A _5835_/Q VPWR VGND sg13cmos5l_dlygate4sd3_1
Xhold1165 _5281_/B _5280_/Y VPWR VGND sg13cmos5l_dlygate4sd3_1
X_6079_ _6079_/Q _6080_/CLK _6079_/D _6079_/RESET_B VPWR VGND sg13cmos5l_dfrbpq_1
Xhold1176 _5339_/A0 _5472_/Q VPWR VGND sg13cmos5l_dlygate4sd3_1
Xhold1143 _3076_/A _5901_/Q VPWR VGND sg13cmos5l_dlygate4sd3_1
Xhold1198 _5420_/A0 _5545_/Q VPWR VGND sg13cmos5l_dlygate4sd3_1
Xhold1187 _3530_/A1 _5757_/Q VPWR VGND sg13cmos5l_dlygate4sd3_1
X_5494__568 _5494_/RESET_B VPWR VGND sg13cmos5l_tiehi
XFILLER_39_892 VPWR VGND sg13cmos5l_decap_8
XFILLER_26_542 VPWR VGND sg13cmos5l_fill_2
X_5548__937 _5548_/RESET_B VPWR VGND sg13cmos5l_tiehi
XFILLER_6_958 VPWR VGND sg13cmos5l_decap_8
X_5906__463 _5906_/RESET_B VPWR VGND sg13cmos5l_tiehi
XFILLER_5_479 VPWR VGND sg13cmos5l_fill_1
XFILLER_1_663 VPWR VGND sg13cmos5l_fill_1
XFILLER_49_656 VPWR VGND sg13cmos5l_decap_4
X_5913__456 _5913_/RESET_B VPWR VGND sg13cmos5l_tiehi
XFILLER_28_80 VPWR VGND sg13cmos5l_fill_1
X_3780_ _3780_/Y _3782_/A _3778_/Y _3779_/Y VPWR VGND sg13cmos5l_a21oi_1
X_5668__752 _5668_/RESET_B VPWR VGND sg13cmos5l_tiehi
XFILLER_8_273 VPWR VGND sg13cmos5l_fill_2
XFILLER_12_291 VPWR VGND sg13cmos5l_fill_1
X_5450_ _5450_/Q _5853_/CLK _5450_/D _5450_/RESET_B VPWR VGND sg13cmos5l_dfrbpq_1
X_4401_ _4403_/B _4381_/B _4380_/Y _4400_/X VPWR VGND sg13cmos5l_a21oi_1
X_5920__449 _5920_/RESET_B VPWR VGND sg13cmos5l_tiehi
X_5381_ _5509_/D _5381_/A0 _5418_/A1 _5389_/S VPWR VGND sg13cmos5l_mux2_1
X_4332_ _4332_/Y _4332_/A _4332_/B _4332_/C VPWR VGND sg13cmos5l_nand3_1
X_4263_ _4263_/Y _4266_/A VPWR VGND sg13cmos5l_inv_1
Xfanout208 _3320_/A1 _5374_/A0 VPWR VGND sg13cmos5l_buf_1
Xfanout219 _5372_/A0 _5410_/A0 VPWR VGND sg13cmos5l_buf_1
X_3214_ _5422_/S _5399_/A _5399_/B _5342_/B VPWR VGND sg13cmos5l_nor3_1
X_6002_ _6002_/Q _6005_/CLK _6002_/D _6002_/RESET_B VPWR VGND sg13cmos5l_dfrbpq_1
X_4194_ _4194_/Y _4200_/A _4200_/B VPWR VGND sg13cmos5l_nand2_1
X_5675__745 _5675_/RESET_B VPWR VGND sg13cmos5l_tiehi
XFILLER_28_818 VPWR VGND sg13cmos5l_fill_1
X_3145_ _4832_/A _4620_/A VPWR VGND sg13cmos5l_inv_1
X_3076_ _3076_/Y _3076_/A VPWR VGND sg13cmos5l_inv_1
XFILLER_35_361 VPWR VGND sg13cmos5l_decap_4
X_5888__488 _5888_/RESET_B VPWR VGND sg13cmos5l_tiehi
XFILLER_24_16 VPWR VGND sg13cmos5l_fill_2
X_3978_ _3978_/Y _3979_/S _5566_/Q _3977_/Y VPWR VGND sg13cmos5l_o21ai_1
X_6044__956 _6044_/RESET_B VPWR VGND sg13cmos5l_tiehi
X_5717_ _5717_/Q _6074_/CLK _5717_/D _5717_/RESET_B VPWR VGND sg13cmos5l_dfrbpq_1
X_5648_ _5648_/Q _5810_/CLK _5648_/D _5648_/RESET_B VPWR VGND sg13cmos5l_dfrbpq_1
X_5682__738 _5682_/RESET_B VPWR VGND sg13cmos5l_tiehi
X_5579_ _5579_/Q clkload3/A _5579_/D _5579_/RESET_B VPWR VGND sg13cmos5l_dfrbpq_1
XFILLER_27_840 VPWR VGND sg13cmos5l_fill_1
XFILLER_41_342 VPWR VGND sg13cmos5l_decap_8
XFILLER_14_93 VPWR VGND sg13cmos5l_fill_1
XFILLER_49_464 VPWR VGND sg13cmos5l_decap_8
Xinput8 input8/X uio_in[2] VPWR VGND sg13cmos5l_buf_1
XFILLER_36_136 VPWR VGND sg13cmos5l_fill_1
XFILLER_17_361 VPWR VGND sg13cmos5l_decap_4
X_4950_ _4950_/Y _4947_/Y _4948_/Y _4949_/Y _6005_/Q VPWR VGND sg13cmos5l_a22oi_1
X_3901_ _3901_/Y _3910_/B _3114_/Y _3900_/Y VPWR VGND sg13cmos5l_a21oi_1
XFILLER_17_394 VPWR VGND sg13cmos5l_fill_2
X_5987__376 _5987_/RESET_B VPWR VGND sg13cmos5l_tiehi
X_4881_ _4881_/Y _4883_/A _4883_/B VPWR VGND sg13cmos5l_nand2_1
X_3832_ _3832_/Y _6080_/Q _5279_/B VPWR VGND sg13cmos5l_nand2b_1
XFILLER_32_342 VPWR VGND sg13cmos5l_decap_8
XFILLER_32_353 VPWR VGND sg13cmos5l_fill_1
X_3763_ _3763_/Y _3763_/A _3767_/C VPWR VGND sg13cmos5l_nor2b_1
X_5502_ _5502_/Q _5674_/CLK _5502_/D _5502_/RESET_B VPWR VGND sg13cmos5l_dfrbpq_1
X_3694_ _3694_/Y _3710_/S _5749_/Q _3693_/Y VPWR VGND sg13cmos5l_o21ai_1
X_5433_ _5433_/Q _5853_/CLK _5433_/D _5433_/RESET_B VPWR VGND sg13cmos5l_dfrbpq_1
X_5364_ _5494_/D _5364_/A0 _5374_/A0 _5370_/S VPWR VGND sg13cmos5l_mux2_1
X_4315_ _4315_/Y _4315_/A _4315_/B VPWR VGND sg13cmos5l_nand2_1
X_5295_ _5434_/D _5295_/A0 _5354_/A0 _5301_/S VPWR VGND sg13cmos5l_mux2_1
X_4246_ _5887_/D _4313_/B _4246_/B VPWR VGND sg13cmos5l_and2_1
X_4177_ _4177_/Y _4287_/B _4175_/Y _4176_/Y VPWR VGND sg13cmos5l_a21oi_1
X_3128_ _3128_/Y _3128_/A VPWR VGND sg13cmos5l_inv_1
XFILLER_42_106 VPWR VGND sg13cmos5l_fill_2
XFILLER_27_169 VPWR VGND sg13cmos5l_fill_1
XFILLER_36_692 VPWR VGND sg13cmos5l_decap_8
XFILLER_7_508 VPWR VGND sg13cmos5l_fill_2
X_5903__466 _5903_/RESET_B VPWR VGND sg13cmos5l_tiehi
XFILLER_4_4 VPWR VGND sg13cmos5l_fill_2
X_5658__762 _5658_/RESET_B VPWR VGND sg13cmos5l_tiehi
XFILLER_47_935 VPWR VGND sg13cmos5l_decap_8
XFILLER_46_401 VPWR VGND sg13cmos5l_decap_8
XFILLER_46_478 VPWR VGND sg13cmos5l_decap_8
X_5910__459 _5910_/RESET_B VPWR VGND sg13cmos5l_tiehi
X_5665__755 _5665_/RESET_B VPWR VGND sg13cmos5l_tiehi
XFILLER_29_1000 VPWR VGND sg13cmos5l_fill_2
X_5080_ _5080_/Y _6063_/Q _5081_/B VPWR VGND sg13cmos5l_nand2_1
X_4100_ _4101_/B _5703_/Q _5686_/Q _5669_/Q _5652_/Q _4100_/S0 _4100_/S1 VPWR VGND
+ sg13cmos5l_mux4_1
X_5878__498 _5878_/RESET_B VPWR VGND sg13cmos5l_tiehi
XFILLER_2_41 VPWR VGND sg13cmos5l_fill_2
X_4031_ _4031_/Y _4031_/A1 _4029_/X _4030_/Y VPWR VGND sg13cmos5l_a21oi_1
XFILLER_38_924 VPWR VGND sg13cmos5l_decap_4
X_5672__748 _5672_/RESET_B VPWR VGND sg13cmos5l_tiehi
XFILLER_37_467 VPWR VGND sg13cmos5l_decap_8
XFILLER_46_990 VPWR VGND sg13cmos5l_decap_8
X_5982_ _5982_/Q _6037_/CLK _5982_/D _5982_/RESET_B VPWR VGND sg13cmos5l_dfrbpq_1
X_4933_ _4933_/Y _4928_/A _4928_/C _4932_/X VPWR VGND sg13cmos5l_o21ai_1
X_4864_ _4866_/C _4778_/B _4864_/B _4864_/C VPWR VGND sg13cmos5l_nand3b_1
XFILLER_32_172 VPWR VGND sg13cmos5l_fill_2
X_3815_ _3815_/Y _5831_/Q _3815_/B VPWR VGND sg13cmos5l_nor2_1
X_4795_ _4795_/Y _5957_/Q _4800_/B VPWR VGND sg13cmos5l_nand2_1
X_3746_ _3746_/Y _3137_/Y _5728_/Q _3761_/B2 VPWR VGND sg13cmos5l_a21oi_1
X_6041__959 _6041_/RESET_B VPWR VGND sg13cmos5l_tiehi
XFILLER_20_378 VPWR VGND sg13cmos5l_decap_4
X_5416_ _5541_/D _5416_/A0 _5416_/A1 _5417_/S VPWR VGND sg13cmos5l_mux2_1
X_3677_ _3682_/B _3677_/A _3677_/B VPWR VGND sg13cmos5l_nor2_1
X_5347_ _5479_/D _5347_/A0 _5414_/A0 _5351_/S VPWR VGND sg13cmos5l_mux2_1
X_5278_ _6068_/D _5278_/A _5278_/B VPWR VGND sg13cmos5l_nor2_1
X_4229_ _4229_/Y _5912_/Q _4247_/A VPWR VGND sg13cmos5l_xnor2_1
XFILLER_29_913 VPWR VGND sg13cmos5l_fill_1
XFILLER_28_423 VPWR VGND sg13cmos5l_fill_2
XFILLER_29_935 VPWR VGND sg13cmos5l_decap_4
XFILLER_43_404 VPWR VGND sg13cmos5l_fill_1
XFILLER_37_990 VPWR VGND sg13cmos5l_fill_2
X_5532__365 _5532_/RESET_B VPWR VGND sg13cmos5l_tiehi
XFILLER_24_684 VPWR VGND sg13cmos5l_fill_2
XFILLER_8_806 VPWR VGND sg13cmos5l_decap_8
XFILLER_11_356 VPWR VGND sg13cmos5l_decap_8
XFILLER_7_349 VPWR VGND sg13cmos5l_fill_1
X_5977__386 _5977_/RESET_B VPWR VGND sg13cmos5l_tiehi
XFILLER_4_1013 VPWR VGND sg13cmos5l_decap_8
XFILLER_19_401 VPWR VGND sg13cmos5l_fill_2
XFILLER_35_916 VPWR VGND sg13cmos5l_fill_1
XFILLER_34_448 VPWR VGND sg13cmos5l_decap_8
XFILLER_36_80 VPWR VGND sg13cmos5l_fill_1
XFILLER_15_673 VPWR VGND sg13cmos5l_fill_1
XFILLER_42_470 VPWR VGND sg13cmos5l_decap_8
XFILLER_15_684 VPWR VGND sg13cmos5l_fill_1
X_5984__379 _5984_/RESET_B VPWR VGND sg13cmos5l_tiehi
X_4580_ _4580_/Y _4580_/A _4580_/B VPWR VGND sg13cmos5l_nand2_1
X_3600_ _3600_/Y _3600_/A _3605_/B VPWR VGND sg13cmos5l_nand2_1
Xinput11 input11/X uio_in[5] VPWR VGND sg13cmos5l_buf_1
X_3531_ _3531_/Y _3531_/A _3531_/B VPWR VGND sg13cmos5l_nand2_1
X_3462_ _5724_/D _5158_/A1 _3468_/B _3461_/Y VPWR VGND sg13cmos5l_o21ai_1
X_5201_ _5201_/X _6017_/Q _5201_/B VPWR VGND sg13cmos5l_and2_1
X_3393_ _5691_/D _3393_/A0 _3393_/A1 _3397_/S VPWR VGND sg13cmos5l_mux2_1
X_5132_ _5132_/Y _6023_/Q _6066_/Q VPWR VGND sg13cmos5l_nor2_1
Xhold1506 _3772_/A _5815_/Q VPWR VGND sg13cmos5l_dlygate4sd3_1
Xhold1517 _4816_/B _5990_/Q VPWR VGND sg13cmos5l_dlygate4sd3_1
Xhold1528 _6022_/D _4997_/Y VPWR VGND sg13cmos5l_dlygate4sd3_1
X_5063_ _5064_/B _5021_/X _5069_/A _4964_/A VPWR VGND sg13cmos5l_a21oi_1
Xhold1539 _3126_/A _6076_/Q VPWR VGND sg13cmos5l_dlygate4sd3_1
X_4014_ _4014_/Y _5842_/Q _4014_/B VPWR VGND sg13cmos5l_nor2_1
X_5965_ _5965_/Q _6007_/CLK _5965_/D _5965_/RESET_B VPWR VGND sg13cmos5l_dfrbpq_1
X_4916_ _4916_/Y _4978_/B _4918_/B VPWR VGND sg13cmos5l_nor2_1
XFILLER_33_470 VPWR VGND sg13cmos5l_fill_2
X_5896_ _5896_/Q _5943_/CLK _5896_/D _5896_/RESET_B VPWR VGND sg13cmos5l_dfrbpq_1
X_4847_ _4847_/Y _5994_/Q _5965_/Q VPWR VGND sg13cmos5l_xnor2_1
XFILLER_20_175 VPWR VGND sg13cmos5l_decap_4
X_5648__772 _5648_/RESET_B VPWR VGND sg13cmos5l_tiehi
X_4778_ _5983_/D _4892_/A _4778_/B VPWR VGND sg13cmos5l_nor2_1
X_3729_ _3729_/Y _3731_/S _3144_/Y _3761_/B2 VPWR VGND sg13cmos5l_o21ai_1
X_5468__882 _5468_/RESET_B VPWR VGND sg13cmos5l_tiehi
XFILLER_29_710 VPWR VGND sg13cmos5l_fill_1
XFILLER_16_415 VPWR VGND sg13cmos5l_fill_2
XFILLER_29_787 VPWR VGND sg13cmos5l_fill_2
X_5655__765 _5655_/RESET_B VPWR VGND sg13cmos5l_tiehi
XFILLER_19_1021 VPWR VGND sg13cmos5l_decap_8
XFILLER_24_481 VPWR VGND sg13cmos5l_decap_8
XFILLER_40_985 VPWR VGND sg13cmos5l_fill_1
X_5662__758 _5662_/RESET_B VPWR VGND sg13cmos5l_tiehi
X_5539__327 _5539_/RESET_B VPWR VGND sg13cmos5l_tiehi
XFILLER_47_595 VPWR VGND sg13cmos5l_decap_8
X_5750_ _5750_/Q _6063_/CLK _5750_/D _5750_/RESET_B VPWR VGND sg13cmos5l_dfrbpq_1
X_5681_ _5681_/Q clkload4/A _5681_/D _5681_/RESET_B VPWR VGND sg13cmos5l_dfrbpq_1
X_4701_ _4703_/A _4696_/A _4685_/X _4708_/A VPWR VGND sg13cmos5l_a21o_1
X_4632_ _4632_/Y _4632_/A _4637_/S VPWR VGND sg13cmos5l_nand2_1
XFILLER_30_451 VPWR VGND sg13cmos5l_fill_1
XFILLER_31_996 VPWR VGND sg13cmos5l_decap_4
XFILLER_33_1018 VPWR VGND sg13cmos5l_decap_8
X_4563_ _4563_/Y _4573_/B _4543_/Y VPWR VGND sg13cmos5l_nor2b_1
X_4494_ _4495_/A _4510_/A _4494_/B VPWR VGND sg13cmos5l_nand2_1
X_3514_ _3514_/Y _3514_/A _3514_/B VPWR VGND sg13cmos5l_nand2_1
X_3445_ _3455_/B _3582_/A _3545_/B _3445_/C VPWR VGND sg13cmos5l_nor3_1
X_3376_ _5678_/D _5322_/A1 _3376_/A1 _3376_/S VPWR VGND sg13cmos5l_mux2_1
Xhold1314 _3233_/A0 _5560_/Q VPWR VGND sg13cmos5l_dlygate4sd3_1
Xhold1303 _5781_/D _3579_/X VPWR VGND sg13cmos5l_dlygate4sd3_1
Xhold1325 _5384_/A0 _5512_/Q VPWR VGND sg13cmos5l_dlygate4sd3_1
X_5115_ _5115_/Y _5097_/Y _5101_/Y _5104_/A _5104_/B _5078_/Y VPWR VGND sg13cmos5l_a221oi_1
Xhold1347 _3287_/A1 _5601_/Q VPWR VGND sg13cmos5l_dlygate4sd3_1
Xhold1358 _3616_/A1 _5799_/Q VPWR VGND sg13cmos5l_dlygate4sd3_1
Xhold1336 _3604_/A1 _5793_/Q VPWR VGND sg13cmos5l_dlygate4sd3_1
X_5046_ _5046_/Y _5046_/A _5047_/B VPWR VGND sg13cmos5l_nor2b_1
Xheichips26_dna_sequencer_263 uio_oe[2] VPWR VGND sg13cmos5l_tielo
Xhold1369 _3326_/A0 _5636_/Q VPWR VGND sg13cmos5l_dlygate4sd3_1
Xheichips26_dna_sequencer_274 uio_out[5] VPWR VGND sg13cmos5l_tielo
X_5948_ _5948_/Q _5973_/CLK _5948_/D _5948_/RESET_B VPWR VGND sg13cmos5l_dfrbpq_1
XFILLER_41_738 VPWR VGND sg13cmos5l_fill_1
XFILLER_25_278 VPWR VGND sg13cmos5l_fill_1
X_5967__396 _5967_/RESET_B VPWR VGND sg13cmos5l_tiehi
X_5879_ _5879_/Q _6080_/CLK _5879_/D _5879_/RESET_B VPWR VGND sg13cmos5l_dfrbpq_1
XFILLER_49_805 VPWR VGND sg13cmos5l_decap_4
X_5974__389 _5974_/RESET_B VPWR VGND sg13cmos5l_tiehi
XFILLER_1_1016 VPWR VGND sg13cmos5l_decap_8
XFILLER_29_551 VPWR VGND sg13cmos5l_fill_1
XFILLER_1_1027 VPWR VGND sg13cmos5l_fill_2
XFILLER_32_705 VPWR VGND sg13cmos5l_fill_2
XFILLER_44_598 VPWR VGND sg13cmos5l_fill_1
XFILLER_9_912 VPWR VGND sg13cmos5l_fill_1
XFILLER_40_771 VPWR VGND sg13cmos5l_fill_1
X_3230_ _5558_/D _5416_/A0 _3230_/A1 _3231_/S VPWR VGND sg13cmos5l_mux2_1
X_3161_ _3185_/A _5279_/B VPWR VGND sg13cmos5l_inv_1
X_3092_ _4652_/A _3092_/A VPWR VGND sg13cmos5l_inv_1
XFILLER_47_392 VPWR VGND sg13cmos5l_decap_8
X_5638__782 _5638_/RESET_B VPWR VGND sg13cmos5l_tiehi
X_5458__892 _5458_/RESET_B VPWR VGND sg13cmos5l_tiehi
X_5802_ _5802_/Q _5834_/CLK _5802_/D _5802_/RESET_B VPWR VGND sg13cmos5l_dfrbpq_1
XFILLER_22_248 VPWR VGND sg13cmos5l_fill_2
X_3994_ _3997_/B _4009_/A _3994_/B VPWR VGND sg13cmos5l_nor2_1
X_5733_ _5733_/Q _6063_/CLK _5733_/D _5733_/RESET_B VPWR VGND sg13cmos5l_dfrbpq_1
X_5664_ _5664_/Q clkload4/A _5664_/D _5664_/RESET_B VPWR VGND sg13cmos5l_dfrbpq_1
X_4615_ _4615_/Y _4832_/A _4615_/B _4615_/C VPWR VGND sg13cmos5l_nand3_1
X_5595_ _5595_/Q _5906_/CLK _5595_/D _5595_/RESET_B VPWR VGND sg13cmos5l_dfrbpq_1
X_6023__283 _6023_/D VPWR VGND sg13cmos5l_tielo
X_4546_ _4546_/Y _4546_/A _4546_/B _4546_/C VPWR VGND sg13cmos5l_nand3_1
X_5645__775 _5645_/RESET_B VPWR VGND sg13cmos5l_tiehi
X_5465__885 _5465_/RESET_B VPWR VGND sg13cmos5l_tiehi
X_4477_ _5938_/D _4477_/A _4523_/A VPWR VGND sg13cmos5l_nor2_1
X_3428_ _5710_/D _3518_/A1 _3427_/B _3427_/Y VPWR VGND sg13cmos5l_o21ai_1
X_3359_ _5664_/D _3359_/A0 _5420_/A1 _3365_/S VPWR VGND sg13cmos5l_mux2_1
Xhold1100 _3442_/A _5716_/Q VPWR VGND sg13cmos5l_dlygate4sd3_1
Xhold1133 _3642_/A _5822_/Q VPWR VGND sg13cmos5l_dlygate4sd3_1
Xhold1122 _3543_/A _5764_/Q VPWR VGND sg13cmos5l_dlygate4sd3_1
Xhold1111 _5995_/D _4824_/Y VPWR VGND sg13cmos5l_dlygate4sd3_1
XFILLER_46_819 VPWR VGND sg13cmos5l_decap_8
Xhold1155 _5430_/A _3628_/Y VPWR VGND sg13cmos5l_dlygate4sd3_1
X_6078_ _6078_/Q _6080_/CLK _6078_/D _6078_/RESET_B VPWR VGND sg13cmos5l_dfrbpq_1
Xhold1166 _4642_/A1 _5930_/Q VPWR VGND sg13cmos5l_dlygate4sd3_1
Xhold1144 _5931_/D _4469_/Y VPWR VGND sg13cmos5l_dlygate4sd3_1
Xhold1177 _3407_/A1 _5704_/Q VPWR VGND sg13cmos5l_dlygate4sd3_1
Xhold1188 _5757_/D _3530_/X VPWR VGND sg13cmos5l_dlygate4sd3_1
X_5029_ _5044_/C _6033_/Q _5059_/B VPWR VGND sg13cmos5l_xnor2_1
Xhold1199 _3391_/A1 _5689_/Q VPWR VGND sg13cmos5l_dlygate4sd3_1
XFILLER_14_727 VPWR VGND sg13cmos5l_fill_1
X_5652__768 _5652_/RESET_B VPWR VGND sg13cmos5l_tiehi
X_5472__878 _5472_/RESET_B VPWR VGND sg13cmos5l_tiehi
XFILLER_41_579 VPWR VGND sg13cmos5l_decap_8
XFILLER_6_937 VPWR VGND sg13cmos5l_decap_8
XFILLER_49_635 VPWR VGND sg13cmos5l_fill_2
XFILLER_23_1028 VPWR VGND sg13cmos5l_fill_1
XFILLER_45_830 VPWR VGND sg13cmos5l_decap_8
XFILLER_45_885 VPWR VGND sg13cmos5l_fill_1
XFILLER_8_230 VPWR VGND sg13cmos5l_fill_2
XFILLER_13_782 VPWR VGND sg13cmos5l_fill_1
X_4400_ _4400_/X _4400_/A _4580_/A VPWR VGND sg13cmos5l_and2_1
X_5380_ _5388_/S _5399_/A _5399_/B _5380_/C VPWR VGND sg13cmos5l_nor3_1
X_4331_ _4332_/C _4346_/A _4331_/B VPWR VGND sg13cmos5l_nand2_1
X_4262_ _4266_/A _4255_/X _4259_/Y _4271_/A _4265_/A _4261_/X VPWR VGND sg13cmos5l_a221oi_1
Xfanout209 _5374_/A0 _5412_/A0 VPWR VGND sg13cmos5l_buf_1
X_3213_ _5342_/B _5371_/A _5371_/B VPWR VGND sg13cmos5l_nand2b_1
X_6001_ _6001_/Q _6007_/CLK _6001_/D _6001_/RESET_B VPWR VGND sg13cmos5l_dfrbpq_1
X_4193_ _4193_/X _4193_/A _4193_/B VPWR VGND sg13cmos5l_and2_1
X_3144_ _3144_/Y _3144_/A VPWR VGND sg13cmos5l_inv_1
XFILLER_27_318 VPWR VGND sg13cmos5l_fill_1
X_3075_ _3075_/Y _4315_/A VPWR VGND sg13cmos5l_inv_1
XFILLER_39_1024 VPWR VGND sg13cmos5l_decap_4
X_3977_ _3977_/Y _3979_/S _3117_/Y _4053_/S1 VPWR VGND sg13cmos5l_a21oi_1
X_5716_ _5716_/Q _6047_/CLK _5716_/D _5716_/RESET_B VPWR VGND sg13cmos5l_dfrbpq_1
X_5964__399 _5964_/RESET_B VPWR VGND sg13cmos5l_tiehi
X_5647_ _5647_/Q clkload4/A _5647_/D _5647_/RESET_B VPWR VGND sg13cmos5l_dfrbpq_1
XFILLER_3_918 VPWR VGND sg13cmos5l_decap_8
X_5578_ _5578_/Q clkload6/A _5578_/D _5578_/RESET_B VPWR VGND sg13cmos5l_dfrbpq_1
X_4529_ _4561_/B _5976_/Q _4529_/B VPWR VGND sg13cmos5l_xnor2_1
XFILLER_14_513 VPWR VGND sg13cmos5l_fill_1
XFILLER_42_899 VPWR VGND sg13cmos5l_decap_4
X_5628__792 _5628_/RESET_B VPWR VGND sg13cmos5l_tiehi
XFILLER_5_299 VPWR VGND sg13cmos5l_fill_1
XFILLER_49_443 VPWR VGND sg13cmos5l_decap_8
XFILLER_37_627 VPWR VGND sg13cmos5l_fill_2
Xinput9 input9/X uio_in[3] VPWR VGND sg13cmos5l_buf_1
X_5850__533 _5850_/RESET_B VPWR VGND sg13cmos5l_tiehi
X_6067__924 _6067_/RESET_B VPWR VGND sg13cmos5l_tiehi
X_3900_ _3900_/Y _3910_/B _5601_/Q _4040_/S1 VPWR VGND sg13cmos5l_o21ai_1
X_5635__785 _5635_/RESET_B VPWR VGND sg13cmos5l_tiehi
X_4880_ _4883_/B _4880_/A _4880_/B VPWR VGND sg13cmos5l_nor2_1
X_5455__895 _5455_/RESET_B VPWR VGND sg13cmos5l_tiehi
X_3831_ _3831_/Y _5304_/A _3828_/C _3830_/Y VPWR VGND sg13cmos5l_a21oi_1
X_3762_ _3762_/X _3762_/A _3762_/B _3762_/C VPWR VGND sg13cmos5l_or3_1
XFILLER_20_549 VPWR VGND sg13cmos5l_fill_2
X_5501_ _5501_/Q _5555_/CLK _5501_/D _5501_/RESET_B VPWR VGND sg13cmos5l_dfrbpq_1
X_3693_ _3693_/Y _5743_/Q _3710_/S VPWR VGND sg13cmos5l_nand2b_1
X_5432_ _5851_/D _5432_/A _5432_/B VPWR VGND sg13cmos5l_and2_1
X_5363_ _5493_/D _5363_/A0 _5373_/A0 _5370_/S VPWR VGND sg13cmos5l_mux2_1
X_5642__778 _5642_/RESET_B VPWR VGND sg13cmos5l_tiehi
X_4314_ _5909_/D _4314_/A _4314_/B VPWR VGND sg13cmos5l_nor2_1
X_5294_ _5433_/D _5294_/A0 _5315_/A1 _5301_/S VPWR VGND sg13cmos5l_mux2_1
X_5894__482 _5894_/RESET_B VPWR VGND sg13cmos5l_tiehi
X_5890__302 _5890_/D VPWR VGND sg13cmos5l_tielo
X_4245_ _4246_/B _3096_/Y _4244_/X _4248_/S VPWR VGND sg13cmos5l_mux2_1
X_5462__888 _5462_/RESET_B VPWR VGND sg13cmos5l_tiehi
X_4176_ _4176_/Y _4168_/X _4175_/Y _4193_/B VPWR VGND sg13cmos5l_o21ai_1
X_3127_ _3127_/Y _5872_/Q VPWR VGND sg13cmos5l_inv_1
XFILLER_36_682 VPWR VGND sg13cmos5l_decap_4
X_5797__623 _5797_/RESET_B VPWR VGND sg13cmos5l_tiehi
XFILLER_47_914 VPWR VGND sg13cmos5l_decap_8
XFILLER_46_457 VPWR VGND sg13cmos5l_decap_8
XFILLER_26_181 VPWR VGND sg13cmos5l_fill_1
XFILLER_15_877 VPWR VGND sg13cmos5l_decap_8
XFILLER_15_899 VPWR VGND sg13cmos5l_fill_1
XFILLER_6_553 VPWR VGND sg13cmos5l_fill_1
X_5483__590 _5483_/RESET_B VPWR VGND sg13cmos5l_tiehi
X_5993__370 _5993_/RESET_B VPWR VGND sg13cmos5l_tiehi
X_4030_ _4030_/Y _4031_/A1 _4028_/Y _4011_/A VPWR VGND sg13cmos5l_o21ai_1
X_5981_ _5981_/Q _6037_/CLK _5981_/D _5981_/RESET_B VPWR VGND sg13cmos5l_dfrbpq_1
XFILLER_24_107 VPWR VGND sg13cmos5l_fill_1
X_4932_ _4932_/X _5226_/A _4932_/B VPWR VGND sg13cmos5l_and2_1
XFILLER_32_140 VPWR VGND sg13cmos5l_fill_1
X_4863_ _4866_/B _4872_/B _4872_/C _4745_/B VPWR VGND sg13cmos5l_o21ai_1
X_3814_ _3814_/Y _5830_/Q _3813_/B _3812_/Y VPWR VGND sg13cmos5l_o21ai_1
XFILLER_20_346 VPWR VGND sg13cmos5l_fill_2
X_4794_ _4794_/Y _4800_/B _4791_/Y _4796_/C _4793_/Y VPWR VGND sg13cmos5l_a22oi_1
X_3745_ _3745_/Y _3745_/A _5722_/Q VPWR VGND sg13cmos5l_nand2_1
X_3676_ _3677_/B _3714_/A _3675_/X _5807_/Q VPWR VGND sg13cmos5l_o21ai_1
X_5415_ _5540_/D _3251_/A _5415_/A1 _5417_/S VPWR VGND sg13cmos5l_mux2_1
X_5346_ _5478_/D _5346_/A0 _5413_/A0 _5351_/S VPWR VGND sg13cmos5l_mux2_1
X_5277_ _5278_/B _5277_/A _5277_/B _5277_/C VPWR VGND sg13cmos5l_nor3_1
X_4228_ _4241_/B _5912_/Q _4247_/A VPWR VGND sg13cmos5l_nor2_1
X_4159_ _5881_/D _4207_/A _4193_/B VPWR VGND sg13cmos5l_and2_1
XFILLER_16_608 VPWR VGND sg13cmos5l_fill_1
Xclkbuf_leaf_35_clk _5822_/CLK clkbuf_leaf_4_clk/A VPWR VGND sg13cmos5l_buf_8
XFILLER_12_847 VPWR VGND sg13cmos5l_decap_4
XFILLER_24_696 VPWR VGND sg13cmos5l_fill_2
XFILLER_7_339 VPWR VGND sg13cmos5l_fill_1
XFILLER_11_51 VPWR VGND sg13cmos5l_fill_2
XFILLER_3_567 VPWR VGND sg13cmos5l_fill_1
X_6057__934 _6057_/RESET_B VPWR VGND sg13cmos5l_tiehi
X_5625__795 _5625_/RESET_B VPWR VGND sg13cmos5l_tiehi
X_6064__927 _6064_/RESET_B VPWR VGND sg13cmos5l_tiehi
Xclkbuf_leaf_26_clk _6037_/CLK clkbuf_3_5__f_clk/X VPWR VGND sg13cmos5l_buf_8
X_5632__788 _5632_/RESET_B VPWR VGND sg13cmos5l_tiehi
XFILLER_30_622 VPWR VGND sg13cmos5l_decap_4
X_5452__898 _5452_/RESET_B VPWR VGND sg13cmos5l_tiehi
XFILLER_30_655 VPWR VGND sg13cmos5l_fill_1
Xinput12 input12/X uio_in[6] VPWR VGND sg13cmos5l_buf_1
X_5884__492 _5884_/RESET_B VPWR VGND sg13cmos5l_tiehi
X_3530_ _3530_/X _3591_/A _3530_/A1 _3531_/B VPWR VGND sg13cmos5l_mux2_1
X_3461_ _3461_/Y _3461_/A _3468_/B VPWR VGND sg13cmos5l_nand2_1
X_5200_ _5264_/B _5195_/A _5192_/B _5199_/X VPWR VGND sg13cmos5l_o21ai_1
X_3392_ _5690_/D _3392_/A0 _3392_/A1 _3397_/S VPWR VGND sg13cmos5l_mux2_1
X_5131_ _5131_/Y _5126_/Y _5128_/Y _5130_/Y VPWR VGND sg13cmos5l_o21ai_1
XFILLER_35_2 VPWR VGND sg13cmos5l_fill_1
X_5062_ _5064_/A _5047_/A _5042_/X _5069_/A VPWR VGND sg13cmos5l_a21o_1
Xhold1507 _5011_/A _6007_/Q VPWR VGND sg13cmos5l_dlygate4sd3_1
Xhold1518 _4817_/A2 _4816_/Y VPWR VGND sg13cmos5l_dlygate4sd3_1
Xhold1529 _5275_/A _6076_/Q VPWR VGND sg13cmos5l_dlygate4sd3_1
X_4013_ _4013_/Y _4005_/Y _4007_/Y _4063_/A VPWR VGND sg13cmos5l_o21ai_1
X_5891__485 _5891_/RESET_B VPWR VGND sg13cmos5l_tiehi
XFILLER_38_788 VPWR VGND sg13cmos5l_decap_8
Xclkbuf_leaf_17_clk _5894_/CLK clkbuf_3_6__f_clk/X VPWR VGND sg13cmos5l_buf_8
X_5964_ _5964_/Q _6077_/CLK _5964_/D _5964_/RESET_B VPWR VGND sg13cmos5l_dfrbpq_1
X_5787__633 _5787_/RESET_B VPWR VGND sg13cmos5l_tiehi
X_4915_ _4915_/Y _5226_/A _4904_/X _4913_/Y _4914_/X VPWR VGND sg13cmos5l_a22oi_1
X_5895_ _5895_/Q _5936_/CLK _5895_/D _5895_/RESET_B VPWR VGND sg13cmos5l_dfrbpq_1
X_4846_ _4846_/Y _5993_/Q _5964_/Q VPWR VGND sg13cmos5l_xnor2_1
X_4777_ _4778_/B _4777_/A _4777_/B VPWR VGND sg13cmos5l_and2_1
X_3728_ _3728_/Y _3137_/Y _5775_/Q _3736_/A1 VPWR VGND sg13cmos5l_a21oi_1
X_3659_ _3659_/Y _3760_/A1 _3651_/Y _3139_/A VPWR VGND sg13cmos5l_o21ai_1
X_5329_ _5463_/D _5329_/A0 _5367_/A1 _5332_/S VPWR VGND sg13cmos5l_mux2_1
X_5794__626 _5794_/RESET_B VPWR VGND sg13cmos5l_tiehi
XFILLER_44_714 VPWR VGND sg13cmos5l_fill_1
XFILLER_17_917 VPWR VGND sg13cmos5l_fill_1
XFILLER_17_939 VPWR VGND sg13cmos5l_decap_8
XFILLER_44_747 VPWR VGND sg13cmos5l_fill_2
XFILLER_24_460 VPWR VGND sg13cmos5l_decap_8
XFILLER_11_132 VPWR VGND sg13cmos5l_fill_2
X_5983__380 _5983_/RESET_B VPWR VGND sg13cmos5l_tiehi
XFILLER_26_1026 VPWR VGND sg13cmos5l_fill_2
X_5990__373 _5990_/RESET_B VPWR VGND sg13cmos5l_tiehi
XFILLER_47_574 VPWR VGND sg13cmos5l_decap_8
XFILLER_16_950 VPWR VGND sg13cmos5l_fill_2
XFILLER_34_257 VPWR VGND sg13cmos5l_fill_1
XFILLER_34_268 VPWR VGND sg13cmos5l_fill_1
X_5680_ _5680_/Q clkload2/A _5680_/D _5680_/RESET_B VPWR VGND sg13cmos5l_dfrbpq_1
X_5847__538 _5847_/RESET_B VPWR VGND sg13cmos5l_tiehi
X_4700_ _4708_/A _4692_/Y _4698_/Y _4699_/Y VPWR VGND sg13cmos5l_o21ai_1
X_4631_ _4637_/S _4630_/Y _4631_/B VPWR VGND sg13cmos5l_nand2b_1
X_4562_ _4657_/A _4562_/A _4774_/A VPWR VGND sg13cmos5l_nand2_1
X_4493_ _4494_/B _4496_/A _4505_/B VPWR VGND sg13cmos5l_nor2_1
X_3513_ _3513_/Y _3066_/Y _3514_/B _3512_/Y VPWR VGND sg13cmos5l_o21ai_1
X_3444_ _3595_/A _3582_/A _3545_/B VPWR VGND sg13cmos5l_nor2_1
Xclkbuf_leaf_6_clk _5840_/CLK clkbuf_leaf_6_clk/A VPWR VGND sg13cmos5l_buf_8
X_3375_ _5677_/D _3113_/Y _3376_/S _3374_/Y VPWR VGND sg13cmos5l_a21oi_1
Xhold1304 _3257_/A0 _5577_/Q VPWR VGND sg13cmos5l_dlygate4sd3_1
X_5114_ _6042_/D _5272_/A _5114_/B VPWR VGND sg13cmos5l_nor2_1
Xhold1315 _3302_/A0 _5614_/Q VPWR VGND sg13cmos5l_dlygate4sd3_1
Xhold1337 _5793_/D _3604_/X VPWR VGND sg13cmos5l_dlygate4sd3_1
Xhold1359 _5799_/D _3616_/X VPWR VGND sg13cmos5l_dlygate4sd3_1
Xhold1348 _3277_/A0 _5592_/Q VPWR VGND sg13cmos5l_dlygate4sd3_1
X_5045_ _5047_/B _5045_/A _5044_/Y VPWR VGND sg13cmos5l_nor2b_1
Xheichips26_dna_sequencer_264 uio_oe[3] VPWR VGND sg13cmos5l_tielo
Xhold1326 _3284_/A1 _5598_/Q VPWR VGND sg13cmos5l_dlygate4sd3_1
Xheichips26_dna_sequencer_275 uio_out[6] VPWR VGND sg13cmos5l_tielo
XFILLER_25_213 VPWR VGND sg13cmos5l_fill_2
XFILLER_25_257 VPWR VGND sg13cmos5l_fill_2
XFILLER_13_419 VPWR VGND sg13cmos5l_fill_1
X_5947_ _5947_/Q _5973_/CLK _5947_/D _5947_/RESET_B VPWR VGND sg13cmos5l_dfrbpq_1
XFILLER_22_997 VPWR VGND sg13cmos5l_decap_8
X_5878_ _5878_/Q _6080_/CLK _5878_/D _5878_/RESET_B VPWR VGND sg13cmos5l_dfrbpq_1
XFILLER_21_485 VPWR VGND sg13cmos5l_decap_8
X_4829_ _6000_/D _4829_/A _4829_/B VPWR VGND sg13cmos5l_and2_1
XFILLER_49_1015 VPWR VGND sg13cmos5l_decap_8
X_5622__798 _5622_/RESET_B VPWR VGND sg13cmos5l_tiehi
XFILLER_16_257 VPWR VGND sg13cmos5l_fill_2
XFILLER_17_769 VPWR VGND sg13cmos5l_fill_2
XFILLER_31_205 VPWR VGND sg13cmos5l_fill_2
X_5881__495 _5881_/RESET_B VPWR VGND sg13cmos5l_tiehi
XFILLER_4_640 VPWR VGND sg13cmos5l_fill_1
X_5777__643 _5777_/RESET_B VPWR VGND sg13cmos5l_tiehi
X_3160_ _5279_/B _6077_/Q _3160_/B VPWR VGND sg13cmos5l_nor2_1
X_3091_ _4653_/A _4438_/C VPWR VGND sg13cmos5l_inv_1
XFILLER_12_4 VPWR VGND sg13cmos5l_fill_2
X_5801_ _5801_/Q clkload7/A _5801_/D _5801_/RESET_B VPWR VGND sg13cmos5l_dfrbpq_1
X_5732_ _5732_/Q _5825_/CLK _5732_/D _5732_/RESET_B VPWR VGND sg13cmos5l_dfrbpq_1
X_3993_ _3994_/B _5621_/Q _5604_/Q _5596_/Q _5570_/Q _4036_/B _4040_/S1 VPWR VGND
+ sg13cmos5l_mux4_1
X_5784__636 _5784_/RESET_B VPWR VGND sg13cmos5l_tiehi
XFILLER_31_761 VPWR VGND sg13cmos5l_fill_2
X_5663_ _5663_/Q clkload2/A _5663_/D _5663_/RESET_B VPWR VGND sg13cmos5l_dfrbpq_1
X_5594_ _5594_/Q clkload3/A _5594_/D _5594_/RESET_B VPWR VGND sg13cmos5l_dfrbpq_1
X_4614_ _4615_/C _5976_/Q _4463_/A _4622_/B VPWR VGND sg13cmos5l_o21ai_1
X_4545_ _4545_/X _4546_/A _4546_/B _4546_/C VPWR VGND sg13cmos5l_and3_1
X_5524__438 _5524_/RESET_B VPWR VGND sg13cmos5l_tiehi
XFILLER_1_109 VPWR VGND sg13cmos5l_fill_2
X_4476_ _5937_/D _4476_/A _4523_/A VPWR VGND sg13cmos5l_nor2_1
X_3427_ _3427_/Y _3427_/A _3427_/B VPWR VGND sg13cmos5l_nand2_1
X_3358_ _5663_/D _3358_/A0 _5419_/A1 _3365_/S VPWR VGND sg13cmos5l_mux2_1
Xhold1123 _3455_/A _5722_/Q VPWR VGND sg13cmos5l_dlygate4sd3_1
X_5791__629 _5791_/RESET_B VPWR VGND sg13cmos5l_tiehi
Xhold1112 _3452_/A _5720_/Q VPWR VGND sg13cmos5l_dlygate4sd3_1
Xhold1101 _3446_/A _5717_/Q VPWR VGND sg13cmos5l_dlygate4sd3_1
Xhold1156 _5835_/D _5430_/Y VPWR VGND sg13cmos5l_dlygate4sd3_1
Xhold1134 _5426_/A _3641_/Y VPWR VGND sg13cmos5l_dlygate4sd3_1
Xhold1145 _3786_/A1 _5818_/Q VPWR VGND sg13cmos5l_dlygate4sd3_1
Xhold1167 _4641_/B _5929_/Q VPWR VGND sg13cmos5l_dlygate4sd3_1
X_6077_ _6077_/Q _6077_/CLK _6077_/D _6077_/RESET_B VPWR VGND sg13cmos5l_dfrbpq_1
X_3289_ _3297_/S _5409_/B _5409_/C _3308_/C VPWR VGND sg13cmos5l_nand3_1
X_5973__390 _5973_/RESET_B VPWR VGND sg13cmos5l_tiehi
Xhold1189 _5408_/A0 _5534_/Q VPWR VGND sg13cmos5l_dlygate4sd3_1
X_5028_ _5044_/B _6027_/Q _5998_/Q _6032_/Q VPWR VGND sg13cmos5l_nand3_1
Xhold1178 _3082_/A _5852_/Q VPWR VGND sg13cmos5l_dlygate4sd3_1
XFILLER_26_544 VPWR VGND sg13cmos5l_fill_1
XFILLER_22_783 VPWR VGND sg13cmos5l_fill_2
XFILLER_6_905 VPWR VGND sg13cmos5l_decap_8
XFILLER_10_956 VPWR VGND sg13cmos5l_fill_1
X_5980__383 _5980_/RESET_B VPWR VGND sg13cmos5l_tiehi
XFILLER_10_989 VPWR VGND sg13cmos5l_fill_2
Xhold990 _3605_/A _5794_/Q VPWR VGND sg13cmos5l_dlygate4sd3_1
XFILLER_45_875 VPWR VGND sg13cmos5l_decap_4
XFILLER_5_971 VPWR VGND sg13cmos5l_fill_2
X_4330_ _4330_/Y _4330_/A VPWR VGND sg13cmos5l_inv_1
X_4261_ _4261_/X _4261_/A _4261_/B _4261_/C VPWR VGND sg13cmos5l_and3_1
X_6018__342 _6018_/RESET_B VPWR VGND sg13cmos5l_tiehi
X_6000_ _6000_/Q _6007_/CLK _6000_/D _6000_/RESET_B VPWR VGND sg13cmos5l_dfrbpq_1
X_3212_ _5409_/B _3824_/A _3824_/B VPWR VGND sg13cmos5l_nor2b_1
X_4192_ _4192_/Y _4192_/A _4221_/A VPWR VGND sg13cmos5l_nor2_1
X_3143_ _3143_/Y _3143_/A VPWR VGND sg13cmos5l_inv_1
X_3074_ _3074_/Y _3074_/A VPWR VGND sg13cmos5l_inv_1
XFILLER_36_820 VPWR VGND sg13cmos5l_fill_2
X_5493__570 _5493_/RESET_B VPWR VGND sg13cmos5l_tiehi
XFILLER_36_897 VPWR VGND sg13cmos5l_decap_4
XFILLER_24_18 VPWR VGND sg13cmos5l_fill_1
X_3976_ _3976_/Y _4068_/A _3976_/B VPWR VGND sg13cmos5l_nor2_1
X_5715_ _5715_/Q _6047_/CLK _5715_/D _5715_/RESET_B VPWR VGND sg13cmos5l_dfrbpq_1
X_5646_ _5646_/Q clkload5/A _5646_/D _5646_/RESET_B VPWR VGND sg13cmos5l_dfrbpq_1
X_5577_ _5577_/Q clkload8/A _5577_/D _5577_/RESET_B VPWR VGND sg13cmos5l_dfrbpq_1
X_4528_ _4529_/B _4829_/A _5975_/Q _5974_/Q VPWR VGND sg13cmos5l_nor3_1
XFILLER_46_1018 VPWR VGND sg13cmos5l_decap_8
X_4459_ _4459_/Y _4459_/A1 _4458_/B _4458_/Y VPWR VGND sg13cmos5l_o21ai_1
XFILLER_46_628 VPWR VGND sg13cmos5l_decap_4
XFILLER_45_127 VPWR VGND sg13cmos5l_fill_2
XFILLER_26_374 VPWR VGND sg13cmos5l_fill_2
XFILLER_14_569 VPWR VGND sg13cmos5l_fill_2
X_5767__653 _5767_/RESET_B VPWR VGND sg13cmos5l_tiehi
XFILLER_5_201 VPWR VGND sg13cmos5l_fill_1
XFILLER_2_985 VPWR VGND sg13cmos5l_decap_8
XFILLER_49_422 VPWR VGND sg13cmos5l_decap_8
X_5774__646 _5774_/RESET_B VPWR VGND sg13cmos5l_tiehi
XFILLER_49_499 VPWR VGND sg13cmos5l_decap_8
XFILLER_18_853 VPWR VGND sg13cmos5l_fill_2
XFILLER_45_694 VPWR VGND sg13cmos5l_fill_2
X_5913__299 _5913_/D VPWR VGND sg13cmos5l_tielo
XFILLER_17_396 VPWR VGND sg13cmos5l_fill_1
X_3830_ _3830_/Y _5304_/A _3828_/C _5304_/C VPWR VGND sg13cmos5l_o21ai_1
X_3761_ _3762_/C _3745_/Y _3746_/Y _3748_/Y _3761_/B2 _3138_/Y VPWR VGND sg13cmos5l_a221oi_1
X_5500_ _5500_/Q clkload9/A _5500_/D _5500_/RESET_B VPWR VGND sg13cmos5l_dfrbpq_1
X_5781__639 _5781_/RESET_B VPWR VGND sg13cmos5l_tiehi
X_3692_ _3692_/X _5737_/Q _5731_/Q _3710_/S VPWR VGND sg13cmos5l_mux2_1
X_5431_ _5836_/D _3083_/Y _5431_/A2 _3632_/Y VPWR VGND sg13cmos5l_a21oi_1
X_5362_ _5492_/D _5362_/A0 _5372_/A0 _5370_/S VPWR VGND sg13cmos5l_mux2_1
X_4313_ _5908_/D _4313_/A _4313_/B VPWR VGND sg13cmos5l_and2_1
X_5293_ _5302_/B _5380_/C _5333_/B VPWR VGND sg13cmos5l_nor2_1
X_4244_ _4244_/X _5910_/Q _4244_/B VPWR VGND sg13cmos5l_and2_1
X_4175_ _4175_/Y _3128_/Y _4143_/Y _4173_/Y _4174_/Y _5872_/Q VPWR VGND sg13cmos5l_a221oi_1
X_3126_ _3865_/A _3126_/A VPWR VGND sg13cmos5l_inv_1
X_5970__393 _5970_/RESET_B VPWR VGND sg13cmos5l_tiehi
XFILLER_42_108 VPWR VGND sg13cmos5l_fill_1
XFILLER_11_506 VPWR VGND sg13cmos5l_fill_2
X_3959_ _3959_/X _5666_/Q _5649_/Q _4085_/S VPWR VGND sg13cmos5l_mux2_1
X_5629_ _5629_/Q clkload5/A _5629_/D _5629_/RESET_B VPWR VGND sg13cmos5l_dfrbpq_1
XFILLER_46_436 VPWR VGND sg13cmos5l_decap_8
XFILLER_18_138 VPWR VGND sg13cmos5l_fill_2
X_6008__352 _6008_/RESET_B VPWR VGND sg13cmos5l_tiehi
XFILLER_10_572 VPWR VGND sg13cmos5l_fill_2
XFILLER_2_43 VPWR VGND sg13cmos5l_fill_1
X_6015__345 _6015_/RESET_B VPWR VGND sg13cmos5l_tiehi
X_5520__474 _5520_/RESET_B VPWR VGND sg13cmos5l_tiehi
XFILLER_37_425 VPWR VGND sg13cmos5l_fill_1
X_5980_ _5980_/Q _6037_/CLK _5980_/D _5980_/RESET_B VPWR VGND sg13cmos5l_dfrbpq_1
XFILLER_45_480 VPWR VGND sg13cmos5l_decap_8
X_4931_ _6010_/D _5071_/A _4931_/B VPWR VGND sg13cmos5l_nor2_1
X_4862_ _4866_/A _4880_/A _4862_/B VPWR VGND sg13cmos5l_nor2_1
XFILLER_36_1017 VPWR VGND sg13cmos5l_decap_8
X_3813_ _3815_/B _5830_/Q _3813_/B VPWR VGND sg13cmos5l_nor2_1
XFILLER_32_174 VPWR VGND sg13cmos5l_fill_1
XFILLER_36_1028 VPWR VGND sg13cmos5l_fill_1
X_4793_ _4793_/Y _6008_/Q _5008_/A VPWR VGND sg13cmos5l_nor2b_1
X_3744_ _5813_/D _3744_/A _3744_/B VPWR VGND sg13cmos5l_and2_1
X_3675_ _3675_/X _5772_/Q _5766_/Q _5760_/Q _5754_/Q _3749_/B _3752_/A VPWR VGND sg13cmos5l_mux4_1
X_5414_ _5539_/D _5414_/A0 _5414_/A1 _5417_/S VPWR VGND sg13cmos5l_mux2_1
X_5345_ _5477_/D _5345_/A0 _5374_/A0 _5351_/S VPWR VGND sg13cmos5l_mux2_1
X_5276_ _5277_/C _5275_/A _3190_/A _5275_/Y VPWR VGND sg13cmos5l_a21oi_1
X_4227_ _4227_/Y _5890_/Q _4231_/A VPWR VGND sg13cmos5l_xnor2_1
X_5757__663 _5757_/RESET_B VPWR VGND sg13cmos5l_tiehi
X_4158_ _5863_/D _4221_/A _4207_/D VPWR VGND sg13cmos5l_nor2_1
X_3109_ _3220_/B input2/X VPWR VGND sg13cmos5l_inv_1
X_4089_ _4089_/Y _5616_/Q _4089_/B VPWR VGND sg13cmos5l_nand2b_1
XFILLER_37_970 VPWR VGND sg13cmos5l_fill_1
XFILLER_24_620 VPWR VGND sg13cmos5l_fill_1
XFILLER_37_992 VPWR VGND sg13cmos5l_fill_1
XFILLER_24_686 VPWR VGND sg13cmos5l_fill_1
X_5764__656 _5764_/RESET_B VPWR VGND sg13cmos5l_tiehi
XFILLER_47_778 VPWR VGND sg13cmos5l_decap_8
X_5771__649 _5771_/RESET_B VPWR VGND sg13cmos5l_tiehi
Xinput13 input13/X uio_in[7] VPWR VGND sg13cmos5l_buf_1
XFILLER_11_881 VPWR VGND sg13cmos5l_decap_4
X_3460_ _5723_/D _3509_/A1 _3468_/B _3459_/Y VPWR VGND sg13cmos5l_o21ai_1
X_3391_ _5689_/D _3391_/A0 _3391_/A1 _3397_/S VPWR VGND sg13cmos5l_mux2_1
X_5130_ _5130_/Y _6022_/Q _5147_/A _6067_/Q _5129_/Y VPWR VGND sg13cmos5l_a22oi_1
X_5061_ _5069_/A _5052_/Y _5058_/Y _5060_/Y VPWR VGND sg13cmos5l_o21ai_1
Xhold1508 _4639_/B _5958_/Q VPWR VGND sg13cmos5l_dlygate4sd3_1
Xhold1519 _5990_/D _4817_/Y VPWR VGND sg13cmos5l_dlygate4sd3_1
X_4012_ _4012_/Y _4012_/A _4012_/B _4012_/C VPWR VGND sg13cmos5l_nor3_1
X_5963_ _5963_/Q _5994_/CLK _5963_/D _5963_/RESET_B VPWR VGND sg13cmos5l_dfrbpq_1
X_4914_ _4914_/X _6012_/Q _4914_/B VPWR VGND sg13cmos5l_xor2_1
X_5894_ _5894_/Q _5894_/CLK _5894_/D _5894_/RESET_B VPWR VGND sg13cmos5l_dfrbpq_1
XFILLER_33_472 VPWR VGND sg13cmos5l_fill_1
X_4845_ _4845_/Y _5995_/Q _5966_/Q VPWR VGND sg13cmos5l_nand2_1
XFILLER_20_166 VPWR VGND sg13cmos5l_decap_4
X_4776_ _4777_/B _4774_/B _4770_/B _4775_/Y VPWR VGND sg13cmos5l_a21o_1
X_3727_ _3727_/Y _3749_/B _5769_/Q VPWR VGND sg13cmos5l_nand2_1
X_3658_ _3658_/X _5795_/Q _5789_/Q _5783_/Q _5777_/Q _3749_/B _3752_/A VPWR VGND sg13cmos5l_mux4_1
X_3589_ _3589_/Y _3589_/A _3591_/B VPWR VGND sg13cmos5l_nand2_1
XFILLER_0_538 VPWR VGND sg13cmos5l_fill_2
X_5328_ _5462_/D _5328_/A0 _5414_/A0 _5332_/S VPWR VGND sg13cmos5l_mux2_1
XFILLER_48_509 VPWR VGND sg13cmos5l_decap_8
X_5259_ _5259_/Y _5251_/A _5196_/Y _5258_/Y VPWR VGND sg13cmos5l_a21oi_1
XFILLER_28_255 VPWR VGND sg13cmos5l_fill_2
XFILLER_43_225 VPWR VGND sg13cmos5l_fill_2
XFILLER_43_214 VPWR VGND sg13cmos5l_fill_1
XFILLER_16_417 VPWR VGND sg13cmos5l_fill_1
X_5864__308 _5864_/D VPWR VGND sg13cmos5l_tielo
X_6005__355 _6005_/RESET_B VPWR VGND sg13cmos5l_tiehi
XFILLER_4_877 VPWR VGND sg13cmos5l_fill_2
XFILLER_4_866 VPWR VGND sg13cmos5l_fill_1
XFILLER_3_332 VPWR VGND sg13cmos5l_fill_2
XFILLER_0_0 VPWR VGND sg13cmos5l_fill_2
X_6070__921 _6070_/RESET_B VPWR VGND sg13cmos5l_tiehi
Xfanout190 _4029_/S _3897_/A1 VPWR VGND sg13cmos5l_buf_1
XFILLER_47_553 VPWR VGND sg13cmos5l_decap_8
X_6012__348 _6012_/RESET_B VPWR VGND sg13cmos5l_tiehi
XFILLER_35_759 VPWR VGND sg13cmos5l_decap_4
XFILLER_42_280 VPWR VGND sg13cmos5l_fill_1
X_4630_ _4630_/Y _4639_/B _4627_/Y _4639_/A VPWR VGND sg13cmos5l_o21ai_1
XFILLER_31_965 VPWR VGND sg13cmos5l_decap_8
X_5747__673 _5747_/RESET_B VPWR VGND sg13cmos5l_tiehi
X_4561_ _4774_/A _4561_/A _4561_/B VPWR VGND sg13cmos5l_and2_1
X_4492_ _4510_/A _4509_/B _4509_/C _4509_/A VPWR VGND sg13cmos5l_a21oi_1
XFILLER_7_693 VPWR VGND sg13cmos5l_fill_2
X_3512_ _3512_/Y _3512_/A _3514_/B VPWR VGND sg13cmos5l_nand2_1
X_5823__583 _5823_/RESET_B VPWR VGND sg13cmos5l_tiehi
X_3443_ _5716_/D _3518_/A1 _3442_/B _3442_/Y VPWR VGND sg13cmos5l_a21oi_1
X_3374_ _3374_/Y _3374_/A _3374_/B VPWR VGND sg13cmos5l_nor2_1
X_5113_ _5113_/X _5083_/Y _5110_/Y _5120_/S VPWR VGND sg13cmos5l_mux2_1
Xhold1316 _5351_/A0 _5483_/Q VPWR VGND sg13cmos5l_dlygate4sd3_1
Xhold1305 _5343_/A0 _5475_/Q VPWR VGND sg13cmos5l_dlygate4sd3_1
X_5044_ _5044_/Y _5044_/A _5044_/B _5044_/C VPWR VGND sg13cmos5l_nand3_1
Xhold1349 _4302_/A1 _5874_/Q VPWR VGND sg13cmos5l_dlygate4sd3_1
Xhold1338 _3282_/A1 _5596_/Q VPWR VGND sg13cmos5l_dlygate4sd3_1
Xhold1327 _5412_/A1 _5537_/Q VPWR VGND sg13cmos5l_dlygate4sd3_1
Xheichips26_dna_sequencer_276 uio_out[7] VPWR VGND sg13cmos5l_tielo
Xheichips26_dna_sequencer_265 uio_oe[4] VPWR VGND sg13cmos5l_tielo
X_5754__666 _5754_/RESET_B VPWR VGND sg13cmos5l_tiehi
XFILLER_38_597 VPWR VGND sg13cmos5l_fill_2
X_5946_ _5946_/Q _5973_/CLK _5946_/D _5946_/RESET_B VPWR VGND sg13cmos5l_dfrbpq_1
XFILLER_13_409 VPWR VGND sg13cmos5l_fill_1
XFILLER_22_943 VPWR VGND sg13cmos5l_fill_1
X_5877_ _5877_/Q _6080_/CLK _5877_/D _5877_/RESET_B VPWR VGND sg13cmos5l_dfrbpq_1
XFILLER_34_792 VPWR VGND sg13cmos5l_fill_2
XFILLER_21_464 VPWR VGND sg13cmos5l_decap_8
X_4828_ _5999_/D _4828_/A _4829_/B VPWR VGND sg13cmos5l_and2_1
XFILLER_5_619 VPWR VGND sg13cmos5l_fill_2
X_4759_ _4759_/X _4759_/A _4759_/B _4759_/C VPWR VGND sg13cmos5l_and3_1
X_5761__659 _5761_/RESET_B VPWR VGND sg13cmos5l_tiehi
XFILLER_32_707 VPWR VGND sg13cmos5l_fill_1
XFILLER_44_589 VPWR VGND sg13cmos5l_decap_8
XFILLER_13_910 VPWR VGND sg13cmos5l_decap_4
XFILLER_13_943 VPWR VGND sg13cmos5l_decap_8
XFILLER_13_954 VPWR VGND sg13cmos5l_decap_8
XFILLER_13_965 VPWR VGND sg13cmos5l_fill_2
XFILLER_3_140 VPWR VGND sg13cmos5l_fill_1
X_3090_ _4561_/A _4829_/A VPWR VGND sg13cmos5l_inv_1
XFILLER_48_873 VPWR VGND sg13cmos5l_decap_8
XFILLER_35_556 VPWR VGND sg13cmos5l_fill_2
X_5800_ _5800_/Q _5822_/CLK _5800_/D _5800_/RESET_B VPWR VGND sg13cmos5l_dfrbpq_1
X_3992_ _5852_/D _4124_/A _4304_/A2 _3991_/Y VPWR VGND sg13cmos5l_a21oi_1
X_5731_ _5731_/Q _5825_/CLK _5731_/D _5731_/RESET_B VPWR VGND sg13cmos5l_dfrbpq_1
X_5662_ _5662_/Q _5810_/CLK _5662_/D _5662_/RESET_B VPWR VGND sg13cmos5l_dfrbpq_1
X_5593_ _5593_/Q clkload6/A _5593_/D _5593_/RESET_B VPWR VGND sg13cmos5l_dfrbpq_1
XFILLER_30_294 VPWR VGND sg13cmos5l_fill_1
X_4613_ _4613_/Y _4613_/A _4622_/B VPWR VGND sg13cmos5l_nand2_1
XFILLER_8_991 VPWR VGND sg13cmos5l_decap_8
X_4544_ _4546_/C _4829_/A _4541_/Y _4543_/Y VPWR VGND sg13cmos5l_a21o_1
X_4475_ _5936_/D _4475_/A _4475_/B VPWR VGND sg13cmos5l_and2_1
X_3426_ _5709_/D _3440_/A _3426_/A1 _3427_/B VPWR VGND sg13cmos5l_mux2_1
X_3357_ _5662_/D _3357_/A0 _5418_/A1 _3365_/S VPWR VGND sg13cmos5l_mux2_1
Xhold1124 _3456_/B1 _3455_/Y VPWR VGND sg13cmos5l_dlygate4sd3_1
Xhold1102 _3436_/A _5713_/Q VPWR VGND sg13cmos5l_dlygate4sd3_1
Xhold1113 _3117_/A _5549_/Q VPWR VGND sg13cmos5l_dlygate4sd3_1
X_6076_ _6076_/Q _6077_/CLK _6076_/D _6076_/RESET_B VPWR VGND sg13cmos5l_dfrbpq_1
X_3288_ _5602_/D _5302_/A _3288_/A1 _3288_/S VPWR VGND sg13cmos5l_mux2_1
Xhold1146 _5818_/D _3786_/Y VPWR VGND sg13cmos5l_dlygate4sd3_1
Xhold1157 _3408_/B _5817_/Q VPWR VGND sg13cmos5l_dlygate4sd3_1
Xhold1135 _5807_/D _3644_/Y VPWR VGND sg13cmos5l_dlygate4sd3_1
X_5027_ _5044_/A _6031_/Q _5059_/B VPWR VGND sg13cmos5l_nand2_1
Xhold1179 _5874_/D _4184_/Y VPWR VGND sg13cmos5l_dlygate4sd3_1
Xhold1168 _4644_/A1 _5931_/Q VPWR VGND sg13cmos5l_dlygate4sd3_1
X_5929_ _5929_/Q _6077_/CLK _5929_/D _5929_/RESET_B VPWR VGND sg13cmos5l_dfrbpq_1
X_6060__931 _6060_/RESET_B VPWR VGND sg13cmos5l_tiehi
XFILLER_22_795 VPWR VGND sg13cmos5l_fill_1
XFILLER_10_968 VPWR VGND sg13cmos5l_decap_4
X_6002__358 _6002_/RESET_B VPWR VGND sg13cmos5l_tiehi
Xhold991 _3481_/A _5734_/Q VPWR VGND sg13cmos5l_dlygate4sd3_1
Xhold980 _4473_/B _5904_/Q VPWR VGND sg13cmos5l_dlygate4sd3_1
XFILLER_49_615 VPWR VGND sg13cmos5l_fill_1
XFILLER_49_604 VPWR VGND sg13cmos5l_decap_8
XFILLER_49_637 VPWR VGND sg13cmos5l_fill_1
X_5737__683 _5737_/RESET_B VPWR VGND sg13cmos5l_tiehi
Xhold1680 _4200_/C _5881_/Q VPWR VGND sg13cmos5l_dlygate4sd3_1
XFILLER_44_320 VPWR VGND sg13cmos5l_fill_2
XFILLER_44_375 VPWR VGND sg13cmos5l_fill_1
XFILLER_44_397 VPWR VGND sg13cmos5l_fill_2
XFILLER_40_581 VPWR VGND sg13cmos5l_decap_8
X_5744__676 _5744_/RESET_B VPWR VGND sg13cmos5l_tiehi
X_4260_ _4271_/A _5868_/Q _4261_/B VPWR VGND sg13cmos5l_xnor2_1
XFILLER_4_471 VPWR VGND sg13cmos5l_fill_1
X_3211_ _5399_/B _5304_/B _5304_/A VPWR VGND sg13cmos5l_nand2b_1
X_4191_ _5879_/D _5432_/B _4200_/B VPWR VGND sg13cmos5l_and2_1
X_3142_ _3142_/Y _5719_/Q VPWR VGND sg13cmos5l_inv_1
X_5790__630 _5790_/RESET_B VPWR VGND sg13cmos5l_tiehi
X_3073_ _3073_/Y _3073_/A VPWR VGND sg13cmos5l_inv_1
X_5751__669 _5751_/RESET_B VPWR VGND sg13cmos5l_tiehi
X_3975_ _3976_/B _4061_/A _3975_/B VPWR VGND sg13cmos5l_nor2_1
X_5714_ _5714_/Q _6077_/CLK _5714_/D _5714_/RESET_B VPWR VGND sg13cmos5l_dfrbpq_1
X_5645_ _5645_/Q _5810_/CLK _5645_/D _5645_/RESET_B VPWR VGND sg13cmos5l_dfrbpq_1
X_5576_ _5576_/Q _5864_/CLK _5576_/D _5576_/RESET_B VPWR VGND sg13cmos5l_dfrbpq_1
X_4527_ _4532_/B _4829_/A _5974_/Q VPWR VGND sg13cmos5l_nor2_1
X_4458_ _4458_/Y _4458_/A _4458_/B VPWR VGND sg13cmos5l_nand2_1
X_3409_ _3411_/B _3409_/A _3634_/B VPWR VGND sg13cmos5l_nand2_1
X_4389_ _4389_/Y _4396_/B _4371_/Y VPWR VGND sg13cmos5l_nor2b_1
X_6059_ _6059_/Q _6061_/CLK _6059_/D _6059_/RESET_B VPWR VGND sg13cmos5l_dfrbpq_1
XFILLER_26_320 VPWR VGND sg13cmos5l_decap_4
XFILLER_10_710 VPWR VGND sg13cmos5l_fill_2
XFILLER_10_776 VPWR VGND sg13cmos5l_fill_1
XFILLER_2_964 VPWR VGND sg13cmos5l_decap_8
XFILLER_49_401 VPWR VGND sg13cmos5l_decap_8
XFILLER_7_1024 VPWR VGND sg13cmos5l_decap_4
XFILLER_37_607 VPWR VGND sg13cmos5l_fill_1
XFILLER_49_478 VPWR VGND sg13cmos5l_decap_8
XFILLER_44_161 VPWR VGND sg13cmos5l_fill_1
XFILLER_33_824 VPWR VGND sg13cmos5l_fill_1
XFILLER_33_879 VPWR VGND sg13cmos5l_fill_2
X_3760_ _3762_/B _3760_/A1 _3754_/Y _3759_/Y VPWR VGND sg13cmos5l_a21oi_1
X_5430_ _5430_/Y _5430_/A _5430_/B VPWR VGND sg13cmos5l_nor2_1
X_3691_ _3691_/Y _3745_/A _5725_/Q _3690_/Y VPWR VGND sg13cmos5l_o21ai_1
X_5361_ _5369_/S _5371_/A _5371_/B _5361_/C _5361_/D VPWR VGND sg13cmos5l_nor4_1
X_5292_ _5333_/B _5352_/A _5352_/B _5352_/C VPWR VGND sg13cmos5l_nand3_1
X_4312_ _5907_/D _4312_/A _4314_/B VPWR VGND sg13cmos5l_nor2_1
X_4243_ _4248_/S _4236_/Y _4242_/Y _4227_/Y VPWR VGND sg13cmos5l_o21ai_1
X_4174_ _4174_/Y _3128_/A _4144_/Y _4171_/Y _3129_/A VPWR VGND sg13cmos5l_a22oi_1
XFILLER_27_117 VPWR VGND sg13cmos5l_fill_2
X_3125_ _3125_/Y _5448_/Q VPWR VGND sg13cmos5l_inv_1
XFILLER_35_172 VPWR VGND sg13cmos5l_fill_2
X_3958_ _3958_/Y _4089_/B _5700_/Q _3957_/Y VPWR VGND sg13cmos5l_o21ai_1
XFILLER_32_890 VPWR VGND sg13cmos5l_fill_1
X_3889_ _3889_/X _5558_/Q _5541_/Q _5524_/Q _5507_/Q _4100_/S0 _4100_/S1 VPWR VGND
+ sg13cmos5l_mux4_1
X_5628_ _5628_/Q clkload1/A _5628_/D _5628_/RESET_B VPWR VGND sg13cmos5l_dfrbpq_1
X_5559_ _5559_/Q _5559_/CLK _5559_/D _5559_/RESET_B VPWR VGND sg13cmos5l_dfrbpq_1
XFILLER_2_205 VPWR VGND sg13cmos5l_fill_2
X_5727__693 _5727_/RESET_B VPWR VGND sg13cmos5l_tiehi
XFILLER_47_949 VPWR VGND sg13cmos5l_decap_8
XFILLER_46_415 VPWR VGND sg13cmos5l_decap_8
X_5734__686 _5734_/RESET_B VPWR VGND sg13cmos5l_tiehi
XFILLER_26_172 VPWR VGND sg13cmos5l_fill_2
X_5867__306 _5867_/D VPWR VGND sg13cmos5l_tielo
XFILLER_41_50 VPWR VGND sg13cmos5l_fill_2
X_5780__640 _5780_/RESET_B VPWR VGND sg13cmos5l_tiehi
X_5741__679 _5741_/RESET_B VPWR VGND sg13cmos5l_tiehi
XFILLER_38_905 VPWR VGND sg13cmos5l_decap_4
X_5850__310 _5850_/D VPWR VGND sg13cmos5l_tielo
X_4930_ _4931_/B _5015_/A _5015_/B VPWR VGND sg13cmos5l_or2_1
X_4861_ _4861_/Y _4861_/A _4861_/B VPWR VGND sg13cmos5l_xnor2_1
X_3812_ _3812_/Y _5830_/Q _5829_/Q _5828_/Q _3812_/D VPWR VGND sg13cmos5l_nand4_1
X_4792_ _4796_/C _6008_/Q _4639_/A _4800_/B VPWR VGND sg13cmos5l_o21ai_1
X_3743_ _3744_/B _3741_/Y _3742_/Y _3724_/Y VPWR VGND sg13cmos5l_o21ai_1
X_3674_ _3677_/A _3761_/B2 _3667_/X _3673_/Y VPWR VGND sg13cmos5l_a21oi_1
X_5413_ _5538_/D _5413_/A0 _5413_/A1 _5417_/S VPWR VGND sg13cmos5l_mux2_1
X_5344_ _5476_/D _5344_/A0 _5373_/A0 _5351_/S VPWR VGND sg13cmos5l_mux2_1
X_5275_ _5275_/Y _5275_/A _5284_/B VPWR VGND sg13cmos5l_nor2_1
X_4226_ _4250_/A _4226_/A _4231_/A VPWR VGND sg13cmos5l_xor2_1
X_4157_ _4207_/D _4138_/Y _4157_/A2 _4275_/A VPWR VGND sg13cmos5l_a21oi_1
X_3108_ _4192_/A _3108_/A VPWR VGND sg13cmos5l_inv_1
X_4088_ _4088_/Y _4097_/S _3123_/Y _4087_/Y VPWR VGND sg13cmos5l_a21oi_1
X_5833__563 _5833_/RESET_B VPWR VGND sg13cmos5l_tiehi
XFILLER_28_459 VPWR VGND sg13cmos5l_decap_8
XFILLER_36_481 VPWR VGND sg13cmos5l_decap_8
XFILLER_47_724 VPWR VGND sg13cmos5l_decap_4
XFILLER_4_1027 VPWR VGND sg13cmos5l_fill_2
XFILLER_35_908 VPWR VGND sg13cmos5l_fill_2
XFILLER_27_470 VPWR VGND sg13cmos5l_fill_2
XFILLER_42_484 VPWR VGND sg13cmos5l_decap_8
X_3390_ _5688_/D _5353_/A0 _3390_/A1 _3397_/S VPWR VGND sg13cmos5l_mux2_1
X_5060_ _5060_/Y _5070_/A _5057_/B _5059_/Y VPWR VGND sg13cmos5l_a21oi_1
Xhold1509 _4640_/A2 _4639_/Y VPWR VGND sg13cmos5l_dlygate4sd3_1
X_4011_ _4012_/C _4011_/A _4011_/B VPWR VGND sg13cmos5l_nor2_1
XFILLER_38_757 VPWR VGND sg13cmos5l_fill_1
X_5962_ _5962_/Q _5994_/CLK _5962_/D _5962_/RESET_B VPWR VGND sg13cmos5l_dfrbpq_1
X_4913_ _4913_/Y _4918_/B _5201_/B VPWR VGND sg13cmos5l_nand2b_1
X_5893_ _5893_/Q _5894_/CLK _5893_/D _5893_/RESET_B VPWR VGND sg13cmos5l_dfrbpq_1
X_4844_ _4844_/X _4869_/A _4869_/B VPWR VGND sg13cmos5l_or2_1
X_4775_ _4775_/Y _4771_/B _4775_/B VPWR VGND sg13cmos5l_nand2b_1
X_3726_ _3726_/Y _3726_/A1 _5763_/Q _3725_/Y VPWR VGND sg13cmos5l_o21ai_1
X_5527__404 _5527_/RESET_B VPWR VGND sg13cmos5l_tiehi
X_3657_ _3657_/Y _3714_/A _3653_/X _3656_/Y VPWR VGND sg13cmos5l_o21ai_1
X_3588_ _5785_/D _3613_/A1 _3593_/B _3587_/Y VPWR VGND sg13cmos5l_o21ai_1
X_5724__696 _5724_/RESET_B VPWR VGND sg13cmos5l_tiehi
X_5327_ _5461_/D _5327_/A0 _5413_/A0 _5332_/S VPWR VGND sg13cmos5l_mux2_1
X_5258_ _5258_/Y _5258_/A _5270_/B VPWR VGND sg13cmos5l_nor2_1
X_5189_ _5189_/Y _5254_/A _5253_/A VPWR VGND sg13cmos5l_nand2_1
X_4209_ _4210_/B _4203_/A _4205_/B _4194_/Y VPWR VGND sg13cmos5l_a21oi_1
X_5770__650 _5770_/RESET_B VPWR VGND sg13cmos5l_tiehi
XFILLER_43_248 VPWR VGND sg13cmos5l_fill_2
X_5731__689 _5731_/RESET_B VPWR VGND sg13cmos5l_tiehi
X_5447__903 _5447_/RESET_B VPWR VGND sg13cmos5l_tiehi
XFILLER_4_834 VPWR VGND sg13cmos5l_fill_2
XFILLER_4_823 VPWR VGND sg13cmos5l_fill_2
XFILLER_4_856 VPWR VGND sg13cmos5l_fill_2
XFILLER_26_1006 VPWR VGND sg13cmos5l_fill_2
XFILLER_26_1028 VPWR VGND sg13cmos5l_fill_1
XFILLER_47_532 VPWR VGND sg13cmos5l_decap_8
Xfanout180 _4083_/A1 fanout196/X VPWR VGND sg13cmos5l_buf_1
Xfanout191 _4045_/B _3998_/S0 VPWR VGND sg13cmos5l_buf_1
XFILLER_16_952 VPWR VGND sg13cmos5l_fill_1
XFILLER_31_900 VPWR VGND sg13cmos5l_fill_1
XFILLER_43_793 VPWR VGND sg13cmos5l_fill_2
X_4560_ _5945_/D _4638_/A _4560_/B VPWR VGND sg13cmos5l_nor2_1
X_3511_ _3511_/Y _3140_/Y _3514_/B _3510_/Y VPWR VGND sg13cmos5l_a21oi_1
XFILLER_6_160 VPWR VGND sg13cmos5l_fill_1
X_4491_ _4509_/C _4491_/A _4491_/B _5937_/Q VPWR VGND sg13cmos5l_nand3_1
X_3442_ _3442_/Y _3442_/A _3442_/B VPWR VGND sg13cmos5l_nor2_1
X_3373_ _5676_/D _3119_/Y _3374_/B _3372_/Y VPWR VGND sg13cmos5l_a21oi_1
X_5112_ _5114_/B _5083_/A _5111_/Y _5120_/S VPWR VGND sg13cmos5l_mux2_1
Xhold1306 _3350_/A1 _5656_/Q VPWR VGND sg13cmos5l_dlygate4sd3_1
Xhold1328 _5396_/A1 _5523_/Q VPWR VGND sg13cmos5l_dlygate4sd3_1
Xhold1317 _5404_/A0 _5530_/Q VPWR VGND sg13cmos5l_dlygate4sd3_1
X_5043_ _5043_/Y _5047_/A _5042_/X _5021_/X VPWR VGND sg13cmos5l_a21oi_1
Xhold1339 _5322_/A0 _5457_/Q VPWR VGND sg13cmos5l_dlygate4sd3_1
Xheichips26_dna_sequencer_277 uo_out[6] VPWR VGND sg13cmos5l_tielo
Xheichips26_dna_sequencer_266 uio_oe[5] VPWR VGND sg13cmos5l_tielo
XFILLER_26_705 VPWR VGND sg13cmos5l_fill_1
X_5945_ _5945_/Q _5973_/CLK _5945_/D _5945_/RESET_B VPWR VGND sg13cmos5l_dfrbpq_1
XFILLER_22_933 VPWR VGND sg13cmos5l_fill_2
X_5876_ _5876_/Q _5906_/CLK _5876_/D _5876_/RESET_B VPWR VGND sg13cmos5l_dfrbpq_1
XFILLER_21_443 VPWR VGND sg13cmos5l_decap_8
XFILLER_22_988 VPWR VGND sg13cmos5l_decap_4
X_4827_ _5998_/D _4827_/A _4827_/B VPWR VGND sg13cmos5l_and2_1
X_4758_ _4759_/C _5951_/Q _5950_/Q _4758_/B1 VPWR VGND sg13cmos5l_o21ai_1
X_3709_ _3709_/X _5738_/Q _5732_/Q _3753_/B VPWR VGND sg13cmos5l_mux2_1
X_4689_ _4697_/B _4604_/B _4571_/B _4689_/S VPWR VGND sg13cmos5l_mux2_1
XFILLER_44_513 VPWR VGND sg13cmos5l_decap_4
XFILLER_44_568 VPWR VGND sg13cmos5l_decap_8
XFILLER_31_207 VPWR VGND sg13cmos5l_fill_1
XFILLER_47_351 VPWR VGND sg13cmos5l_fill_1
XFILLER_23_708 VPWR VGND sg13cmos5l_fill_2
X_3991_ _3991_/Y _4304_/A2 _4124_/B _5291_/A VPWR VGND sg13cmos5l_o21ai_1
X_5730_ _5730_/Q _5825_/CLK _5730_/D _5730_/RESET_B VPWR VGND sg13cmos5l_dfrbpq_1
XFILLER_15_270 VPWR VGND sg13cmos5l_fill_2
X_5661_ _5661_/Q _5864_/CLK _5661_/D _5661_/RESET_B VPWR VGND sg13cmos5l_dfrbpq_1
XFILLER_30_273 VPWR VGND sg13cmos5l_fill_1
X_5592_ _5592_/Q clkload5/A _5592_/D _5592_/RESET_B VPWR VGND sg13cmos5l_dfrbpq_1
XFILLER_30_284 VPWR VGND sg13cmos5l_fill_2
X_4612_ _4622_/B _4608_/Y _4610_/Y _4611_/Y VPWR VGND sg13cmos5l_o21ai_1
X_4543_ _4543_/Y _5946_/Q _5945_/Q VPWR VGND sg13cmos5l_xnor2_1
X_5760__660 _5760_/RESET_B VPWR VGND sg13cmos5l_tiehi
X_4474_ _5935_/D _4649_/A _4491_/B VPWR VGND sg13cmos5l_and2_1
X_3425_ _3425_/Y _5162_/A1 _3418_/B _3424_/Y VPWR VGND sg13cmos5l_o21ai_1
X_5721__699 _5721_/RESET_B VPWR VGND sg13cmos5l_tiehi
X_3356_ _3364_/S _5304_/A _5304_/B _5399_/A _5399_/C VPWR VGND sg13cmos5l_nor4_1
X_3287_ _5601_/D _3374_/A _3287_/A1 _3288_/S VPWR VGND sg13cmos5l_mux2_1
Xhold1103 _3087_/A _5823_/Q VPWR VGND sg13cmos5l_dlygate4sd3_1
X_6075_ _6075_/Q _6080_/CLK _6075_/D _6075_/RESET_B VPWR VGND sg13cmos5l_dfrbpq_1
Xhold1114 _3121_/A _5440_/Q VPWR VGND sg13cmos5l_dlygate4sd3_1
Xhold1125 _5722_/D _3456_/Y VPWR VGND sg13cmos5l_dlygate4sd3_1
Xhold1158 _3629_/B _5834_/Q VPWR VGND sg13cmos5l_dlygate4sd3_1
X_5026_ _5035_/A _6035_/Q _5059_/B VPWR VGND sg13cmos5l_nor2_1
Xhold1136 _4301_/B _5873_/Q VPWR VGND sg13cmos5l_dlygate4sd3_1
Xhold1147 _3847_/A _5847_/Q VPWR VGND sg13cmos5l_dlygate4sd3_1
XFILLER_39_841 VPWR VGND sg13cmos5l_fill_1
X_5617__803 _5617_/RESET_B VPWR VGND sg13cmos5l_tiehi
Xhold1169 _4491_/A _5932_/Q VPWR VGND sg13cmos5l_dlygate4sd3_1
X_5437__913 _5437_/RESET_B VPWR VGND sg13cmos5l_tiehi
XFILLER_26_557 VPWR VGND sg13cmos5l_fill_2
X_5928_ _5928_/Q _6007_/CLK _5928_/D _5928_/RESET_B VPWR VGND sg13cmos5l_dfrbpq_1
XFILLER_41_527 VPWR VGND sg13cmos5l_decap_4
XFILLER_16_1027 VPWR VGND sg13cmos5l_fill_2
X_5859_ _5859_/Q _5906_/CLK _5859_/D _5859_/RESET_B VPWR VGND sg13cmos5l_dfrbpq_1
X_5444__906 _5444_/RESET_B VPWR VGND sg13cmos5l_tiehi
Xhold981 _3420_/A _5706_/Q VPWR VGND sg13cmos5l_dlygate4sd3_1
Xhold970 hold970/X _6074_/Q VPWR VGND sg13cmos5l_dlygate4sd3_1
Xhold992 _3560_/A _5772_/Q VPWR VGND sg13cmos5l_dlygate4sd3_1
XFILLER_48_159 VPWR VGND sg13cmos5l_fill_2
Xhold1670 _4581_/B1 _5921_/Q VPWR VGND sg13cmos5l_dlygate4sd3_1
XFILLER_45_844 VPWR VGND sg13cmos5l_fill_2
Xhold1681 _5037_/A1 _6031_/Q VPWR VGND sg13cmos5l_dlygate4sd3_1
XFILLER_40_560 VPWR VGND sg13cmos5l_fill_1
XFILLER_9_767 VPWR VGND sg13cmos5l_fill_1
XFILLER_5_951 VPWR VGND sg13cmos5l_fill_2
XFILLER_5_44 VPWR VGND sg13cmos5l_fill_1
X_4190_ _5878_/D _4190_/A _4190_/B VPWR VGND sg13cmos5l_and2_1
X_3210_ _5409_/A _5304_/B _5352_/A VPWR VGND sg13cmos5l_nor2b_1
X_3141_ _3141_/Y _5767_/Q VPWR VGND sg13cmos5l_inv_1
X_3072_ _3072_/Y _4665_/A VPWR VGND sg13cmos5l_inv_1
XFILLER_35_321 VPWR VGND sg13cmos5l_fill_1
XFILLER_35_354 VPWR VGND sg13cmos5l_fill_2
XFILLER_39_1005 VPWR VGND sg13cmos5l_fill_2
X_3974_ _3975_/B _5702_/Q _5685_/Q _5668_/Q _5651_/Q _3979_/S _4053_/S1 VPWR VGND
+ sg13cmos5l_mux4_1
X_5713_ _5713_/Q _6056_/CLK _5713_/D _5713_/RESET_B VPWR VGND sg13cmos5l_dfrbpq_1
X_5644_ _5644_/Q _5864_/CLK _5644_/D _5644_/RESET_B VPWR VGND sg13cmos5l_dfrbpq_1
X_5575_ _5575_/Q _5864_/CLK _5575_/D _5575_/RESET_B VPWR VGND sg13cmos5l_dfrbpq_1
X_4526_ _4606_/A _4818_/B _4649_/A VPWR VGND sg13cmos5l_nand2b_1
X_4457_ _5924_/D _4523_/A _4457_/B VPWR VGND sg13cmos5l_nor2_1
X_3408_ _3634_/B _5818_/Q _3408_/B _5816_/Q _5815_/Q VPWR VGND sg13cmos5l_nor4_1
X_4388_ _4388_/Y _4652_/A _4400_/A VPWR VGND sg13cmos5l_nand2_1
X_3339_ _5646_/D _3339_/A0 _5373_/A0 _3346_/S VPWR VGND sg13cmos5l_mux2_1
X_6058_ _6058_/Q _6061_/CLK _6058_/D _6058_/RESET_B VPWR VGND sg13cmos5l_dfrbpq_1
XFILLER_27_811 VPWR VGND sg13cmos5l_fill_1
XFILLER_45_129 VPWR VGND sg13cmos5l_fill_1
X_5009_ _6032_/D _5009_/A _5071_/A VPWR VGND sg13cmos5l_nor2_1
XFILLER_39_693 VPWR VGND sg13cmos5l_fill_2
XFILLER_14_505 VPWR VGND sg13cmos5l_fill_2
XFILLER_26_343 VPWR VGND sg13cmos5l_fill_1
XFILLER_26_376 VPWR VGND sg13cmos5l_fill_1
XFILLER_10_766 VPWR VGND sg13cmos5l_fill_2
X_5843__543 _5843_/RESET_B VPWR VGND sg13cmos5l_tiehi
XFILLER_49_457 VPWR VGND sg13cmos5l_decap_8
X_6013__285 _6013_/D VPWR VGND sg13cmos5l_tielo
XFILLER_17_343 VPWR VGND sg13cmos5l_fill_2
XFILLER_17_354 VPWR VGND sg13cmos5l_decap_8
XFILLER_29_192 VPWR VGND sg13cmos5l_fill_2
XFILLER_45_696 VPWR VGND sg13cmos5l_fill_1
XFILLER_17_365 VPWR VGND sg13cmos5l_fill_2
XFILLER_33_836 VPWR VGND sg13cmos5l_decap_4
X_5750__670 _5750_/RESET_B VPWR VGND sg13cmos5l_tiehi
XFILLER_32_335 VPWR VGND sg13cmos5l_fill_2
XFILLER_41_891 VPWR VGND sg13cmos5l_decap_8
XFILLER_9_520 VPWR VGND sg13cmos5l_fill_1
XFILLER_9_575 VPWR VGND sg13cmos5l_fill_1
X_3690_ _3690_/Y _3745_/A _3142_/Y _3718_/A1 VPWR VGND sg13cmos5l_a21oi_1
X_5360_ _5491_/D _5302_/A _5360_/A1 _5360_/S VPWR VGND sg13cmos5l_mux2_1
X_5607__813 _5607_/RESET_B VPWR VGND sg13cmos5l_tiehi
X_5291_ _6073_/D _5291_/A _5291_/B VPWR VGND sg13cmos5l_and2_1
X_4311_ _5906_/D _4311_/A _4313_/B VPWR VGND sg13cmos5l_and2_1
X_4242_ _4242_/Y _4229_/Y _4250_/B _4244_/B VPWR VGND sg13cmos5l_o21ai_1
X_4173_ _4173_/Y _4173_/A _4173_/B VPWR VGND sg13cmos5l_nand2_1
XFILLER_49_980 VPWR VGND sg13cmos5l_decap_8
X_3124_ _3124_/Y _3124_/A VPWR VGND sg13cmos5l_inv_1
XFILLER_36_630 VPWR VGND sg13cmos5l_decap_4
X_5614__806 _5614_/RESET_B VPWR VGND sg13cmos5l_tiehi
X_5434__916 _5434_/RESET_B VPWR VGND sg13cmos5l_tiehi
X_3957_ _3957_/Y _4089_/B _3115_/Y _4091_/A1 VPWR VGND sg13cmos5l_a21oi_1
X_3888_ _3888_/Y _3881_/Y _3886_/Y _3887_/Y VPWR VGND sg13cmos5l_o21ai_1
X_5627_ _5627_/Q _5864_/CLK _5627_/D _5627_/RESET_B VPWR VGND sg13cmos5l_dfrbpq_1
X_5558_ _5558_/Q _5692_/CLK _5558_/D _5558_/RESET_B VPWR VGND sg13cmos5l_dfrbpq_1
X_4509_ _4510_/C _4509_/A _4509_/B _4509_/C VPWR VGND sg13cmos5l_and3_1
X_5489_ _5489_/Q _5853_/CLK _5489_/D _5489_/RESET_B VPWR VGND sg13cmos5l_dfrbpq_1
X_5441__909 _5441_/RESET_B VPWR VGND sg13cmos5l_tiehi
XFILLER_47_928 VPWR VGND sg13cmos5l_decap_8
Xclkbuf_leaf_38_clk clkload4/A clkbuf_leaf_2_clk/A VPWR VGND sg13cmos5l_buf_8
XFILLER_15_836 VPWR VGND sg13cmos5l_decap_4
XFILLER_15_858 VPWR VGND sg13cmos5l_fill_2
XFILLER_42_688 VPWR VGND sg13cmos5l_fill_2
XFILLER_14_368 VPWR VGND sg13cmos5l_decap_8
XFILLER_23_891 VPWR VGND sg13cmos5l_decap_8
XFILLER_10_552 VPWR VGND sg13cmos5l_fill_1
XFILLER_10_574 VPWR VGND sg13cmos5l_fill_1
XFILLER_37_405 VPWR VGND sg13cmos5l_fill_1
XFILLER_38_928 VPWR VGND sg13cmos5l_fill_2
Xclkbuf_leaf_29_clk _6063_/CLK clkbuf_3_5__f_clk/X VPWR VGND sg13cmos5l_buf_8
XFILLER_46_983 VPWR VGND sg13cmos5l_decap_8
XFILLER_17_162 VPWR VGND sg13cmos5l_fill_1
X_4860_ _4861_/B _5999_/Q _4867_/B _4845_/Y VPWR VGND sg13cmos5l_a21oi_1
X_3811_ _3811_/Y _3162_/B _3809_/Y _3810_/Y VPWR VGND sg13cmos5l_a21oi_1
X_4791_ _4791_/Y _5959_/Q _4791_/B VPWR VGND sg13cmos5l_nor2_1
X_3742_ _3742_/Y _3735_/Y _3737_/Y _3767_/C VPWR VGND sg13cmos5l_o21ai_1
X_3673_ _3673_/Y _3761_/B2 _3669_/Y _3139_/A VPWR VGND sg13cmos5l_o21ai_1
X_5412_ _5537_/D _5412_/A0 _5412_/A1 _5417_/S VPWR VGND sg13cmos5l_mux2_1
X_5343_ _5475_/D _5343_/A0 _5372_/A0 _5351_/S VPWR VGND sg13cmos5l_mux2_1
X_5274_ _5277_/B _5284_/B _5274_/B VPWR VGND sg13cmos5l_nor2_1
X_4225_ _4231_/A _5887_/Q _5888_/Q _5889_/Q VPWR VGND sg13cmos5l_nor3_1
XFILLER_29_928 VPWR VGND sg13cmos5l_decap_8
XFILLER_29_939 VPWR VGND sg13cmos5l_fill_1
X_4156_ _5862_/D _4221_/A _4207_/C VPWR VGND sg13cmos5l_nor2_1
X_3107_ _5177_/A _4978_/B VPWR VGND sg13cmos5l_inv_1
XFILLER_44_909 VPWR VGND sg13cmos5l_fill_1
X_4087_ _4087_/Y _4097_/S _5591_/Q _4098_/A1 VPWR VGND sg13cmos5l_o21ai_1
XFILLER_36_460 VPWR VGND sg13cmos5l_decap_8
XFILLER_37_983 VPWR VGND sg13cmos5l_decap_8
XFILLER_12_828 VPWR VGND sg13cmos5l_fill_2
X_4989_ _4989_/Y _4980_/B _4987_/X _4989_/B1 VPWR VGND sg13cmos5l_a21oi_1
XFILLER_20_883 VPWR VGND sg13cmos5l_fill_2
XFILLER_3_559 VPWR VGND sg13cmos5l_fill_2
X_6038__314 _6038_/RESET_B VPWR VGND sg13cmos5l_tiehi
X_5740__680 _5740_/RESET_B VPWR VGND sg13cmos5l_tiehi
XFILLER_4_1006 VPWR VGND sg13cmos5l_decap_8
XFILLER_28_961 VPWR VGND sg13cmos5l_decap_8
XFILLER_28_972 VPWR VGND sg13cmos5l_fill_1
XFILLER_43_953 VPWR VGND sg13cmos5l_fill_2
XFILLER_43_931 VPWR VGND sg13cmos5l_fill_2
XFILLER_42_463 VPWR VGND sg13cmos5l_decap_8
XFILLER_30_669 VPWR VGND sg13cmos5l_fill_1
XFILLER_7_876 VPWR VGND sg13cmos5l_fill_2
X_5604__816 _5604_/RESET_B VPWR VGND sg13cmos5l_tiehi
XFILLER_42_1012 VPWR VGND sg13cmos5l_decap_8
XFILLER_28_4 VPWR VGND sg13cmos5l_fill_2
X_4010_ _4011_/B _5691_/Q _5674_/Q _5657_/Q _5640_/Q _4029_/S _4031_/A1 VPWR VGND
+ sg13cmos5l_mux4_1
XFILLER_38_703 VPWR VGND sg13cmos5l_fill_1
XFILLER_38_769 VPWR VGND sg13cmos5l_fill_2
XFILLER_46_780 VPWR VGND sg13cmos5l_fill_2
X_5961_ _5961_/Q _6077_/CLK _5961_/D _5961_/RESET_B VPWR VGND sg13cmos5l_dfrbpq_1
XFILLER_25_408 VPWR VGND sg13cmos5l_fill_2
X_4912_ _5201_/B _6037_/Q _6038_/Q _6039_/Q VPWR VGND sg13cmos5l_o21ai_1
XFILLER_18_482 VPWR VGND sg13cmos5l_fill_2
X_5892_ _5892_/Q _5894_/CLK _5892_/D _5892_/RESET_B VPWR VGND sg13cmos5l_dfrbpq_1
X_5611__809 _5611_/RESET_B VPWR VGND sg13cmos5l_tiehi
X_4843_ _4869_/B _4843_/A _4872_/B _4872_/C VPWR VGND sg13cmos5l_nor3_1
X_4774_ _4777_/A _4774_/A _4774_/B VPWR VGND sg13cmos5l_nand2_1
X_3725_ _3725_/Y _5757_/Q _3749_/B VPWR VGND sg13cmos5l_nand2b_1
Xclkbuf_leaf_9_clk _5674_/CLK clkbuf_leaf_9_clk/A VPWR VGND sg13cmos5l_buf_8
X_3656_ _3656_/Y _3720_/A _3656_/B VPWR VGND sg13cmos5l_nor2_1
X_3587_ _3587_/Y _3587_/A _3593_/B VPWR VGND sg13cmos5l_nand2_1
X_5326_ _5460_/D _5326_/A0 _5374_/A0 _5332_/S VPWR VGND sg13cmos5l_mux2_1
X_5257_ _5257_/Y _5246_/A _5248_/A _5256_/Y VPWR VGND sg13cmos5l_o21ai_1
X_5579__848 _5579_/RESET_B VPWR VGND sg13cmos5l_tiehi
X_4208_ _4208_/Y _4208_/A _4208_/B VPWR VGND sg13cmos5l_nand2_1
X_5188_ _5253_/A _6060_/Q _5190_/B VPWR VGND sg13cmos5l_or2_1
XFILLER_29_747 VPWR VGND sg13cmos5l_fill_1
X_4139_ _4139_/Y _5883_/Q _5861_/Q VPWR VGND sg13cmos5l_nand2_1
XFILLER_44_728 VPWR VGND sg13cmos5l_decap_4
XFILLER_19_1014 VPWR VGND sg13cmos5l_decap_8
XFILLER_24_474 VPWR VGND sg13cmos5l_decap_8
XFILLER_40_956 VPWR VGND sg13cmos5l_fill_2
XFILLER_22_53 VPWR VGND sg13cmos5l_fill_2
XFILLER_22_75 VPWR VGND sg13cmos5l_fill_2
X_5480__596 _5480_/RESET_B VPWR VGND sg13cmos5l_tiehi
XFILLER_47_511 VPWR VGND sg13cmos5l_decap_8
Xfanout170 _4024_/A1 _4039_/A1 VPWR VGND sg13cmos5l_buf_1
Xfanout181 _4105_/S _4069_/S0 VPWR VGND sg13cmos5l_buf_1
Xfanout192 _3910_/B _3998_/S0 VPWR VGND sg13cmos5l_buf_1
XFILLER_47_61 VPWR VGND sg13cmos5l_fill_2
XFILLER_47_588 VPWR VGND sg13cmos5l_decap_8
Xclkbuf_3_4__f_clk clkbuf_3_4__f_clk/X clkbuf_0_clk/X VPWR VGND sg13cmos5l_buf_8
XFILLER_15_485 VPWR VGND sg13cmos5l_fill_1
XFILLER_30_433 VPWR VGND sg13cmos5l_fill_2
XFILLER_31_989 VPWR VGND sg13cmos5l_fill_2
X_3510_ _3510_/Y _6048_/Q _3514_/B VPWR VGND sg13cmos5l_nor2_1
XFILLER_8_77 VPWR VGND sg13cmos5l_fill_2
X_4490_ _4509_/B _4505_/A _4505_/B VPWR VGND sg13cmos5l_nand2_1
X_3441_ _5715_/D _3144_/Y _3440_/B _3440_/Y VPWR VGND sg13cmos5l_o21ai_1
X_3372_ _3372_/Y _3372_/A _3374_/B VPWR VGND sg13cmos5l_nor2_1
X_5111_ _5111_/Y _5111_/A _5119_/B VPWR VGND sg13cmos5l_nand2_1
Xhold1307 _5413_/A1 _5538_/Q VPWR VGND sg13cmos5l_dlygate4sd3_1
Xhold1318 _3219_/A0 _5551_/Q VPWR VGND sg13cmos5l_dlygate4sd3_1
X_5042_ _5042_/X _5042_/A _5042_/B VPWR VGND sg13cmos5l_xor2_1
Xhold1329 _3325_/A0 _5635_/Q VPWR VGND sg13cmos5l_dlygate4sd3_1
Xheichips26_dna_sequencer_278 uo_out[7] VPWR VGND sg13cmos5l_tielo
Xheichips26_dna_sequencer_267 uio_oe[6] VPWR VGND sg13cmos5l_tielo
XFILLER_26_739 VPWR VGND sg13cmos5l_fill_2
X_5944_ _5944_/Q _5994_/CLK _5944_/D _5944_/RESET_B VPWR VGND sg13cmos5l_dfrbpq_1
X_6028__324 _6028_/RESET_B VPWR VGND sg13cmos5l_tiehi
X_5875_ _5875_/Q _5906_/CLK _5875_/D _5875_/RESET_B VPWR VGND sg13cmos5l_dfrbpq_1
XFILLER_34_794 VPWR VGND sg13cmos5l_fill_1
X_5730__690 _5730_/RESET_B VPWR VGND sg13cmos5l_tiehi
X_4826_ _5997_/D _4827_/A _4826_/B VPWR VGND sg13cmos5l_and2_1
X_4757_ _4757_/Y _4757_/A _4757_/B VPWR VGND sg13cmos5l_nor2_1
X_3708_ _3708_/X _5798_/Q _5792_/Q _3734_/S VPWR VGND sg13cmos5l_mux2_1
X_4688_ _4688_/X _4688_/A _4688_/B _4688_/C VPWR VGND sg13cmos5l_or3_1
X_3639_ _5425_/B _3642_/B _5424_/C VPWR VGND sg13cmos5l_xnor2_1
X_5309_ _5445_/D _5414_/A0 _5309_/A1 _5313_/S VPWR VGND sg13cmos5l_mux2_1
XFILLER_49_809 VPWR VGND sg13cmos5l_fill_1
X_6035__317 _6035_/RESET_B VPWR VGND sg13cmos5l_tiehi
XFILLER_1_1009 VPWR VGND sg13cmos5l_decap_8
XFILLER_17_20 VPWR VGND sg13cmos5l_fill_2
XFILLER_9_905 VPWR VGND sg13cmos5l_decap_8
X_5601__819 _5601_/RESET_B VPWR VGND sg13cmos5l_tiehi
XFILLER_47_374 VPWR VGND sg13cmos5l_fill_2
XFILLER_47_385 VPWR VGND sg13cmos5l_decap_8
XFILLER_35_525 VPWR VGND sg13cmos5l_fill_1
X_3990_ _4124_/B _3888_/Y _3926_/Y _3989_/Y _3621_/A VPWR VGND sg13cmos5l_a22oi_1
XFILLER_15_260 VPWR VGND sg13cmos5l_fill_2
X_5660_ _5660_/Q _5864_/CLK _5660_/D _5660_/RESET_B VPWR VGND sg13cmos5l_dfrbpq_1
X_4611_ _4611_/Y _5976_/Q _4463_/A _5927_/Q _4831_/A VPWR VGND sg13cmos5l_a22oi_1
X_5591_ _5591_/Q clkload5/A _5591_/D _5591_/RESET_B VPWR VGND sg13cmos5l_dfrbpq_1
X_5569__858 _5569_/RESET_B VPWR VGND sg13cmos5l_tiehi
XFILLER_8_971 VPWR VGND sg13cmos5l_fill_1
XFILLER_8_960 VPWR VGND sg13cmos5l_decap_8
X_4542_ _4546_/B _4541_/Y _4561_/A VPWR VGND sg13cmos5l_nand2b_1
X_4473_ _5934_/D _4649_/A _4473_/B VPWR VGND sg13cmos5l_and2_1
X_3424_ _3424_/Y _3424_/A _3427_/B VPWR VGND sg13cmos5l_nand2_1
X_3355_ _5661_/D _5417_/A0 _3355_/A1 _3355_/S VPWR VGND sg13cmos5l_mux2_1
X_3286_ _5600_/D _3251_/A _3286_/A1 _3288_/S VPWR VGND sg13cmos5l_mux2_1
Xhold1104 _5808_/D _3646_/Y VPWR VGND sg13cmos5l_dlygate4sd3_1
X_6074_ _6074_/Q _6074_/CLK _6074_/D _6074_/RESET_B VPWR VGND sg13cmos5l_dfrbpq_1
Xhold1115 _5440_/D _5303_/Y VPWR VGND sg13cmos5l_dlygate4sd3_1
Xhold1137 _3782_/A _5817_/Q VPWR VGND sg13cmos5l_dlygate4sd3_1
X_5025_ _5042_/B _5023_/Y _5024_/Y _5022_/Y VPWR VGND sg13cmos5l_a21oi_1
Xhold1126 _3124_/A _5550_/Q VPWR VGND sg13cmos5l_dlygate4sd3_1
Xhold1148 _4129_/A2 _3853_/Y VPWR VGND sg13cmos5l_dlygate4sd3_1
Xhold1159 _5431_/A2 _3630_/B VPWR VGND sg13cmos5l_dlygate4sd3_1
XFILLER_38_363 VPWR VGND sg13cmos5l_decap_4
X_5927_ _5927_/Q _5973_/CLK _5927_/D _5927_/RESET_B VPWR VGND sg13cmos5l_dfrbpq_1
X_5858_ _5858_/Q _5860_/CLK _5858_/D _5858_/RESET_B VPWR VGND sg13cmos5l_dfrbpq_1
XFILLER_6_919 VPWR VGND sg13cmos5l_fill_2
X_5789_ _5789_/Q _5822_/CLK _5789_/D _5789_/RESET_B VPWR VGND sg13cmos5l_dfrbpq_1
X_4809_ _4809_/Y _4808_/Y _4809_/B VPWR VGND sg13cmos5l_nand2b_1
Xhold982 _3422_/A _5707_/Q VPWR VGND sg13cmos5l_dlygate4sd3_1
Xhold971 _3193_/B _3192_/Y VPWR VGND sg13cmos5l_dlygate4sd3_1
Xhold960 _3159_/C _6073_/Q VPWR VGND sg13cmos5l_dlygate4sd3_1
X_5876__501 _5876_/RESET_B VPWR VGND sg13cmos5l_tiehi
Xhold993 _3577_/A _5780_/Q VPWR VGND sg13cmos5l_dlygate4sd3_1
XFILLER_49_628 VPWR VGND sg13cmos5l_decap_8
Xhold1660 _3105_/A _6037_/Q VPWR VGND sg13cmos5l_dlygate4sd3_1
Xhold1671 _5199_/A _6058_/Q VPWR VGND sg13cmos5l_dlygate4sd3_1
Xheichips26_dna_sequencer uio_oe[0] VPWR VGND sg13cmos5l_tielo
XFILLER_45_823 VPWR VGND sg13cmos5l_decap_8
XFILLER_44_399 VPWR VGND sg13cmos5l_fill_1
XFILLER_40_594 VPWR VGND sg13cmos5l_decap_8
X_3140_ _3140_/Y _3140_/A VPWR VGND sg13cmos5l_inv_1
XFILLER_10_4 VPWR VGND sg13cmos5l_fill_1
X_3071_ _5134_/B _3071_/A VPWR VGND sg13cmos5l_inv_1
XFILLER_48_683 VPWR VGND sg13cmos5l_decap_4
XFILLER_36_834 VPWR VGND sg13cmos5l_fill_2
XFILLER_36_878 VPWR VGND sg13cmos5l_fill_2
XFILLER_39_1017 VPWR VGND sg13cmos5l_decap_8
XFILLER_39_1028 VPWR VGND sg13cmos5l_fill_1
X_3973_ _3973_/Y _4098_/A1 _3970_/Y _3972_/Y VPWR VGND sg13cmos5l_o21ai_1
X_5712_ _5712_/Q _6077_/CLK _5712_/D _5712_/RESET_B VPWR VGND sg13cmos5l_dfrbpq_1
X_5643_ _5643_/Q _5864_/CLK _5643_/D _5643_/RESET_B VPWR VGND sg13cmos5l_dfrbpq_1
X_5574_ _5574_/Q _5692_/CLK _5574_/D _5574_/RESET_B VPWR VGND sg13cmos5l_dfrbpq_1
X_4525_ _4655_/B _5278_/A _4818_/B VPWR VGND sg13cmos5l_nor2_1
X_4456_ _4456_/Y _4456_/A1 _4458_/B _4455_/Y VPWR VGND sg13cmos5l_o21ai_1
X_4387_ _5914_/D _4475_/B _4387_/B VPWR VGND sg13cmos5l_and2_1
X_3407_ _5704_/D _3407_/A0 _3407_/A1 _3407_/S VPWR VGND sg13cmos5l_mux2_1
X_3338_ _5645_/D _3338_/A0 _5372_/A0 _3346_/S VPWR VGND sg13cmos5l_mux2_1
X_6057_ _6057_/Q _6061_/CLK _6057_/D _6057_/RESET_B VPWR VGND sg13cmos5l_dfrbpq_1
XFILLER_22_1021 VPWR VGND sg13cmos5l_decap_8
X_3269_ _5399_/C _5371_/B _5371_/A VPWR VGND sg13cmos5l_nand2b_1
X_5008_ _6031_/D _5008_/A _5011_/B VPWR VGND sg13cmos5l_and2_1
XFILLER_42_848 VPWR VGND sg13cmos5l_fill_2
XFILLER_42_859 VPWR VGND sg13cmos5l_fill_2
X_5450__900 _5450_/RESET_B VPWR VGND sg13cmos5l_tiehi
XFILLER_14_65 VPWR VGND sg13cmos5l_fill_1
XFILLER_2_911 VPWR VGND sg13cmos5l_fill_2
XFILLER_2_999 VPWR VGND sg13cmos5l_decap_8
XFILLER_49_436 VPWR VGND sg13cmos5l_decap_8
XFILLER_39_73 VPWR VGND sg13cmos5l_fill_2
X_5559__868 _5559_/RESET_B VPWR VGND sg13cmos5l_tiehi
X_6052__280 _6052_/D VPWR VGND sg13cmos5l_tielo
Xhold1490 _4796_/A _6006_/Q VPWR VGND sg13cmos5l_dlygate4sd3_1
XFILLER_45_686 VPWR VGND sg13cmos5l_decap_4
XFILLER_33_815 VPWR VGND sg13cmos5l_fill_1
XFILLER_41_881 VPWR VGND sg13cmos5l_fill_1
X_5290_ _5291_/B _3157_/Y _5290_/B _5290_/C VPWR VGND sg13cmos5l_nand3b_1
X_4310_ _5905_/D _4358_/B _4315_/B VPWR VGND sg13cmos5l_and2_1
X_4241_ _4244_/B _5913_/Q _4241_/B VPWR VGND sg13cmos5l_xnor2_1
XFILLER_45_1021 VPWR VGND sg13cmos5l_decap_8
X_4172_ _4173_/B _4283_/B _4171_/A _4168_/X VPWR VGND sg13cmos5l_a21oi_1
X_3123_ _3123_/Y _3123_/A VPWR VGND sg13cmos5l_inv_1
XFILLER_27_119 VPWR VGND sg13cmos5l_fill_1
XFILLER_35_174 VPWR VGND sg13cmos5l_fill_1
XFILLER_36_686 VPWR VGND sg13cmos5l_fill_2
XFILLER_24_859 VPWR VGND sg13cmos5l_fill_1
X_3956_ _3956_/Y _4071_/A _3950_/X _3931_/A VPWR VGND sg13cmos5l_o21ai_1
X_3887_ _3887_/Y _5842_/Q _3887_/B VPWR VGND sg13cmos5l_nor2_1
X_5626_ _5626_/Q _5864_/CLK _5626_/D _5626_/RESET_B VPWR VGND sg13cmos5l_dfrbpq_1
X_5557_ _5557_/Q _5692_/CLK _5557_/D _5557_/RESET_B VPWR VGND sg13cmos5l_dfrbpq_1
X_4508_ _4512_/A _4403_/B _4480_/C _4398_/Y VPWR VGND sg13cmos5l_a21oi_1
XFILLER_2_207 VPWR VGND sg13cmos5l_fill_1
X_5488_ _5488_/Q clkload6/A _5488_/D _5488_/RESET_B VPWR VGND sg13cmos5l_dfrbpq_1
X_4439_ _4441_/B _4439_/A1 _4445_/C _4438_/Y VPWR VGND sg13cmos5l_o21ai_1
XFILLER_47_907 VPWR VGND sg13cmos5l_decap_8
XFILLER_26_174 VPWR VGND sg13cmos5l_fill_1
XFILLER_26_196 VPWR VGND sg13cmos5l_fill_1
XFILLER_30_807 VPWR VGND sg13cmos5l_fill_1
XFILLER_10_520 VPWR VGND sg13cmos5l_fill_1
XFILLER_49_277 VPWR VGND sg13cmos5l_fill_1
XFILLER_46_962 VPWR VGND sg13cmos5l_decap_8
XFILLER_45_494 VPWR VGND sg13cmos5l_decap_8
X_3810_ _3810_/Y _3162_/B _3809_/Y _3220_/C VPWR VGND sg13cmos5l_o21ai_1
X_5490__576 _5490_/RESET_B VPWR VGND sg13cmos5l_tiehi
X_4790_ _4800_/B _6007_/Q _3149_/Y _4789_/Y VPWR VGND sg13cmos5l_o21ai_1
X_3741_ _3741_/Y _3138_/Y _3739_/X _3740_/Y VPWR VGND sg13cmos5l_a21oi_1
XFILLER_32_188 VPWR VGND sg13cmos5l_fill_2
X_3672_ _3672_/Y _3137_/Y _3140_/Y _3760_/A1 VPWR VGND sg13cmos5l_a21oi_1
X_5411_ _5536_/D _5411_/A0 _5411_/A1 _5417_/S VPWR VGND sg13cmos5l_mux2_1
X_6078__843 _6078_/RESET_B VPWR VGND sg13cmos5l_tiehi
X_5342_ _5350_/S _5361_/C _5342_/B _5361_/D VPWR VGND sg13cmos5l_nor3_1
X_5273_ _6066_/D _5251_/A _5273_/A2 _5266_/A VPWR VGND sg13cmos5l_a21oi_1
X_5620__800 _5620_/RESET_B VPWR VGND sg13cmos5l_tiehi
X_5440__910 _5440_/RESET_B VPWR VGND sg13cmos5l_tiehi
X_4224_ _4298_/A _4465_/B _4818_/A VPWR VGND sg13cmos5l_nand2b_1
X_4155_ _4207_/C _4153_/B _4154_/X _4153_/Y VPWR VGND sg13cmos5l_a21oi_1
X_3106_ _5175_/A _4975_/A VPWR VGND sg13cmos5l_inv_1
X_4086_ _4086_/Y _4086_/A1 _4085_/X _4067_/A VPWR VGND sg13cmos5l_a21oi_1
X_4988_ _4988_/Y _3071_/A _4987_/X _5011_/B VPWR VGND sg13cmos5l_o21ai_1
X_3939_ _3939_/Y _4071_/A _3939_/B VPWR VGND sg13cmos5l_nor2_1
X_5609_ _5609_/Q _5864_/CLK _5609_/D _5609_/RESET_B VPWR VGND sg13cmos5l_dfrbpq_1
XFILLER_47_737 VPWR VGND sg13cmos5l_decap_4
X_5812__605 _5812_/RESET_B VPWR VGND sg13cmos5l_tiehi
X_5515__502 _5515_/RESET_B VPWR VGND sg13cmos5l_tiehi
XFILLER_27_483 VPWR VGND sg13cmos5l_fill_2
XFILLER_42_442 VPWR VGND sg13cmos5l_decap_8
XFILLER_14_177 VPWR VGND sg13cmos5l_fill_1
XFILLER_30_626 VPWR VGND sg13cmos5l_fill_2
XFILLER_10_361 VPWR VGND sg13cmos5l_decap_4
XFILLER_7_811 VPWR VGND sg13cmos5l_fill_1
XFILLER_10_372 VPWR VGND sg13cmos5l_decap_4
XFILLER_6_332 VPWR VGND sg13cmos5l_fill_2
XFILLER_7_899 VPWR VGND sg13cmos5l_decap_8
X_5960_ _5960_/Q _6077_/CLK _5960_/D _5960_/RESET_B VPWR VGND sg13cmos5l_dfrbpq_1
X_5891_ _5891_/Q _5943_/CLK _5891_/D _5891_/RESET_B VPWR VGND sg13cmos5l_dfrbpq_1
X_4911_ _4918_/B _6037_/Q _6038_/Q _6039_/Q VPWR VGND sg13cmos5l_nor3_1
XFILLER_33_464 VPWR VGND sg13cmos5l_fill_2
X_4842_ _4869_/A _4864_/B _4864_/C _4737_/Y VPWR VGND sg13cmos5l_a21oi_1
X_4773_ _5982_/D _4829_/B _4843_/A VPWR VGND sg13cmos5l_and2_1
X_3724_ _3724_/Y _3724_/A _3724_/B VPWR VGND sg13cmos5l_nand2_1
X_3655_ _3656_/B _3761_/B2 _3649_/X _3654_/Y VPWR VGND sg13cmos5l_a21oi_1
X_3586_ _5784_/D _3611_/A1 _3593_/B _3585_/Y VPWR VGND sg13cmos5l_o21ai_1
X_5325_ _5459_/D _5325_/A0 _5373_/A0 _5332_/S VPWR VGND sg13cmos5l_mux2_1
X_5256_ _5256_/Y _5258_/A _5270_/B VPWR VGND sg13cmos5l_nand2_1
X_4207_ _4208_/B _4207_/A _4207_/B _4207_/C _4207_/D VPWR VGND sg13cmos5l_nand4_1
X_5187_ _5254_/A _6059_/Q _5190_/B _5245_/A VPWR VGND sg13cmos5l_a21o_1
X_4138_ _4138_/Y _4138_/A VPWR VGND sg13cmos5l_inv_1
XFILLER_43_206 VPWR VGND sg13cmos5l_fill_2
X_4069_ _4069_/X _5495_/Q _5478_/Q _5461_/Q _5444_/Q _4069_/S0 _4107_/B1 VPWR VGND
+ sg13cmos5l_mux4_1
XFILLER_24_420 VPWR VGND sg13cmos5l_fill_1
XFILLER_24_453 VPWR VGND sg13cmos5l_decap_8
XFILLER_40_935 VPWR VGND sg13cmos5l_fill_2
XFILLER_40_946 VPWR VGND sg13cmos5l_fill_2
XFILLER_4_836 VPWR VGND sg13cmos5l_fill_1
Xfanout171 _4040_/S1 _4039_/A1 VPWR VGND sg13cmos5l_buf_1
Xfanout160 _4086_/A1 fanout162/X VPWR VGND sg13cmos5l_buf_1
Xfanout182 _4109_/B _4079_/S VPWR VGND sg13cmos5l_buf_1
Xfanout193 _4036_/B _3998_/S0 VPWR VGND sg13cmos5l_buf_1
XFILLER_47_567 VPWR VGND sg13cmos5l_decap_8
XFILLER_34_228 VPWR VGND sg13cmos5l_fill_2
XFILLER_43_751 VPWR VGND sg13cmos5l_decap_8
XFILLER_43_795 VPWR VGND sg13cmos5l_fill_1
XFILLER_31_935 VPWR VGND sg13cmos5l_fill_2
X_5610__810 _5610_/RESET_B VPWR VGND sg13cmos5l_tiehi
X_3440_ _3440_/Y _3440_/A _3440_/B VPWR VGND sg13cmos5l_nand2_1
X_3371_ _5675_/D _3394_/A0 _3371_/A1 _3374_/B VPWR VGND sg13cmos5l_mux2_1
X_5110_ _5110_/Y _5138_/B _5110_/B VPWR VGND sg13cmos5l_nor2_1
X_5041_ _5041_/Y _5051_/A _5051_/B VPWR VGND sg13cmos5l_nand2_1
Xhold1319 _5325_/A0 _5459_/Q VPWR VGND sg13cmos5l_dlygate4sd3_1
Xhold1308 _5403_/A0 _5529_/Q VPWR VGND sg13cmos5l_dlygate4sd3_1
X_5719__701 _5719_/RESET_B VPWR VGND sg13cmos5l_tiehi
Xheichips26_dna_sequencer_268 uio_oe[7] VPWR VGND sg13cmos5l_tielo
XFILLER_38_534 VPWR VGND sg13cmos5l_fill_2
X_5943_ _5943_/Q _5943_/CLK _5943_/D _5943_/RESET_B VPWR VGND sg13cmos5l_dfrbpq_1
XFILLER_18_291 VPWR VGND sg13cmos5l_fill_2
X_5874_ _5874_/Q _6080_/CLK _5874_/D _5874_/RESET_B VPWR VGND sg13cmos5l_dfrbpq_1
X_4825_ _5996_/D _5007_/A _4825_/B VPWR VGND sg13cmos5l_and2_1
XFILLER_33_294 VPWR VGND sg13cmos5l_fill_2
XFILLER_21_478 VPWR VGND sg13cmos5l_decap_8
X_4756_ _4757_/B _5953_/Q _4759_/B VPWR VGND sg13cmos5l_xor2_1
X_3707_ _3707_/X _5786_/Q _5780_/Q _3734_/S VPWR VGND sg13cmos5l_mux2_1
X_4687_ _4688_/C _4687_/A _4687_/B _4687_/C VPWR VGND sg13cmos5l_and3_1
XFILLER_49_1008 VPWR VGND sg13cmos5l_decap_8
X_3638_ _5805_/D _5429_/A _5424_/B _5424_/C VPWR VGND sg13cmos5l_nor3_1
X_3569_ _3607_/B _3569_/A _3569_/B _4131_/A VPWR VGND sg13cmos5l_nor3_1
X_5308_ _5444_/D _5413_/A0 _5308_/A1 _5313_/S VPWR VGND sg13cmos5l_mux2_1
X_5239_ _5249_/C _5241_/B _5241_/C _5114_/B VPWR VGND sg13cmos5l_a21oi_1
XFILLER_44_559 VPWR VGND sg13cmos5l_fill_1
X_5512__527 _5512_/RESET_B VPWR VGND sg13cmos5l_tiehi
XFILLER_40_732 VPWR VGND sg13cmos5l_fill_1
XFILLER_0_872 VPWR VGND sg13cmos5l_decap_4
XFILLER_43_592 VPWR VGND sg13cmos5l_fill_2
XFILLER_15_272 VPWR VGND sg13cmos5l_fill_1
X_4610_ _4610_/Y _4830_/A _5926_/Q _4609_/Y VPWR VGND sg13cmos5l_o21ai_1
XFILLER_8_950 VPWR VGND sg13cmos5l_fill_1
X_5590_ _5590_/Q clkload5/A _5590_/D _5590_/RESET_B VPWR VGND sg13cmos5l_dfrbpq_1
X_4541_ _4541_/Y _5945_/Q _5972_/Q VPWR VGND sg13cmos5l_nand2_1
X_4472_ _5933_/D _4998_/A _4472_/B VPWR VGND sg13cmos5l_and2_1
X_3423_ _5707_/D _3501_/A1 _3427_/B _3422_/Y VPWR VGND sg13cmos5l_o21ai_1
X_3354_ _5660_/D _3374_/A _3354_/A1 _3355_/S VPWR VGND sg13cmos5l_mux2_1
X_3285_ _5599_/D _5357_/A0 _3285_/A1 _3288_/S VPWR VGND sg13cmos5l_mux2_1
X_6053__941 _6053_/RESET_B VPWR VGND sg13cmos5l_tiehi
X_6073_ _6073_/Q _6074_/CLK _6073_/D _6073_/RESET_B VPWR VGND sg13cmos5l_dfrbpq_1
Xhold1105 _4125_/A _5853_/Q VPWR VGND sg13cmos5l_dlygate4sd3_1
Xhold1138 _5817_/D _3780_/Y VPWR VGND sg13cmos5l_dlygate4sd3_1
Xhold1127 _3538_/A _5761_/Q VPWR VGND sg13cmos5l_dlygate4sd3_1
Xhold1116 _5166_/B _6024_/Q VPWR VGND sg13cmos5l_dlygate4sd3_1
X_5024_ _5024_/Y _6026_/Q _5997_/Q VPWR VGND sg13cmos5l_xnor2_1
Xhold1149 _5845_/D _3855_/Y VPWR VGND sg13cmos5l_dlygate4sd3_1
XFILLER_26_526 VPWR VGND sg13cmos5l_fill_2
XFILLER_26_559 VPWR VGND sg13cmos5l_fill_1
X_5926_ _5926_/Q _5973_/CLK _5926_/D _5926_/RESET_B VPWR VGND sg13cmos5l_dfrbpq_1
XFILLER_10_927 VPWR VGND sg13cmos5l_fill_2
X_5857_ _5857_/Q _5906_/CLK _5857_/D _5857_/RESET_B VPWR VGND sg13cmos5l_dfrbpq_1
X_5788_ _5788_/Q _5822_/CLK _5788_/D _5788_/RESET_B VPWR VGND sg13cmos5l_dfrbpq_1
XFILLER_10_949 VPWR VGND sg13cmos5l_fill_2
X_4808_ _4808_/Y _4816_/B _4805_/Y _4816_/A VPWR VGND sg13cmos5l_o21ai_1
X_4739_ _4781_/A _4998_/B _5007_/A VPWR VGND sg13cmos5l_nand2b_1
Xhold961 _6075_/D _3159_/Y VPWR VGND sg13cmos5l_dlygate4sd3_1
Xhold972 _4650_/B _5935_/Q VPWR VGND sg13cmos5l_dlygate4sd3_1
Xhold994 _5780_/D _3578_/Y VPWR VGND sg13cmos5l_dlygate4sd3_1
Xhold983 _4308_/B _5877_/Q VPWR VGND sg13cmos5l_dlygate4sd3_1
X_5600__820 _5600_/RESET_B VPWR VGND sg13cmos5l_tiehi
XFILLER_0_179 VPWR VGND sg13cmos5l_fill_1
Xhold1661 _4407_/B _5892_/Q VPWR VGND sg13cmos5l_dlygate4sd3_1
XFILLER_17_504 VPWR VGND sg13cmos5l_fill_1
Xhold1650 _4685_/A _5967_/Q VPWR VGND sg13cmos5l_dlygate4sd3_1
Xhold1672 _4254_/B1 _5867_/Q VPWR VGND sg13cmos5l_dlygate4sd3_1
XFILLER_45_879 VPWR VGND sg13cmos5l_fill_2
XFILLER_45_868 VPWR VGND sg13cmos5l_decap_8
XFILLER_44_389 VPWR VGND sg13cmos5l_fill_1
XFILLER_44_41 VPWR VGND sg13cmos5l_fill_2
XFILLER_40_540 VPWR VGND sg13cmos5l_fill_2
X_5709__711 _5709_/RESET_B VPWR VGND sg13cmos5l_tiehi
X_5820__589 _5820_/RESET_B VPWR VGND sg13cmos5l_tiehi
X_3070_ _3070_/Y _6020_/Q VPWR VGND sg13cmos5l_inv_1
X_5716__704 _5716_/RESET_B VPWR VGND sg13cmos5l_tiehi
X_5575__852 _5575_/RESET_B VPWR VGND sg13cmos5l_tiehi
XFILLER_47_183 VPWR VGND sg13cmos5l_fill_2
XFILLER_35_356 VPWR VGND sg13cmos5l_fill_1
X_3972_ _3972_/Y _4098_/A1 _3971_/X _4009_/A VPWR VGND sg13cmos5l_a21oi_1
X_5711_ _5711_/Q _6074_/CLK _5711_/D _5711_/RESET_B VPWR VGND sg13cmos5l_dfrbpq_1
X_5642_ _5642_/Q _5695_/CLK _5642_/D _5642_/RESET_B VPWR VGND sg13cmos5l_dfrbpq_1
X_5573_ _5573_/Q _5695_/CLK _5573_/D _5573_/RESET_B VPWR VGND sg13cmos5l_dfrbpq_1
X_4524_ _5943_/D _4403_/B _4524_/A2 _4523_/A VPWR VGND sg13cmos5l_a21oi_1
XFILLER_8_780 VPWR VGND sg13cmos5l_fill_1
X_5582__845 _5582_/RESET_B VPWR VGND sg13cmos5l_tiehi
X_4455_ _4455_/Y _4455_/A _4458_/B VPWR VGND sg13cmos5l_nand2_1
X_4386_ _4387_/B _4362_/Y _4395_/A _4385_/Y VPWR VGND sg13cmos5l_o21ai_1
X_3406_ _5703_/D _5398_/A0 _3406_/A1 _3406_/S VPWR VGND sg13cmos5l_mux2_1
X_3337_ _3345_/S _5304_/A _5304_/B _5399_/A _5380_/C VPWR VGND sg13cmos5l_nor4_1
X_6056_ _6056_/Q _6056_/CLK _6056_/D _6056_/RESET_B VPWR VGND sg13cmos5l_dfrbpq_1
X_3268_ _5390_/C _3824_/B _3824_/A VPWR VGND sg13cmos5l_nor2b_1
XFILLER_39_651 VPWR VGND sg13cmos5l_fill_2
X_5007_ _6030_/D _5007_/A _5007_/B VPWR VGND sg13cmos5l_and2_1
X_3199_ _5277_/A _3199_/A hold1605/X VPWR VGND sg13cmos5l_nor2b_1
XFILLER_26_301 VPWR VGND sg13cmos5l_decap_8
XFILLER_39_695 VPWR VGND sg13cmos5l_fill_1
X_5909_ _5909_/Q _5936_/CLK _5909_/D _5909_/RESET_B VPWR VGND sg13cmos5l_dfrbpq_1
XFILLER_30_65 VPWR VGND sg13cmos5l_fill_1
XFILLER_49_415 VPWR VGND sg13cmos5l_decap_8
XFILLER_2_978 VPWR VGND sg13cmos5l_decap_8
XFILLER_18_824 VPWR VGND sg13cmos5l_fill_2
Xhold1491 _3064_/A _6052_/Q VPWR VGND sg13cmos5l_dlygate4sd3_1
XFILLER_17_345 VPWR VGND sg13cmos5l_fill_1
Xhold1480 _6027_/D _5004_/Y VPWR VGND sg13cmos5l_dlygate4sd3_1
XFILLER_45_665 VPWR VGND sg13cmos5l_fill_1
XFILLER_32_337 VPWR VGND sg13cmos5l_fill_1
XFILLER_13_551 VPWR VGND sg13cmos5l_fill_2
XFILLER_13_562 VPWR VGND sg13cmos5l_fill_2
XFILLER_13_595 VPWR VGND sg13cmos5l_fill_1
XFILLER_9_566 VPWR VGND sg13cmos5l_fill_1
X_5959__407 _5959_/RESET_B VPWR VGND sg13cmos5l_tiehi
XFILLER_45_1000 VPWR VGND sg13cmos5l_decap_8
X_4240_ _4247_/B _4478_/A _4241_/B VPWR VGND sg13cmos5l_xnor2_1
X_4171_ _4171_/Y _4171_/A VPWR VGND sg13cmos5l_inv_1
X_3122_ _3122_/Y _3122_/A VPWR VGND sg13cmos5l_inv_1
XFILLER_48_481 VPWR VGND sg13cmos5l_decap_8
X_6031__321 _6031_/RESET_B VPWR VGND sg13cmos5l_tiehi
X_3955_ _3955_/Y _4111_/A1 _3953_/X _3954_/Y VPWR VGND sg13cmos5l_a21oi_1
X_3886_ _3886_/Y _3884_/Y _3885_/Y _4003_/A VPWR VGND sg13cmos5l_o21ai_1
X_5625_ _5625_/Q _5692_/CLK _5625_/D _5625_/RESET_B VPWR VGND sg13cmos5l_dfrbpq_1
X_5556_ _5556_/Q _5559_/CLK _5556_/D _5556_/RESET_B VPWR VGND sg13cmos5l_dfrbpq_1
X_4507_ _4507_/X _4507_/A _4507_/B VPWR VGND sg13cmos5l_and2_1
X_5487_ _5487_/Q _5840_/CLK _5487_/D _5487_/RESET_B VPWR VGND sg13cmos5l_dfrbpq_1
X_4438_ _4438_/Y _5944_/Q _4445_/C _4438_/C VPWR VGND sg13cmos5l_nand3b_1
X_4369_ _4369_/Y _5940_/Q _5914_/Q VPWR VGND sg13cmos5l_nand2_1
XFILLER_46_429 VPWR VGND sg13cmos5l_decap_8
X_6039_ _6039_/Q _6061_/CLK _6039_/D _6039_/RESET_B VPWR VGND sg13cmos5l_dfrbpq_1
XFILLER_27_654 VPWR VGND sg13cmos5l_fill_1
XFILLER_25_43 VPWR VGND sg13cmos5l_fill_1
XFILLER_25_54 VPWR VGND sg13cmos5l_fill_2
XFILLER_26_186 VPWR VGND sg13cmos5l_fill_1
X_5706__714 _5706_/RESET_B VPWR VGND sg13cmos5l_tiehi
X_5565__862 _5565_/RESET_B VPWR VGND sg13cmos5l_tiehi
XFILLER_9_0 VPWR VGND sg13cmos5l_fill_2
XFILLER_2_58 VPWR VGND sg13cmos5l_fill_2
XFILLER_46_941 VPWR VGND sg13cmos5l_decap_8
X_5819__591 _5819_/RESET_B VPWR VGND sg13cmos5l_tiehi
XFILLER_45_473 VPWR VGND sg13cmos5l_decap_8
X_5713__707 _5713_/RESET_B VPWR VGND sg13cmos5l_tiehi
X_5572__855 _5572_/RESET_B VPWR VGND sg13cmos5l_tiehi
X_3740_ _3740_/Y _3730_/Y _3738_/Y _3139_/A VPWR VGND sg13cmos5l_o21ai_1
XFILLER_14_882 VPWR VGND sg13cmos5l_decap_8
X_3671_ _3671_/Y _5742_/Q _3753_/B VPWR VGND sg13cmos5l_nand2b_1
X_5410_ _5535_/D _5410_/A0 _5410_/A1 _5417_/S VPWR VGND sg13cmos5l_mux2_1
X_5341_ _5474_/D _5341_/A0 _5302_/A _5341_/S VPWR VGND sg13cmos5l_mux2_1
X_5544__946 _5544_/RESET_B VPWR VGND sg13cmos5l_tiehi
X_5272_ _6065_/D _5272_/A _5272_/B _5272_/C VPWR VGND sg13cmos5l_nor3_1
X_4223_ _4313_/B _5278_/A _4465_/B VPWR VGND sg13cmos5l_nor2_1
XFILLER_29_908 VPWR VGND sg13cmos5l_fill_1
X_4154_ _4154_/X _4312_/A _4265_/A VPWR VGND sg13cmos5l_and2_1
X_3105_ _5174_/A _3105_/A VPWR VGND sg13cmos5l_inv_1
X_4085_ _4085_/X _5667_/Q _5650_/Q _4085_/S VPWR VGND sg13cmos5l_mux2_1
XFILLER_37_952 VPWR VGND sg13cmos5l_decap_8
XFILLER_36_495 VPWR VGND sg13cmos5l_decap_8
X_4987_ _4987_/X _6023_/Q _4987_/B _4987_/C VPWR VGND sg13cmos5l_or3_1
XFILLER_23_167 VPWR VGND sg13cmos5l_fill_2
X_3938_ _3939_/B _5562_/Q _5545_/Q _5528_/Q _5511_/Q _3172_/S _4076_/S1 VPWR VGND
+ sg13cmos5l_mux4_1
XFILLER_20_852 VPWR VGND sg13cmos5l_fill_1
XFILLER_32_690 VPWR VGND sg13cmos5l_decap_4
X_3869_ _3870_/C _3880_/A _3869_/B VPWR VGND sg13cmos5l_nor2_1
X_5608_ _5608_/Q _5695_/CLK _5608_/D _5608_/RESET_B VPWR VGND sg13cmos5l_dfrbpq_1
X_5539_ _5539_/Q _5559_/CLK _5539_/D _5539_/RESET_B VPWR VGND sg13cmos5l_dfrbpq_1
XFILLER_28_941 VPWR VGND sg13cmos5l_decap_4
X_5949__417 _5949_/RESET_B VPWR VGND sg13cmos5l_tiehi
XFILLER_43_966 VPWR VGND sg13cmos5l_decap_4
XFILLER_42_498 VPWR VGND sg13cmos5l_decap_8
XFILLER_14_167 VPWR VGND sg13cmos5l_fill_1
XFILLER_30_616 VPWR VGND sg13cmos5l_fill_2
X_5890_ _5890_/Q _5894_/CLK _5890_/D _5890_/RESET_B VPWR VGND sg13cmos5l_dfrbpq_1
X_4910_ _4910_/Y _4910_/A _4910_/B _4910_/C VPWR VGND sg13cmos5l_nand3_1
X_4841_ _4864_/C _4836_/X _4837_/Y _4839_/Y VPWR VGND sg13cmos5l_a21o_1
XFILLER_21_616 VPWR VGND sg13cmos5l_fill_2
XFILLER_34_999 VPWR VGND sg13cmos5l_fill_1
X_4772_ _4843_/A _4771_/Y _4556_/A _4772_/S VPWR VGND sg13cmos5l_mux2_1
X_3723_ _5812_/D input4/X _3208_/B _3712_/Y _3721_/Y _3722_/Y VPWR VGND sg13cmos5l_a221oi_1
XFILLER_20_159 VPWR VGND sg13cmos5l_decap_8
XFILLER_9_171 VPWR VGND sg13cmos5l_fill_1
X_3654_ _3654_/Y _3761_/B2 _3648_/Y _3139_/A VPWR VGND sg13cmos5l_o21ai_1
X_3585_ _3585_/Y _3585_/A _3593_/B VPWR VGND sg13cmos5l_nand2_1
X_5324_ _5458_/D _5324_/A0 _5372_/A0 _5332_/S VPWR VGND sg13cmos5l_mux2_1
X_5255_ _5270_/B _5195_/A _5192_/B _5254_/Y VPWR VGND sg13cmos5l_o21ai_1
X_4206_ _4206_/X _4207_/D _4206_/B VPWR VGND sg13cmos5l_or2_1
X_5186_ _5245_/A _5244_/A _5244_/B _5244_/C VPWR VGND sg13cmos5l_a21oi_1
X_4137_ _4138_/A _4148_/B _4136_/Y VPWR VGND sg13cmos5l_nor2b_1
X_4068_ _4074_/A _4068_/A _4068_/B _4068_/C VPWR VGND sg13cmos5l_nor3_1
X_5555__872 _5555_/RESET_B VPWR VGND sg13cmos5l_tiehi
X_5703__717 _5703_/RESET_B VPWR VGND sg13cmos5l_tiehi
X_5562__865 _5562_/RESET_B VPWR VGND sg13cmos5l_tiehi
Xfanout150 _4067_/A _4061_/A VPWR VGND sg13cmos5l_buf_1
Xfanout161 _4091_/A1 fanout162/X VPWR VGND sg13cmos5l_buf_1
Xfanout172 _4049_/A1 _4039_/A1 VPWR VGND sg13cmos5l_buf_1
Xfanout183 _4079_/S _4069_/S0 VPWR VGND sg13cmos5l_buf_1
XFILLER_47_546 VPWR VGND sg13cmos5l_decap_8
XFILLER_47_63 VPWR VGND sg13cmos5l_fill_1
Xfanout194 _3998_/S0 _3897_/A1 VPWR VGND sg13cmos5l_buf_1
XFILLER_47_96 VPWR VGND sg13cmos5l_fill_2
XFILLER_16_966 VPWR VGND sg13cmos5l_fill_2
X_5962__403 _5962_/RESET_B VPWR VGND sg13cmos5l_tiehi
XFILLER_30_435 VPWR VGND sg13cmos5l_fill_1
XFILLER_31_958 VPWR VGND sg13cmos5l_decap_8
XFILLER_8_46 VPWR VGND sg13cmos5l_fill_1
X_3370_ _5674_/D _3393_/A0 _3370_/A1 _3374_/B VPWR VGND sg13cmos5l_mux2_1
X_5040_ _5051_/B _4959_/B _4931_/B _5048_/B VPWR VGND sg13cmos5l_mux2_1
XFILLER_33_4 VPWR VGND sg13cmos5l_fill_1
Xhold1309 _5385_/A0 _5513_/Q VPWR VGND sg13cmos5l_dlygate4sd3_1
Xheichips26_dna_sequencer_269 uio_out[0] VPWR VGND sg13cmos5l_tielo
XFILLER_38_546 VPWR VGND sg13cmos5l_fill_2
XFILLER_19_760 VPWR VGND sg13cmos5l_fill_2
XFILLER_38_557 VPWR VGND sg13cmos5l_fill_2
X_5942_ _5942_/Q _5943_/CLK _5942_/D _5942_/RESET_B VPWR VGND sg13cmos5l_dfrbpq_1
X_5830__569 _5830_/RESET_B VPWR VGND sg13cmos5l_tiehi
X_5873_ _5873_/Q _6080_/CLK _5873_/D _5873_/RESET_B VPWR VGND sg13cmos5l_dfrbpq_1
XFILLER_21_424 VPWR VGND sg13cmos5l_fill_2
X_4824_ _4824_/Y _3072_/Y _4824_/A2 _4823_/Y VPWR VGND sg13cmos5l_a21oi_1
XFILLER_21_457 VPWR VGND sg13cmos5l_decap_8
X_4755_ _4766_/B _5952_/Q _5953_/Q _5951_/Q _5950_/Q VPWR VGND sg13cmos5l_nor4_1
X_3706_ _5811_/D _3703_/Y _3704_/Y _3705_/Y VPWR VGND sg13cmos5l_a21oi_1
XFILLER_30_991 VPWR VGND sg13cmos5l_fill_2
X_4686_ _4692_/A _4691_/A _4691_/B _4685_/X _4696_/A _4664_/X VPWR VGND sg13cmos5l_a221oi_1
X_3637_ _5424_/C _3637_/A _3767_/B _3767_/C VPWR VGND sg13cmos5l_and3_1
X_3568_ _5776_/D _3618_/A1 _3567_/B _3567_/Y VPWR VGND sg13cmos5l_o21ai_1
X_5939__427 _5939_/RESET_B VPWR VGND sg13cmos5l_tiehi
X_5307_ _5443_/D _5374_/A0 _5307_/A1 _5313_/S VPWR VGND sg13cmos5l_mux2_1
X_5505__546 _5505_/RESET_B VPWR VGND sg13cmos5l_tiehi
X_3499_ _3499_/Y _5158_/A1 _3498_/B _3498_/Y VPWR VGND sg13cmos5l_o21ai_1
X_5238_ _5249_/B _5238_/A _5241_/B _5241_/C VPWR VGND sg13cmos5l_and3_1
X_5169_ _5169_/Y _6055_/Q _5172_/A2 _4998_/A VPWR VGND sg13cmos5l_o21ai_1
XFILLER_13_914 VPWR VGND sg13cmos5l_fill_2
XFILLER_24_240 VPWR VGND sg13cmos5l_decap_8
XFILLER_40_711 VPWR VGND sg13cmos5l_decap_8
XFILLER_24_295 VPWR VGND sg13cmos5l_fill_2
XFILLER_32_1024 VPWR VGND sg13cmos5l_decap_4
XFILLER_3_166 VPWR VGND sg13cmos5l_fill_2
XFILLER_0_851 VPWR VGND sg13cmos5l_fill_2
XFILLER_15_240 VPWR VGND sg13cmos5l_fill_2
XFILLER_30_221 VPWR VGND sg13cmos5l_decap_4
Xclkbuf_leaf_10_clk _5559_/CLK clkbuf_leaf_9_clk/A VPWR VGND sg13cmos5l_buf_8
X_4540_ _4540_/Y _4539_/A _4539_/B _4759_/A VPWR VGND sg13cmos5l_a21oi_1
X_4471_ _5932_/D _3075_/Y _4471_/A2 _4470_/Y VPWR VGND sg13cmos5l_a21oi_1
XFILLER_48_1020 VPWR VGND sg13cmos5l_decap_8
X_3422_ _3422_/Y _3422_/A _3427_/B VPWR VGND sg13cmos5l_nand2_1
X_3353_ _5659_/D _3372_/A _3353_/A1 _3355_/S VPWR VGND sg13cmos5l_mux2_1
X_6072_ _6072_/Q _6074_/CLK _6072_/D _6072_/RESET_B VPWR VGND sg13cmos5l_dfrbpq_1
Xhold1106 _5875_/D _4186_/Y VPWR VGND sg13cmos5l_dlygate4sd3_1
X_3284_ _5598_/D _5356_/A0 _3284_/A1 _3288_/S VPWR VGND sg13cmos5l_mux2_1
XFILLER_39_811 VPWR VGND sg13cmos5l_fill_2
Xhold1128 _3163_/A _5832_/Q VPWR VGND sg13cmos5l_dlygate4sd3_1
Xhold1117 _3550_/A _5767_/Q VPWR VGND sg13cmos5l_dlygate4sd3_1
X_5023_ _5023_/Y _6025_/Q _5996_/Q VPWR VGND sg13cmos5l_xnor2_1
Xhold1139 _3540_/A _5762_/Q VPWR VGND sg13cmos5l_dlygate4sd3_1
XFILLER_39_899 VPWR VGND sg13cmos5l_decap_4
X_5869__510 _5869_/RESET_B VPWR VGND sg13cmos5l_tiehi
X_5925_ _5925_/Q _5973_/CLK _5925_/D _5925_/RESET_B VPWR VGND sg13cmos5l_dfrbpq_1
X_5856_ _5856_/Q _6080_/CLK _5856_/D _5856_/RESET_B VPWR VGND sg13cmos5l_dfrbpq_1
X_5552__875 _5552_/RESET_B VPWR VGND sg13cmos5l_tiehi
X_4807_ _4809_/B _4803_/Y _4804_/Y _4806_/Y VPWR VGND sg13cmos5l_o21ai_1
XFILLER_22_755 VPWR VGND sg13cmos5l_fill_2
X_5787_ _5787_/Q _5822_/CLK _5787_/D _5787_/RESET_B VPWR VGND sg13cmos5l_dfrbpq_1
X_4738_ _4738_/Y _5278_/A _4998_/B VPWR VGND sg13cmos5l_nor2_1
X_4669_ _4679_/A _5971_/Q _4685_/B VPWR VGND sg13cmos5l_nor2_1
Xhold962 hold962/X _6079_/Q VPWR VGND sg13cmos5l_dlygate4sd3_1
Xhold973 _5432_/A _6075_/Q VPWR VGND sg13cmos5l_dlygate4sd3_1
Xhold984 _3531_/A _5758_/Q VPWR VGND sg13cmos5l_dlygate4sd3_1
Xhold995 _3564_/A _5774_/Q VPWR VGND sg13cmos5l_dlygate4sd3_1
Xhold1640 _5038_/A _6032_/Q VPWR VGND sg13cmos5l_dlygate4sd3_1
Xhold1662 _4735_/A _5977_/Q VPWR VGND sg13cmos5l_dlygate4sd3_1
Xhold1651 hold1651/X _5973_/Q VPWR VGND sg13cmos5l_dlygate4sd3_1
Xhold1673 _5082_/B _6042_/Q VPWR VGND sg13cmos5l_dlygate4sd3_1
XFILLER_44_368 VPWR VGND sg13cmos5l_decap_8
XFILLER_13_722 VPWR VGND sg13cmos5l_decap_4
XFILLER_44_97 VPWR VGND sg13cmos5l_fill_1
XFILLER_40_574 VPWR VGND sg13cmos5l_decap_8
XFILLER_36_858 VPWR VGND sg13cmos5l_fill_2
X_3971_ _3971_/X _5592_/Q _5583_/Q _3971_/S VPWR VGND sg13cmos5l_mux2_1
X_5710_ _5710_/Q _6047_/CLK _5710_/D _5710_/RESET_B VPWR VGND sg13cmos5l_dfrbpq_1
X_5641_ _5641_/Q _5695_/CLK _5641_/D _5641_/RESET_B VPWR VGND sg13cmos5l_dfrbpq_1
X_5829__571 _5829_/RESET_B VPWR VGND sg13cmos5l_tiehi
X_5572_ _5572_/Q _5840_/CLK _5572_/D _5572_/RESET_B VPWR VGND sg13cmos5l_dfrbpq_1
X_4523_ _5942_/D _4523_/A _4523_/B VPWR VGND sg13cmos5l_nor2_1
X_4454_ _4458_/B _4453_/Y _4454_/B VPWR VGND sg13cmos5l_nand2b_1
X_4385_ _4385_/Y _4395_/A _4383_/Y _4384_/Y VPWR VGND sg13cmos5l_o21ai_1
X_3405_ _5702_/D _3215_/A _3405_/A1 _3407_/S VPWR VGND sg13cmos5l_mux2_1
X_3336_ _5644_/D _5302_/A _3336_/A1 _3336_/S VPWR VGND sg13cmos5l_mux2_1
X_6055_ _6055_/Q _6056_/CLK _6055_/D _6055_/RESET_B VPWR VGND sg13cmos5l_dfrbpq_1
X_3267_ _5585_/D _3267_/A0 _5408_/A1 _3267_/S VPWR VGND sg13cmos5l_mux2_1
X_5006_ _6029_/D _5006_/A _5006_/B VPWR VGND sg13cmos5l_and2_1
X_3198_ _3199_/A _4465_/B _4301_/B _3198_/C VPWR VGND sg13cmos5l_nor3_1
XFILLER_26_324 VPWR VGND sg13cmos5l_fill_2
XFILLER_42_839 VPWR VGND sg13cmos5l_fill_1
X_5535__336 _5535_/RESET_B VPWR VGND sg13cmos5l_tiehi
XFILLER_41_349 VPWR VGND sg13cmos5l_fill_1
X_5908_ _5908_/Q _5936_/CLK _5908_/D _5908_/RESET_B VPWR VGND sg13cmos5l_dfrbpq_1
XFILLER_10_725 VPWR VGND sg13cmos5l_fill_2
X_5839_ _5839_/Q _5840_/CLK _5839_/D _5839_/RESET_B VPWR VGND sg13cmos5l_dfrbpq_1
XFILLER_2_924 VPWR VGND sg13cmos5l_fill_2
XFILLER_1_401 VPWR VGND sg13cmos5l_fill_2
XFILLER_2_957 VPWR VGND sg13cmos5l_decap_8
XFILLER_7_1028 VPWR VGND sg13cmos5l_fill_1
Xhold1470 _3399_/A1 _5696_/Q VPWR VGND sg13cmos5l_dlygate4sd3_1
Xhold1492 _5165_/A2 _5164_/Y VPWR VGND sg13cmos5l_dlygate4sd3_1
Xhold1481 _5171_/A1 _6056_/Q VPWR VGND sg13cmos5l_dlygate4sd3_1
XFILLER_29_184 VPWR VGND sg13cmos5l_fill_2
XFILLER_26_880 VPWR VGND sg13cmos5l_decap_4
XFILLER_9_534 VPWR VGND sg13cmos5l_fill_2
X_5859__520 _5859_/RESET_B VPWR VGND sg13cmos5l_tiehi
X_4170_ _4171_/A _3860_/Y _4169_/C _4169_/Y VPWR VGND sg13cmos5l_o21ai_1
X_3121_ _3121_/Y _3121_/A VPWR VGND sg13cmos5l_inv_1
XFILLER_49_994 VPWR VGND sg13cmos5l_decap_8
XFILLER_48_460 VPWR VGND sg13cmos5l_decap_8
XFILLER_35_121 VPWR VGND sg13cmos5l_fill_1
XFILLER_36_655 VPWR VGND sg13cmos5l_fill_2
XFILLER_24_817 VPWR VGND sg13cmos5l_decap_8
XFILLER_36_699 VPWR VGND sg13cmos5l_decap_8
X_5866__513 _5866_/RESET_B VPWR VGND sg13cmos5l_tiehi
X_3954_ _3954_/Y _4111_/A1 _3952_/Y _3918_/A VPWR VGND sg13cmos5l_o21ai_1
X_3885_ _3885_/Y _4009_/A _3882_/X _3881_/A VPWR VGND sg13cmos5l_o21ai_1
X_5624_ _5624_/Q _5695_/CLK _5624_/D _5624_/RESET_B VPWR VGND sg13cmos5l_dfrbpq_1
X_5555_ _5555_/Q _5555_/CLK _5555_/D _5555_/RESET_B VPWR VGND sg13cmos5l_dfrbpq_1
X_4506_ _4507_/B _4510_/B _4506_/B _4509_/B VPWR VGND sg13cmos5l_nand3b_1
X_5486_ _5486_/Q clkload6/A _5486_/D _5486_/RESET_B VPWR VGND sg13cmos5l_dfrbpq_1
X_4437_ _4445_/C _5944_/Q _4436_/Y _4435_/Y VPWR VGND sg13cmos5l_o21ai_1
X_4368_ _4368_/X _5916_/Q _4368_/B VPWR VGND sg13cmos5l_xor2_1
X_5873__506 _5873_/RESET_B VPWR VGND sg13cmos5l_tiehi
X_3319_ _5629_/D _3319_/A0 _3391_/A0 _3326_/S VPWR VGND sg13cmos5l_mux2_1
X_4299_ _4299_/Y _5898_/Q _4299_/B VPWR VGND sg13cmos5l_nand2b_1
XFILLER_46_408 VPWR VGND sg13cmos5l_decap_8
X_6038_ _6038_/Q _6061_/CLK _6038_/D _6038_/RESET_B VPWR VGND sg13cmos5l_dfrbpq_1
XFILLER_27_644 VPWR VGND sg13cmos5l_fill_1
XFILLER_39_482 VPWR VGND sg13cmos5l_decap_8
XFILLER_42_625 VPWR VGND sg13cmos5l_decap_4
XFILLER_27_699 VPWR VGND sg13cmos5l_fill_2
XFILLER_41_168 VPWR VGND sg13cmos5l_fill_2
XFILLER_38_909 VPWR VGND sg13cmos5l_fill_1
XFILLER_45_452 VPWR VGND sg13cmos5l_decap_8
XFILLER_46_997 VPWR VGND sg13cmos5l_decap_8
X_3670_ _3670_/X _5736_/Q _5730_/Q _3753_/B VPWR VGND sg13cmos5l_mux2_1
X_5340_ _5473_/D _5340_/A0 _5359_/A0 _5341_/S VPWR VGND sg13cmos5l_mux2_1
X_5271_ _5272_/C _5270_/A _5270_/C _5258_/A VPWR VGND sg13cmos5l_a21oi_1
X_4222_ _5885_/D _4193_/B _4222_/A2 _5863_/D VPWR VGND sg13cmos5l_a21o_1
X_4153_ _4153_/Y _4153_/A _4153_/B VPWR VGND sg13cmos5l_nor2_1
X_4084_ _4084_/Y _4089_/B _5701_/Q _4083_/Y VPWR VGND sg13cmos5l_o21ai_1
X_3104_ _5012_/A _4801_/B VPWR VGND sg13cmos5l_inv_1
XFILLER_36_474 VPWR VGND sg13cmos5l_decap_8
X_4986_ _4987_/C _6022_/Q _4986_/B VPWR VGND sg13cmos5l_nor2_1
XFILLER_12_809 VPWR VGND sg13cmos5l_fill_2
X_3937_ _3949_/B _4063_/A _3937_/B _3937_/C VPWR VGND sg13cmos5l_nor3_1
XFILLER_31_190 VPWR VGND sg13cmos5l_fill_1
X_3868_ _3869_/B _5688_/Q _5671_/Q _5654_/Q _5637_/Q _4045_/B _4049_/A1 VPWR VGND
+ sg13cmos5l_mux4_1
X_3799_ _3807_/C _3824_/C _3798_/A VPWR VGND sg13cmos5l_nor2b_1
XFILLER_20_897 VPWR VGND sg13cmos5l_decap_4
X_5607_ _5607_/Q _5860_/CLK _5607_/D _5607_/RESET_B VPWR VGND sg13cmos5l_dfrbpq_1
X_5538_ _5538_/Q _5674_/CLK _5538_/D _5538_/RESET_B VPWR VGND sg13cmos5l_dfrbpq_1
X_5840__549 _5840_/RESET_B VPWR VGND sg13cmos5l_tiehi
X_5469_ _5469_/Q clkload6/A _5469_/D _5469_/RESET_B VPWR VGND sg13cmos5l_dfrbpq_1
XFILLER_43_901 VPWR VGND sg13cmos5l_fill_2
XFILLER_27_430 VPWR VGND sg13cmos5l_fill_1
XFILLER_27_463 VPWR VGND sg13cmos5l_decap_8
XFILLER_27_485 VPWR VGND sg13cmos5l_fill_1
XFILLER_42_477 VPWR VGND sg13cmos5l_decap_8
XFILLER_11_842 VPWR VGND sg13cmos5l_fill_2
XFILLER_6_334 VPWR VGND sg13cmos5l_fill_1
XFILLER_6_367 VPWR VGND sg13cmos5l_fill_1
XFILLER_42_1026 VPWR VGND sg13cmos5l_fill_2
X_5856__523 _5856_/RESET_B VPWR VGND sg13cmos5l_tiehi
XFILLER_34_934 VPWR VGND sg13cmos5l_fill_1
X_4840_ _4872_/C _4836_/X _4837_/Y _4839_/Y VPWR VGND sg13cmos5l_a21oi_1
XFILLER_34_956 VPWR VGND sg13cmos5l_fill_1
XFILLER_21_628 VPWR VGND sg13cmos5l_fill_1
X_4771_ _4771_/Y _4771_/A _4771_/B VPWR VGND sg13cmos5l_nor2_1
X_5863__516 _5863_/RESET_B VPWR VGND sg13cmos5l_tiehi
X_3722_ _3722_/Y input4/X _3722_/A2 _3220_/C VPWR VGND sg13cmos5l_o21ai_1
X_3653_ _3653_/X _5771_/Q _5765_/Q _5759_/Q _5753_/Q _3749_/B _3752_/A VPWR VGND sg13cmos5l_mux4_1
X_3584_ _5783_/D _3609_/A1 _3593_/B _3583_/Y VPWR VGND sg13cmos5l_o21ai_1
X_5323_ _5331_/S _5399_/A _5399_/C _5361_/D VPWR VGND sg13cmos5l_nor3_1
X_5254_ _5254_/Y _5254_/A _5254_/B VPWR VGND sg13cmos5l_xnor2_1
X_5185_ _5244_/C _6059_/Q _5190_/B VPWR VGND sg13cmos5l_xnor2_1
X_4205_ _4206_/B _4205_/A _4205_/B _4205_/C VPWR VGND sg13cmos5l_nor3_1
X_4136_ _4136_/Y _5861_/Q _5862_/Q _5863_/Q VPWR VGND sg13cmos5l_o21ai_1
X_5870__509 _5870_/RESET_B VPWR VGND sg13cmos5l_tiehi
XFILLER_28_227 VPWR VGND sg13cmos5l_fill_2
X_4067_ _4068_/C _4067_/A _4067_/B VPWR VGND sg13cmos5l_nor2_1
XFILLER_43_208 VPWR VGND sg13cmos5l_fill_1
XFILLER_25_978 VPWR VGND sg13cmos5l_fill_1
XFILLER_19_1028 VPWR VGND sg13cmos5l_fill_1
XFILLER_24_488 VPWR VGND sg13cmos5l_fill_1
X_4969_ _4974_/B _6039_/Q _3132_/Y _4968_/Y VPWR VGND sg13cmos5l_o21ai_1
XFILLER_4_849 VPWR VGND sg13cmos5l_decap_8
X_5955__411 _5955_/RESET_B VPWR VGND sg13cmos5l_tiehi
Xfanout140 _3731_/S _3755_/S VPWR VGND sg13cmos5l_buf_1
Xfanout151 _4061_/A _4101_/A VPWR VGND sg13cmos5l_buf_1
Xfanout162 fanout162/X fanout174/X VPWR VGND sg13cmos5l_buf_1
Xfanout173 _4039_/A1 fanout174/X VPWR VGND sg13cmos5l_buf_1
XFILLER_47_525 VPWR VGND sg13cmos5l_decap_8
Xfanout184 _4100_/S0 _4069_/S0 VPWR VGND sg13cmos5l_buf_1
Xfanout195 _3897_/A1 fanout196/X VPWR VGND sg13cmos5l_buf_1
XFILLER_15_400 VPWR VGND sg13cmos5l_fill_1
XFILLER_34_208 VPWR VGND sg13cmos5l_fill_1
XFILLER_31_937 VPWR VGND sg13cmos5l_fill_1
XFILLER_2_381 VPWR VGND sg13cmos5l_fill_2
XFILLER_26_4 VPWR VGND sg13cmos5l_fill_2
XFILLER_38_536 VPWR VGND sg13cmos5l_fill_1
X_5941_ _5941_/Q _5943_/CLK _5941_/D _5941_/RESET_B VPWR VGND sg13cmos5l_dfrbpq_1
XFILLER_18_293 VPWR VGND sg13cmos5l_fill_1
X_5872_ _5872_/Q _5936_/CLK _5872_/D _5872_/RESET_B VPWR VGND sg13cmos5l_dfrbpq_1
XFILLER_21_436 VPWR VGND sg13cmos5l_decap_8
X_4823_ _4823_/Y _5995_/Q _4824_/A2 _4827_/A VPWR VGND sg13cmos5l_o21ai_1
XFILLER_33_296 VPWR VGND sg13cmos5l_fill_1
X_4754_ _4759_/B _5952_/Q _5951_/Q _5950_/Q VPWR VGND sg13cmos5l_or3_1
X_3705_ _3705_/Y input4/X _3705_/A2 _3779_/B1 VPWR VGND sg13cmos5l_o21ai_1
X_4685_ _4685_/X _4685_/A _4685_/B VPWR VGND sg13cmos5l_xor2_1
X_3636_ _5424_/B _3767_/B _3767_/C _3637_/A VPWR VGND sg13cmos5l_a21oi_1
X_3567_ _3567_/Y _3567_/A _3567_/B VPWR VGND sg13cmos5l_nand2_1
XFILLER_0_318 VPWR VGND sg13cmos5l_fill_2
X_5306_ _5442_/D _5419_/A1 _5306_/A1 _5313_/S VPWR VGND sg13cmos5l_mux2_1
X_3498_ _3498_/Y _3498_/A _3498_/B VPWR VGND sg13cmos5l_nand2_1
X_5237_ _5247_/S _5241_/B _5241_/C VPWR VGND sg13cmos5l_nand2_1
XFILLER_25_1010 VPWR VGND sg13cmos5l_fill_2
X_5839__551 _5839_/RESET_B VPWR VGND sg13cmos5l_tiehi
X_5168_ _5168_/Y _3063_/Y _5172_/A2 _5167_/Y VPWR VGND sg13cmos5l_a21oi_1
XFILLER_44_506 VPWR VGND sg13cmos5l_decap_8
X_5099_ _5110_/B _5119_/B VPWR VGND sg13cmos5l_inv_1
X_4119_ _4120_/A _4128_/A _4186_/A2 _4190_/A VPWR VGND sg13cmos5l_o21ai_1
XFILLER_44_517 VPWR VGND sg13cmos5l_fill_2
XFILLER_24_263 VPWR VGND sg13cmos5l_fill_1
XFILLER_20_480 VPWR VGND sg13cmos5l_decap_4
XFILLER_3_156 VPWR VGND sg13cmos5l_fill_1
XFILLER_0_830 VPWR VGND sg13cmos5l_fill_2
XFILLER_47_366 VPWR VGND sg13cmos5l_decap_4
XFILLER_47_399 VPWR VGND sg13cmos5l_decap_8
XFILLER_43_594 VPWR VGND sg13cmos5l_fill_1
XFILLER_30_200 VPWR VGND sg13cmos5l_fill_2
XFILLER_31_723 VPWR VGND sg13cmos5l_fill_2
XFILLER_8_930 VPWR VGND sg13cmos5l_decap_8
XFILLER_30_266 VPWR VGND sg13cmos5l_fill_2
XFILLER_30_299 VPWR VGND sg13cmos5l_decap_8
X_5860__519 _5860_/RESET_B VPWR VGND sg13cmos5l_tiehi
X_4470_ _4470_/Y _4491_/A _4471_/A2 _4649_/A VPWR VGND sg13cmos5l_o21ai_1
X_3421_ _5706_/D _5158_/A1 _3427_/B _3420_/Y VPWR VGND sg13cmos5l_o21ai_1
X_3352_ _5658_/D _5357_/A0 _3352_/A1 _3355_/S VPWR VGND sg13cmos5l_mux2_1
X_6071_ _6071_/Q _6074_/CLK _6071_/D _6071_/RESET_B VPWR VGND sg13cmos5l_dfrbpq_1
X_3283_ _5597_/D _5355_/A0 _3283_/A1 _3288_/S VPWR VGND sg13cmos5l_mux2_1
Xhold1129 _5832_/D _3820_/Y VPWR VGND sg13cmos5l_dlygate4sd3_1
Xhold1118 _3548_/A _5766_/Q VPWR VGND sg13cmos5l_dlygate4sd3_1
Xhold1107 _3450_/A _5719_/Q VPWR VGND sg13cmos5l_dlygate4sd3_1
X_5022_ _5022_/Y _6027_/Q _5998_/Q VPWR VGND sg13cmos5l_nand2_1
XFILLER_26_528 VPWR VGND sg13cmos5l_fill_1
XFILLER_0_70 VPWR VGND sg13cmos5l_fill_1
XFILLER_0_1012 VPWR VGND sg13cmos5l_decap_8
X_5924_ _5924_/Q _5943_/CLK _5924_/D _5924_/RESET_B VPWR VGND sg13cmos5l_dfrbpq_1
XFILLER_22_723 VPWR VGND sg13cmos5l_fill_1
X_5855_ _5855_/Q _6080_/CLK _5855_/D _5855_/RESET_B VPWR VGND sg13cmos5l_dfrbpq_1
X_5945__421 _5945_/RESET_B VPWR VGND sg13cmos5l_tiehi
X_4806_ _4806_/Y _4814_/A1 _4798_/Y _4805_/Y _4816_/B VPWR VGND sg13cmos5l_a22oi_1
XFILLER_21_255 VPWR VGND sg13cmos5l_fill_2
X_5786_ _5786_/Q _5825_/CLK _5786_/D _5786_/RESET_B VPWR VGND sg13cmos5l_dfrbpq_1
XFILLER_10_929 VPWR VGND sg13cmos5l_fill_1
X_4737_ _4737_/Y _4740_/A VPWR VGND sg13cmos5l_inv_1
X_4668_ _4694_/B _4666_/Y _4667_/Y _4665_/Y VPWR VGND sg13cmos5l_a21oi_1
X_3619_ _3620_/B _5842_/Q _4003_/A VPWR VGND sg13cmos5l_and2_1
X_4599_ _4657_/C _4594_/A _4594_/B _4388_/Y VPWR VGND sg13cmos5l_o21ai_1
Xhold963 _3201_/B _3200_/Y VPWR VGND sg13cmos5l_dlygate4sd3_1
Xhold974 _3498_/A _5742_/Q VPWR VGND sg13cmos5l_dlygate4sd3_1
Xhold985 _3496_/A _5741_/Q VPWR VGND sg13cmos5l_dlygate4sd3_1
Xhold996 hold996/X _3564_/Y VPWR VGND sg13cmos5l_dlygate4sd3_1
X_5952__414 _5952_/RESET_B VPWR VGND sg13cmos5l_tiehi
Xhold1630 _3092_/A _5941_/Q VPWR VGND sg13cmos5l_dlygate4sd3_1
XFILLER_45_804 VPWR VGND sg13cmos5l_fill_2
Xhold1652 _4945_/B1 _5984_/Q VPWR VGND sg13cmos5l_dlygate4sd3_1
XFILLER_28_66 VPWR VGND sg13cmos5l_fill_2
Xhold1641 _4867_/A _5999_/Q VPWR VGND sg13cmos5l_dlygate4sd3_1
XFILLER_45_837 VPWR VGND sg13cmos5l_decap_8
Xhold1674 _5089_/A _6044_/Q VPWR VGND sg13cmos5l_dlygate4sd3_1
Xhold1663 _5193_/A _6057_/Q VPWR VGND sg13cmos5l_dlygate4sd3_1
XFILLER_44_43 VPWR VGND sg13cmos5l_fill_1
XFILLER_25_561 VPWR VGND sg13cmos5l_decap_4
XFILLER_5_933 VPWR VGND sg13cmos5l_fill_1
XFILLER_47_141 VPWR VGND sg13cmos5l_fill_1
XFILLER_47_185 VPWR VGND sg13cmos5l_fill_1
XFILLER_44_870 VPWR VGND sg13cmos5l_fill_2
XFILLER_16_561 VPWR VGND sg13cmos5l_fill_1
X_3970_ _3970_/Y _4097_/S _5634_/Q _3969_/Y VPWR VGND sg13cmos5l_o21ai_1
X_5640_ _5640_/Q _5840_/CLK _5640_/D _5640_/RESET_B VPWR VGND sg13cmos5l_dfrbpq_1
X_5571_ _5571_/Q _5860_/CLK _5571_/D _5571_/RESET_B VPWR VGND sg13cmos5l_dfrbpq_1
X_4522_ _4523_/B _4512_/A _4511_/Y _4522_/S VPWR VGND sg13cmos5l_mux2_1
X_4453_ _4453_/Y _4463_/B _4450_/Y _4463_/A VPWR VGND sg13cmos5l_o21ai_1
X_3404_ _5701_/D _3384_/A _3404_/A1 _3407_/S VPWR VGND sg13cmos5l_mux2_1
X_4384_ _4384_/Y _4384_/A _4396_/B VPWR VGND sg13cmos5l_nor2_1
X_3335_ _5643_/D _3374_/A _3335_/A1 _3336_/S VPWR VGND sg13cmos5l_mux2_1
X_6054_ _6054_/Q _6077_/CLK _6054_/D _6054_/RESET_B VPWR VGND sg13cmos5l_dfrbpq_1
X_3266_ _5584_/D _3266_/A0 _5322_/A1 _3266_/S VPWR VGND sg13cmos5l_mux2_1
X_5005_ _6028_/D _5007_/A _5005_/B VPWR VGND sg13cmos5l_and2_1
X_3197_ _3198_/C _3197_/A _3197_/B VPWR VGND sg13cmos5l_nand2_1
XFILLER_39_686 VPWR VGND sg13cmos5l_fill_1
XFILLER_42_807 VPWR VGND sg13cmos5l_fill_1
X_5907_ _5907_/Q _6080_/CLK _5907_/D _5907_/RESET_B VPWR VGND sg13cmos5l_dfrbpq_1
X_5838_ _5838_/Q clkload9/A _5838_/D _5838_/RESET_B VPWR VGND sg13cmos5l_dfrbpq_1
X_5808__612 _5808_/RESET_B VPWR VGND sg13cmos5l_tiehi
X_5769_ _5769_/Q clkload7/A _5769_/D _5769_/RESET_B VPWR VGND sg13cmos5l_dfrbpq_1
XFILLER_29_163 VPWR VGND sg13cmos5l_fill_2
Xhold1460 _3310_/A1 _5621_/Q VPWR VGND sg13cmos5l_dlygate4sd3_1
Xhold1493 _6051_/D _5165_/Y VPWR VGND sg13cmos5l_dlygate4sd3_1
Xhold1471 _5355_/A1 _5486_/Q VPWR VGND sg13cmos5l_dlygate4sd3_1
XFILLER_29_174 VPWR VGND sg13cmos5l_fill_2
Xhold1482 _3852_/A _5845_/Q VPWR VGND sg13cmos5l_dlygate4sd3_1
XFILLER_33_829 VPWR VGND sg13cmos5l_decap_8
XFILLER_26_870 VPWR VGND sg13cmos5l_fill_1
XFILLER_13_531 VPWR VGND sg13cmos5l_fill_2
XFILLER_13_553 VPWR VGND sg13cmos5l_fill_1
XFILLER_9_513 VPWR VGND sg13cmos5l_decap_8
X_3120_ _3120_/Y _3120_/A VPWR VGND sg13cmos5l_inv_1
X_5935__431 _5935_/RESET_B VPWR VGND sg13cmos5l_tiehi
XFILLER_49_973 VPWR VGND sg13cmos5l_decap_8
X_3953_ _3953_/X _5462_/Q _5445_/Q _4079_/S VPWR VGND sg13cmos5l_mux2_1
X_3884_ _3884_/Y _3918_/A _3884_/B VPWR VGND sg13cmos5l_nor2_1
X_5623_ _5623_/Q _5840_/CLK _5623_/D _5623_/RESET_B VPWR VGND sg13cmos5l_dfrbpq_1
X_5942__424 _5942_/RESET_B VPWR VGND sg13cmos5l_tiehi
X_5554_ _5554_/Q _5674_/CLK _5554_/D _5554_/RESET_B VPWR VGND sg13cmos5l_dfrbpq_1
X_4505_ _4506_/B _4505_/A _4505_/B VPWR VGND sg13cmos5l_or2_1
X_5485_ _5485_/Q _5853_/CLK _5485_/D _5485_/RESET_B VPWR VGND sg13cmos5l_dfrbpq_1
X_4436_ _4436_/Y _5898_/Q _5943_/Q VPWR VGND sg13cmos5l_nor2_1
X_4367_ _4396_/A _4367_/A _4368_/B VPWR VGND sg13cmos5l_xnor2_1
X_3318_ _5628_/D _3318_/A0 _5353_/A0 _3326_/S VPWR VGND sg13cmos5l_mux2_1
X_4298_ _5896_/D _4298_/A _4298_/B VPWR VGND sg13cmos5l_nor2_1
X_6037_ _6037_/Q _6037_/CLK _6037_/D _6037_/RESET_B VPWR VGND sg13cmos5l_dfrbpq_1
X_3249_ _5572_/D _5356_/A0 _3249_/A1 _3253_/B VPWR VGND sg13cmos5l_mux2_1
XFILLER_39_461 VPWR VGND sg13cmos5l_decap_8
XFILLER_25_56 VPWR VGND sg13cmos5l_fill_1
XFILLER_9_2 VPWR VGND sg13cmos5l_fill_1
XFILLER_2_16 VPWR VGND sg13cmos5l_fill_1
XFILLER_49_236 VPWR VGND sg13cmos5l_fill_1
XFILLER_46_976 VPWR VGND sg13cmos5l_decap_8
XFILLER_45_431 VPWR VGND sg13cmos5l_decap_8
Xhold1290 _5769_/D _3554_/X VPWR VGND sg13cmos5l_dlygate4sd3_1
XFILLER_32_158 VPWR VGND sg13cmos5l_fill_1
X_5270_ _5272_/B _5270_/A _5270_/B _5270_/C VPWR VGND sg13cmos5l_and3_1
X_4221_ _4221_/Y _4221_/A _4221_/B _4221_/C VPWR VGND sg13cmos5l_nor3_1
X_4152_ _5861_/D _4221_/A _4152_/B VPWR VGND sg13cmos5l_nor2_1
X_4083_ _4083_/Y _4083_/A1 _3122_/Y _4086_/A1 VPWR VGND sg13cmos5l_a21oi_1
X_3103_ _5009_/A _4785_/A VPWR VGND sg13cmos5l_inv_1
XFILLER_36_453 VPWR VGND sg13cmos5l_decap_8
XFILLER_37_976 VPWR VGND sg13cmos5l_decap_8
X_4985_ _4987_/B _4981_/Y _4982_/Y _4986_/B _6022_/Q _4983_/Y VPWR VGND sg13cmos5l_a221oi_1
X_3936_ _3937_/C _4071_/A _3933_/Y _3935_/Y VPWR VGND sg13cmos5l_a21oi_1
XFILLER_23_169 VPWR VGND sg13cmos5l_fill_1
X_5549__837 _5549_/RESET_B VPWR VGND sg13cmos5l_tiehi
X_3867_ _3870_/B _4009_/A _3867_/B VPWR VGND sg13cmos5l_nor2_1
X_3798_ _3812_/D _3798_/A _3824_/C VPWR VGND sg13cmos5l_nor2b_1
X_5805__615 _5805_/RESET_B VPWR VGND sg13cmos5l_tiehi
X_5606_ _5606_/Q _5840_/CLK _5606_/D _5606_/RESET_B VPWR VGND sg13cmos5l_dfrbpq_1
X_5537_ _5537_/Q _5674_/CLK _5537_/D _5537_/RESET_B VPWR VGND sg13cmos5l_dfrbpq_1
X_5468_ _5468_/Q _5853_/CLK _5468_/D _5468_/RESET_B VPWR VGND sg13cmos5l_dfrbpq_1
X_4419_ _4421_/A _4407_/A _4419_/B VPWR VGND sg13cmos5l_nand2b_1
X_5399_ _5407_/S _5399_/A _5399_/B _5399_/C VPWR VGND sg13cmos5l_nor3_1
X_5478__600 _5478_/RESET_B VPWR VGND sg13cmos5l_tiehi
XFILLER_47_718 VPWR VGND sg13cmos5l_fill_2
XFILLER_42_456 VPWR VGND sg13cmos5l_decap_8
XFILLER_7_869 VPWR VGND sg13cmos5l_decap_8
XFILLER_19_921 VPWR VGND sg13cmos5l_fill_2
XFILLER_34_902 VPWR VGND sg13cmos5l_fill_2
XFILLER_34_968 VPWR VGND sg13cmos5l_fill_2
XFILLER_21_618 VPWR VGND sg13cmos5l_fill_1
X_4770_ _4772_/S _4774_/B _4770_/B VPWR VGND sg13cmos5l_and2_1
X_3721_ _3721_/Y _3721_/A _3767_/C VPWR VGND sg13cmos5l_nor2b_1
X_3652_ _3652_/X _5735_/Q _5729_/Q _3710_/S VPWR VGND sg13cmos5l_mux2_1
X_3583_ _3583_/Y _3583_/A _3593_/B VPWR VGND sg13cmos5l_nand2_1
X_5322_ _5457_/D _5322_/A0 _5322_/A1 _5322_/S VPWR VGND sg13cmos5l_mux2_1
X_5253_ _5254_/B _5253_/A _5253_/B VPWR VGND sg13cmos5l_nand2_1
X_5184_ _5244_/B _6056_/Q _6030_/Q _6058_/Q VPWR VGND sg13cmos5l_nand3_1
X_4204_ _4216_/A _4211_/A _4204_/B VPWR VGND sg13cmos5l_nor2_1
X_4135_ _4148_/B _5861_/Q _5862_/Q _5863_/Q VPWR VGND sg13cmos5l_nor3_1
X_4066_ _4067_/B _5699_/Q _5682_/Q _5665_/Q _5648_/Q _3178_/A _4086_/A1 VPWR VGND
+ sg13cmos5l_mux4_1
XFILLER_25_902 VPWR VGND sg13cmos5l_decap_8
XFILLER_24_467 VPWR VGND sg13cmos5l_decap_8
XFILLER_40_905 VPWR VGND sg13cmos5l_fill_2
X_4968_ _4968_/Y _4978_/B _4816_/A _4967_/Y VPWR VGND sg13cmos5l_a21oi_1
X_4899_ _4928_/A _6013_/Q _4900_/B VPWR VGND sg13cmos5l_xor2_1
X_3919_ _3919_/Y _5471_/Q _3971_/S VPWR VGND sg13cmos5l_nand2b_1
XFILLER_4_817 VPWR VGND sg13cmos5l_fill_2
XFILLER_4_828 VPWR VGND sg13cmos5l_fill_2
Xfanout130 _3761_/B2 _3739_/S1 VPWR VGND sg13cmos5l_buf_1
XFILLER_47_504 VPWR VGND sg13cmos5l_decap_8
Xfanout141 _3755_/S fanout142/X VPWR VGND sg13cmos5l_buf_1
Xfanout174 fanout174/X _5802_/Q VPWR VGND sg13cmos5l_buf_1
Xfanout163 _4107_/B1 _4043_/S1 VPWR VGND sg13cmos5l_buf_1
Xfanout152 _3918_/A _4101_/A VPWR VGND sg13cmos5l_buf_1
Xfanout196 fanout196/X _5801_/Q VPWR VGND sg13cmos5l_buf_1
Xfanout185 _4069_/S0 fanout196/X VPWR VGND sg13cmos5l_buf_1
XFILLER_47_98 VPWR VGND sg13cmos5l_fill_1
XFILLER_16_913 VPWR VGND sg13cmos5l_fill_1
XFILLER_16_968 VPWR VGND sg13cmos5l_fill_1
XFILLER_43_765 VPWR VGND sg13cmos5l_fill_1
XFILLER_11_651 VPWR VGND sg13cmos5l_fill_2
X_5999__361 _5999_/RESET_B VPWR VGND sg13cmos5l_tiehi
XFILLER_38_559 VPWR VGND sg13cmos5l_fill_1
X_5940_ _5940_/Q _5943_/CLK _5940_/D _5940_/RESET_B VPWR VGND sg13cmos5l_dfrbpq_1
XFILLER_25_209 VPWR VGND sg13cmos5l_decap_4
XFILLER_21_404 VPWR VGND sg13cmos5l_fill_2
X_5871_ _5871_/Q _5936_/CLK _5871_/D _5871_/RESET_B VPWR VGND sg13cmos5l_dfrbpq_1
XFILLER_21_426 VPWR VGND sg13cmos5l_fill_1
X_4822_ _4822_/Y _3073_/Y _4824_/A2 _4821_/Y VPWR VGND sg13cmos5l_a21oi_1
XFILLER_33_264 VPWR VGND sg13cmos5l_fill_2
X_4753_ _5980_/D _4892_/A _4838_/A VPWR VGND sg13cmos5l_nor2_1
X_3704_ _3704_/Y input2/X _3622_/A _3724_/A VPWR VGND sg13cmos5l_a21oi_1
X_4684_ _4691_/B _4602_/B _4566_/B _4689_/S VPWR VGND sg13cmos5l_mux2_1
X_3635_ _3767_/C _3724_/A input2/X VPWR VGND sg13cmos5l_nor2_1
X_3566_ _3566_/X _3591_/A _3566_/A1 _3566_/S VPWR VGND sg13cmos5l_mux2_1
X_5802__618 _5802_/RESET_B VPWR VGND sg13cmos5l_tiehi
X_3497_ _5741_/D _3509_/A1 _3505_/B _3496_/Y VPWR VGND sg13cmos5l_o21ai_1
X_5305_ _5441_/D _5418_/A1 _5305_/A1 _5313_/S VPWR VGND sg13cmos5l_mux2_1
X_5236_ _5241_/C _5236_/A VPWR VGND sg13cmos5l_inv_1
X_5167_ _5167_/Y _6054_/Q _5172_/A2 _5007_/A VPWR VGND sg13cmos5l_o21ai_1
X_5098_ _5119_/B _6067_/Q _5098_/B VPWR VGND sg13cmos5l_xnor2_1
X_4118_ _5853_/D _3081_/Y _4304_/A2 _4117_/Y VPWR VGND sg13cmos5l_a21oi_1
X_4049_ _4049_/Y _4049_/A1 _4046_/Y _3880_/A VPWR VGND sg13cmos5l_o21ai_1
XFILLER_24_297 VPWR VGND sg13cmos5l_fill_1
XFILLER_3_168 VPWR VGND sg13cmos5l_fill_1
XFILLER_0_853 VPWR VGND sg13cmos5l_fill_1
XFILLER_0_886 VPWR VGND sg13cmos5l_decap_4
XFILLER_15_242 VPWR VGND sg13cmos5l_fill_1
X_5886__303 _5886_/D VPWR VGND sg13cmos5l_tielo
XFILLER_43_584 VPWR VGND sg13cmos5l_decap_4
XFILLER_11_481 VPWR VGND sg13cmos5l_fill_1
X_3420_ _3420_/Y _3420_/A _3427_/B VPWR VGND sg13cmos5l_nand2_1
X_3351_ _5657_/D _3393_/A0 _3351_/A1 _3355_/S VPWR VGND sg13cmos5l_mux2_1
X_6070_ _6070_/Q _6074_/CLK _6070_/D _6070_/RESET_B VPWR VGND sg13cmos5l_dfrbpq_1
X_3282_ _5596_/D _5354_/A0 _3282_/A1 _3288_/S VPWR VGND sg13cmos5l_mux2_1
X_5021_ _5021_/X _4956_/B _4927_/B _5048_/B VPWR VGND sg13cmos5l_mux2_1
Xhold1119 _3546_/A _5765_/Q VPWR VGND sg13cmos5l_dlygate4sd3_1
Xhold1108 _3438_/A _5714_/Q VPWR VGND sg13cmos5l_dlygate4sd3_1
XFILLER_39_813 VPWR VGND sg13cmos5l_fill_1
XFILLER_38_367 VPWR VGND sg13cmos5l_fill_1
X_5923_ _5923_/Q _5973_/CLK _5923_/D _5923_/RESET_B VPWR VGND sg13cmos5l_dfrbpq_1
X_5854_ _5854_/Q _5906_/CLK _5854_/D _5854_/RESET_B VPWR VGND sg13cmos5l_dfrbpq_1
X_4805_ _4805_/Y _5011_/A _5012_/A _4639_/A _4639_/B VPWR VGND sg13cmos5l_a22oi_1
X_5785_ _5785_/Q _5822_/CLK _5785_/D _5785_/RESET_B VPWR VGND sg13cmos5l_dfrbpq_1
X_4736_ _4740_/A _4714_/Y _4735_/X _4748_/S VPWR VGND sg13cmos5l_mux2_1
X_4667_ _4667_/Y _5962_/Q _5934_/Q VPWR VGND sg13cmos5l_xnor2_1
X_3618_ _5800_/D _3618_/A1 _3617_/B _3617_/Y VPWR VGND sg13cmos5l_o21ai_1
Xhold964 _5006_/B _5997_/Q VPWR VGND sg13cmos5l_dlygate4sd3_1
X_4598_ _5950_/D _4638_/A _4598_/B VPWR VGND sg13cmos5l_nor2_1
Xhold975 _5742_/D _3499_/Y VPWR VGND sg13cmos5l_dlygate4sd3_1
Xhold997 _5774_/D _3565_/Y VPWR VGND sg13cmos5l_dlygate4sd3_1
Xhold986 _3424_/A _5708_/Q VPWR VGND sg13cmos5l_dlygate4sd3_1
X_3549_ _5766_/D _3611_/A1 _3555_/B _3548_/Y VPWR VGND sg13cmos5l_a21oi_1
X_5219_ _5220_/A _6037_/Q _5218_/Y _5226_/B VPWR VGND sg13cmos5l_mux2_1
XFILLER_29_312 VPWR VGND sg13cmos5l_fill_2
Xhold1631 _4384_/A _5914_/Q VPWR VGND sg13cmos5l_dlygate4sd3_1
Xhold1620 _5840_/D _3831_/Y VPWR VGND sg13cmos5l_dlygate4sd3_1
Xhold1642 _4886_/A1 _4869_/C VPWR VGND sg13cmos5l_dlygate4sd3_1
Xhold1653 _4878_/A _6002_/Q VPWR VGND sg13cmos5l_dlygate4sd3_1
Xhold1664 _4717_/A _5980_/Q VPWR VGND sg13cmos5l_dlygate4sd3_1
Xhold1675 _4535_/A _5948_/Q VPWR VGND sg13cmos5l_dlygate4sd3_1
XFILLER_12_256 VPWR VGND sg13cmos5l_fill_2
XFILLER_12_289 VPWR VGND sg13cmos5l_fill_2
XFILLER_5_912 VPWR VGND sg13cmos5l_decap_8
XFILLER_5_901 VPWR VGND sg13cmos5l_fill_1
XFILLER_5_967 VPWR VGND sg13cmos5l_decap_4
XFILLER_5_16 VPWR VGND sg13cmos5l_fill_2
XFILLER_4_433 VPWR VGND sg13cmos5l_fill_2
X_5486__584 _5486_/RESET_B VPWR VGND sg13cmos5l_tiehi
XFILLER_4_477 VPWR VGND sg13cmos5l_fill_2
X_5996__364 _5996_/RESET_B VPWR VGND sg13cmos5l_tiehi
X_5523__467 _5523_/RESET_B VPWR VGND sg13cmos5l_tiehi
XFILLER_48_654 VPWR VGND sg13cmos5l_fill_2
XFILLER_48_687 VPWR VGND sg13cmos5l_fill_2
XFILLER_36_827 VPWR VGND sg13cmos5l_decap_8
XFILLER_35_326 VPWR VGND sg13cmos5l_fill_2
XFILLER_31_576 VPWR VGND sg13cmos5l_fill_2
X_5570_ _5570_/Q _5864_/CLK _5570_/D _5570_/RESET_B VPWR VGND sg13cmos5l_dfrbpq_1
X_4521_ _5941_/D _4521_/A _4521_/B VPWR VGND sg13cmos5l_nor2_1
X_4452_ _4454_/B _4448_/Y _4449_/Y _4451_/Y VPWR VGND sg13cmos5l_o21ai_1
X_3403_ _5700_/D _5298_/A _3403_/A1 _3407_/S VPWR VGND sg13cmos5l_mux2_1
X_4383_ _4383_/Y _4400_/A _4396_/B VPWR VGND sg13cmos5l_nor2_1
X_3334_ _5642_/D _3372_/A _3334_/A1 _3336_/S VPWR VGND sg13cmos5l_mux2_1
X_6053_ _6053_/Q _6056_/CLK _6053_/D _6053_/RESET_B VPWR VGND sg13cmos5l_dfrbpq_1
X_3265_ _5583_/D _3265_/A0 _5359_/A0 _3266_/S VPWR VGND sg13cmos5l_mux2_1
X_5004_ _5004_/Y _3061_/Y _5004_/A2 _5003_/Y VPWR VGND sg13cmos5l_a21oi_1
X_3196_ _3197_/B _6075_/Q _6080_/Q _5851_/Q _5960_/Q VPWR VGND sg13cmos5l_nor4_1
XFILLER_26_315 VPWR VGND sg13cmos5l_fill_1
XFILLER_27_838 VPWR VGND sg13cmos5l_fill_2
X_5906_ _5906_/Q _5906_/CLK _5906_/D _5906_/RESET_B VPWR VGND sg13cmos5l_dfrbpq_1
X_5837_ _5837_/Q clkload9/A _5837_/D _5837_/RESET_B VPWR VGND sg13cmos5l_dfrbpq_1
X_5768_ _5768_/Q _5834_/CLK _5768_/D _5768_/RESET_B VPWR VGND sg13cmos5l_dfrbpq_1
X_4719_ _4750_/B _6007_/Q _4719_/B VPWR VGND sg13cmos5l_xor2_1
X_5699_ _5699_/Q _5810_/CLK _5699_/D _5699_/RESET_B VPWR VGND sg13cmos5l_dfrbpq_1
XFILLER_1_403 VPWR VGND sg13cmos5l_fill_1
X_5598__822 _5598_/RESET_B VPWR VGND sg13cmos5l_tiehi
XFILLER_49_429 VPWR VGND sg13cmos5l_decap_8
Xhold1461 _3426_/A1 _5709_/Q VPWR VGND sg13cmos5l_dlygate4sd3_1
Xhold1450 _3265_/A0 _5583_/Q VPWR VGND sg13cmos5l_dlygate4sd3_1
Xhold1472 _3231_/A1 _5559_/Q VPWR VGND sg13cmos5l_dlygate4sd3_1
Xhold1494 _5176_/A _6039_/Q VPWR VGND sg13cmos5l_dlygate4sd3_1
XFILLER_17_337 VPWR VGND sg13cmos5l_fill_2
Xhold1483 _3857_/B _3856_/Y VPWR VGND sg13cmos5l_dlygate4sd3_1
XFILLER_33_808 VPWR VGND sg13cmos5l_decap_8
XFILLER_9_536 VPWR VGND sg13cmos5l_fill_1
X_6024__331 _6024_/RESET_B VPWR VGND sg13cmos5l_tiehi
XFILLER_5_797 VPWR VGND sg13cmos5l_decap_8
XFILLER_4_274 VPWR VGND sg13cmos5l_fill_2
XFILLER_45_1014 VPWR VGND sg13cmos5l_decap_8
XFILLER_1_981 VPWR VGND sg13cmos5l_decap_8
XFILLER_49_952 VPWR VGND sg13cmos5l_decap_8
XFILLER_0_491 VPWR VGND sg13cmos5l_fill_2
X_6050__947 _6050_/RESET_B VPWR VGND sg13cmos5l_tiehi
XFILLER_48_495 VPWR VGND sg13cmos5l_decap_8
X_3952_ _3952_/Y _4079_/S _5496_/Q _3951_/Y VPWR VGND sg13cmos5l_o21ai_1
XFILLER_32_874 VPWR VGND sg13cmos5l_fill_1
X_3883_ _3884_/B _5554_/Q _5537_/Q _5520_/Q _5503_/Q _4100_/S0 _4100_/S1 VPWR VGND
+ sg13cmos5l_mux4_1
X_5622_ _5622_/Q _5860_/CLK _5622_/D _5622_/RESET_B VPWR VGND sg13cmos5l_dfrbpq_1
X_5553_ _5553_/Q _5674_/CLK _5553_/D _5553_/RESET_B VPWR VGND sg13cmos5l_dfrbpq_1
X_4504_ _4504_/Y _4519_/A _4504_/B VPWR VGND sg13cmos5l_nand2_1
X_5484_ _5484_/Q _5853_/CLK _5484_/D _5484_/RESET_B VPWR VGND sg13cmos5l_dfrbpq_1
X_4435_ _4435_/Y _4430_/Y _4432_/Y _4434_/Y VPWR VGND sg13cmos5l_o21ai_1
X_4366_ _4377_/B _5916_/Q _5914_/Q _5915_/Q VPWR VGND sg13cmos5l_nor3_1
X_3317_ _3325_/S _3824_/A _3824_/B _5361_/C _3317_/D VPWR VGND sg13cmos5l_nor4_1
X_4297_ _4297_/X _4285_/B _4442_/B _4297_/S VPWR VGND sg13cmos5l_mux2_1
X_6036_ _6036_/Q _6037_/CLK _6036_/D _6036_/RESET_B VPWR VGND sg13cmos5l_dfrbpq_1
X_3248_ _5571_/D _5355_/A0 _3248_/A1 _3253_/B VPWR VGND sg13cmos5l_mux2_1
X_3179_ _3179_/Y _3178_/A _5619_/Q _3178_/Y VPWR VGND sg13cmos5l_a21oi_1
XFILLER_27_668 VPWR VGND sg13cmos5l_fill_2
XFILLER_27_679 VPWR VGND sg13cmos5l_fill_2
XFILLER_42_638 VPWR VGND sg13cmos5l_fill_1
XFILLER_49_215 VPWR VGND sg13cmos5l_fill_1
XFILLER_46_955 VPWR VGND sg13cmos5l_decap_8
Xhold1280 _3274_/A0 _5589_/Q VPWR VGND sg13cmos5l_dlygate4sd3_1
Xhold1291 _3400_/A1 _5697_/Q VPWR VGND sg13cmos5l_dlygate4sd3_1
XFILLER_45_487 VPWR VGND sg13cmos5l_decap_8
XFILLER_33_627 VPWR VGND sg13cmos5l_fill_1
X_6080__918 _6080_/RESET_B VPWR VGND sg13cmos5l_tiehi
XFILLER_41_693 VPWR VGND sg13cmos5l_fill_2
X_4220_ _4221_/C _4220_/A _4219_/A VPWR VGND sg13cmos5l_nor2b_1
X_4151_ _4208_/A _4151_/A0 _4264_/A _4153_/B VPWR VGND sg13cmos5l_mux2_1
XFILLER_49_760 VPWR VGND sg13cmos5l_decap_8
X_4082_ _4082_/Y _4061_/A _4076_/X _3931_/A VPWR VGND sg13cmos5l_o21ai_1
X_3102_ _5010_/A _4796_/A VPWR VGND sg13cmos5l_inv_1
XFILLER_37_900 VPWR VGND sg13cmos5l_fill_1
XFILLER_49_782 VPWR VGND sg13cmos5l_decap_8
XFILLER_37_966 VPWR VGND sg13cmos5l_decap_4
X_4984_ _4986_/B _5176_/A _5177_/A _4816_/A _4816_/B VPWR VGND sg13cmos5l_a22oi_1
XFILLER_23_137 VPWR VGND sg13cmos5l_fill_2
X_3935_ _3935_/Y _4071_/A _3934_/X _3931_/A VPWR VGND sg13cmos5l_o21ai_1
X_5588__832 _5588_/RESET_B VPWR VGND sg13cmos5l_tiehi
X_3866_ _3867_/B _5620_/Q _5603_/Q _5595_/Q _5569_/Q _4045_/B _4049_/A1 VPWR VGND
+ sg13cmos5l_mux4_1
X_5605_ _5605_/Q _5860_/CLK _5605_/D _5605_/RESET_B VPWR VGND sg13cmos5l_dfrbpq_1
X_3797_ _5827_/D _4131_/A _3797_/B VPWR VGND sg13cmos5l_nor2_1
X_5536_ _5536_/Q _5674_/CLK _5536_/D _5536_/RESET_B VPWR VGND sg13cmos5l_dfrbpq_1
X_5467_ _5467_/Q _5853_/CLK _5467_/D _5467_/RESET_B VPWR VGND sg13cmos5l_dfrbpq_1
X_4418_ _4419_/B _4420_/B _4423_/C _4405_/Y VPWR VGND sg13cmos5l_a21oi_1
X_5398_ _5525_/D _5398_/A0 _5398_/A1 _5398_/S VPWR VGND sg13cmos5l_mux2_1
X_4349_ _4349_/Y _4351_/B _4347_/Y _4348_/Y VPWR VGND sg13cmos5l_o21ai_1
X_5595__825 _5595_/RESET_B VPWR VGND sg13cmos5l_tiehi
X_6019_ _6019_/Q _6056_/CLK _6019_/D _6019_/RESET_B VPWR VGND sg13cmos5l_dfrbpq_1
XFILLER_43_903 VPWR VGND sg13cmos5l_fill_1
XFILLER_27_421 VPWR VGND sg13cmos5l_fill_1
XFILLER_28_955 VPWR VGND sg13cmos5l_fill_2
XFILLER_15_605 VPWR VGND sg13cmos5l_fill_2
XFILLER_27_476 VPWR VGND sg13cmos5l_decap_4
XFILLER_28_999 VPWR VGND sg13cmos5l_decap_8
XFILLER_10_321 VPWR VGND sg13cmos5l_fill_2
XFILLER_7_804 VPWR VGND sg13cmos5l_decap_8
XFILLER_11_844 VPWR VGND sg13cmos5l_fill_1
XFILLER_10_376 VPWR VGND sg13cmos5l_fill_1
XFILLER_10_365 VPWR VGND sg13cmos5l_fill_2
XFILLER_7_848 VPWR VGND sg13cmos5l_decap_4
XFILLER_7_0 VPWR VGND sg13cmos5l_fill_1
XFILLER_42_1028 VPWR VGND sg13cmos5l_fill_1
X_5932__435 _5932_/RESET_B VPWR VGND sg13cmos5l_tiehi
XFILLER_46_730 VPWR VGND sg13cmos5l_decap_8
XFILLER_18_421 VPWR VGND sg13cmos5l_decap_8
XFILLER_19_966 VPWR VGND sg13cmos5l_decap_4
XFILLER_46_774 VPWR VGND sg13cmos5l_fill_2
XFILLER_45_284 VPWR VGND sg13cmos5l_fill_2
XFILLER_33_457 VPWR VGND sg13cmos5l_decap_8
X_3720_ _3721_/A _3720_/A _3720_/B _3720_/C VPWR VGND sg13cmos5l_nor3_1
XFILLER_14_682 VPWR VGND sg13cmos5l_fill_1
X_3651_ _3651_/Y _3710_/S _5747_/Q _3650_/Y VPWR VGND sg13cmos5l_o21ai_1
X_3582_ _3582_/Y _3582_/A _3582_/B _3607_/B VPWR VGND sg13cmos5l_nand3_1
X_5321_ _5456_/D _5321_/A0 _5359_/A0 _5322_/S VPWR VGND sg13cmos5l_mux2_1
X_5252_ _5258_/A _5252_/A _5252_/B VPWR VGND sg13cmos5l_nand2_1
X_5183_ _5244_/A _6057_/Q _5190_/B VPWR VGND sg13cmos5l_nand2_1
X_4203_ _4204_/B _4203_/A _4205_/B VPWR VGND sg13cmos5l_xnor2_1
XFILLER_29_708 VPWR VGND sg13cmos5l_fill_2
X_4134_ _4261_/A _5885_/Q _5884_/Q VPWR VGND sg13cmos5l_xnor2_1
XFILLER_49_590 VPWR VGND sg13cmos5l_decap_8
X_4065_ _4068_/B _4065_/A _4065_/B VPWR VGND sg13cmos5l_nor2_1
XFILLER_24_446 VPWR VGND sg13cmos5l_decap_8
X_4967_ _4967_/Y _6039_/Q _3132_/Y _4799_/A _6038_/Q _4966_/Y VPWR VGND sg13cmos5l_a221oi_1
X_3918_ _3918_/Y _3918_/A _3918_/B VPWR VGND sg13cmos5l_nor2_1
X_4898_ _4900_/B _6012_/Q _4914_/B VPWR VGND sg13cmos5l_nor2_1
Xclkbuf_leaf_31_clk _6047_/CLK clkbuf_3_4__f_clk/X VPWR VGND sg13cmos5l_buf_8
XFILLER_32_490 VPWR VGND sg13cmos5l_fill_1
X_3849_ _3849_/Y _3849_/A _4160_/B VPWR VGND sg13cmos5l_nor2_1
XFILLER_22_69 VPWR VGND sg13cmos5l_fill_2
X_5519_ _5519_/Q _5674_/CLK _5519_/D _5519_/RESET_B VPWR VGND sg13cmos5l_dfrbpq_1
Xfanout131 _3739_/S1 _3718_/A1 VPWR VGND sg13cmos5l_buf_1
Xfanout120 _5371_/A _5838_/Q VPWR VGND sg13cmos5l_buf_1
Xfanout153 _4101_/A _5803_/Q VPWR VGND sg13cmos5l_buf_1
Xfanout142 fanout142/X _5805_/Q VPWR VGND sg13cmos5l_buf_1
Xfanout164 _4111_/A1 _4043_/S1 VPWR VGND sg13cmos5l_buf_1
Xfanout175 _3172_/S _4083_/A1 VPWR VGND sg13cmos5l_buf_1
Xfanout186 _4097_/S _3892_/S VPWR VGND sg13cmos5l_buf_1
Xfanout197 _5428_/A _3110_/Y VPWR VGND sg13cmos5l_buf_1
XFILLER_43_700 VPWR VGND sg13cmos5l_fill_1
X_5816__597 _5816_/RESET_B VPWR VGND sg13cmos5l_tiehi
XFILLER_30_449 VPWR VGND sg13cmos5l_fill_2
Xclkbuf_leaf_22_clk _5994_/CLK clkbuf_3_6__f_clk/X VPWR VGND sg13cmos5l_buf_8
XFILLER_3_840 VPWR VGND sg13cmos5l_decap_8
XFILLER_38_505 VPWR VGND sg13cmos5l_fill_1
XFILLER_38_527 VPWR VGND sg13cmos5l_decap_8
X_5496__564 _5496_/RESET_B VPWR VGND sg13cmos5l_tiehi
XFILLER_46_582 VPWR VGND sg13cmos5l_decap_8
X_5870_ _5870_/Q _5936_/CLK _5870_/D _5870_/RESET_B VPWR VGND sg13cmos5l_dfrbpq_1
X_4821_ _4821_/Y _5994_/Q _4824_/A2 _4827_/A VPWR VGND sg13cmos5l_o21ai_1
XFILLER_15_980 VPWR VGND sg13cmos5l_decap_8
Xclkbuf_leaf_13_clk _5864_/CLK clkbuf_leaf_6_clk/A VPWR VGND sg13cmos5l_buf_8
X_4752_ _4877_/A _4732_/A _4730_/Y _4750_/X VPWR VGND sg13cmos5l_a21o_1
X_3703_ _3703_/Y _3699_/Y _3702_/Y _3220_/B VPWR VGND sg13cmos5l_o21ai_1
XFILLER_30_961 VPWR VGND sg13cmos5l_fill_1
X_4683_ _4691_/A _4688_/B _4683_/B VPWR VGND sg13cmos5l_nor2_1
X_5585__835 _5585_/RESET_B VPWR VGND sg13cmos5l_tiehi
X_3634_ _3767_/B _3409_/A _3634_/B VPWR VGND sg13cmos5l_nand2b_1
X_3565_ _3565_/Y _3565_/A1 _3566_/S hold996/X VPWR VGND sg13cmos5l_o21ai_1
X_3496_ _3496_/Y _3496_/A _3505_/B VPWR VGND sg13cmos5l_nand2_1
X_5304_ _5311_/S _5304_/A _5304_/B _5304_/C _5304_/D VPWR VGND sg13cmos5l_nand4_1
X_5235_ _5236_/A _5252_/A _5251_/B _5251_/A VPWR VGND sg13cmos5l_o21ai_1
X_5166_ _6053_/D _5166_/A _5166_/B VPWR VGND sg13cmos5l_and2_1
X_5097_ _5097_/Y _5084_/Y _5091_/Y _5096_/Y VPWR VGND sg13cmos5l_o21ai_1
X_5592__828 _5592_/RESET_B VPWR VGND sg13cmos5l_tiehi
X_4117_ _4117_/Y _4304_/A2 _4125_/B _5291_/A VPWR VGND sg13cmos5l_o21ai_1
X_4048_ _4048_/Y _4045_/B _3121_/Y _4047_/Y VPWR VGND sg13cmos5l_a21oi_1
XFILLER_12_405 VPWR VGND sg13cmos5l_fill_2
X_5999_ _5999_/Q _6007_/CLK _5999_/D _5999_/RESET_B VPWR VGND sg13cmos5l_dfrbpq_1
XFILLER_21_972 VPWR VGND sg13cmos5l_fill_2
XFILLER_21_994 VPWR VGND sg13cmos5l_fill_2
XFILLER_0_843 VPWR VGND sg13cmos5l_decap_4
XFILLER_0_865 VPWR VGND sg13cmos5l_decap_8
XFILLER_0_876 VPWR VGND sg13cmos5l_fill_2
X_5853__528 _5853_/RESET_B VPWR VGND sg13cmos5l_tiehi
XFILLER_15_221 VPWR VGND sg13cmos5l_fill_1
XFILLER_15_254 VPWR VGND sg13cmos5l_fill_1
XFILLER_30_202 VPWR VGND sg13cmos5l_fill_1
XFILLER_31_725 VPWR VGND sg13cmos5l_fill_1
XFILLER_30_268 VPWR VGND sg13cmos5l_fill_1
XFILLER_8_998 VPWR VGND sg13cmos5l_fill_2
XFILLER_7_464 VPWR VGND sg13cmos5l_fill_2
X_3350_ _5656_/D _3392_/A0 _3350_/A1 _3355_/S VPWR VGND sg13cmos5l_mux2_1
X_5897__477 _5897_/RESET_B VPWR VGND sg13cmos5l_tiehi
X_5020_ _5048_/B _5016_/Y _5018_/Y _5019_/Y VPWR VGND sg13cmos5l_o21ai_1
XFILLER_31_4 VPWR VGND sg13cmos5l_fill_2
X_3281_ _5595_/D _5315_/A1 _3281_/A1 _3288_/S VPWR VGND sg13cmos5l_mux2_1
Xhold1109 _5714_/D _3439_/Y VPWR VGND sg13cmos5l_dlygate4sd3_1
Xclkbuf_leaf_2_clk clkload2/A clkbuf_leaf_2_clk/A VPWR VGND sg13cmos5l_buf_8
XFILLER_38_302 VPWR VGND sg13cmos5l_fill_2
XFILLER_38_335 VPWR VGND sg13cmos5l_decap_4
XFILLER_26_519 VPWR VGND sg13cmos5l_fill_2
X_5922_ _5922_/Q _5973_/CLK _5922_/D _5922_/RESET_B VPWR VGND sg13cmos5l_dfrbpq_1
X_5853_ _5853_/Q _5853_/CLK _5853_/D _5853_/RESET_B VPWR VGND sg13cmos5l_dfrbpq_1
X_5784_ _5784_/Q _5822_/CLK _5784_/D _5784_/RESET_B VPWR VGND sg13cmos5l_dfrbpq_1
X_4804_ _4804_/Y _5988_/Q _4802_/Y _4799_/Y VPWR VGND sg13cmos5l_o21ai_1
XFILLER_21_257 VPWR VGND sg13cmos5l_fill_1
XFILLER_21_268 VPWR VGND sg13cmos5l_fill_2
X_4735_ _4735_/X _4735_/A _4743_/B VPWR VGND sg13cmos5l_or2_1
X_4666_ _4666_/Y _5961_/Q _5933_/Q VPWR VGND sg13cmos5l_xnor2_1
X_4597_ _4598_/B _4656_/C _4656_/D VPWR VGND sg13cmos5l_nand2_1
X_3617_ _3617_/Y _3617_/A _3617_/B VPWR VGND sg13cmos5l_nand2_1
X_3548_ _3548_/Y _3548_/A _3555_/B VPWR VGND sg13cmos5l_nor2_1
Xhold998 _3514_/A _5750_/Q VPWR VGND sg13cmos5l_dlygate4sd3_1
Xhold976 _3427_/A _5710_/Q VPWR VGND sg13cmos5l_dlygate4sd3_1
Xhold987 _5708_/D _3425_/Y VPWR VGND sg13cmos5l_dlygate4sd3_1
Xhold965 _4648_/B _5933_/Q VPWR VGND sg13cmos5l_dlygate4sd3_1
X_3479_ _5732_/D _3615_/A1 _3481_/B _3478_/Y VPWR VGND sg13cmos5l_o21ai_1
X_5218_ _5218_/Y _5207_/X _5218_/B VPWR VGND sg13cmos5l_nand2b_1
Xhold1610 _4151_/A0 _5861_/Q VPWR VGND sg13cmos5l_dlygate4sd3_1
Xhold1632 hold1632/X _5825_/Q VPWR VGND sg13cmos5l_dlygate4sd3_1
X_5149_ _5149_/Y _5148_/B _5147_/Y _5148_/Y VPWR VGND sg13cmos5l_a21oi_1
Xhold1621 _4955_/A0 _5982_/Q VPWR VGND sg13cmos5l_dlygate4sd3_1
XFILLER_28_57 VPWR VGND sg13cmos5l_fill_1
Xhold1643 _4148_/A _5864_/Q VPWR VGND sg13cmos5l_dlygate4sd3_1
Xhold1665 _4367_/A _5916_/Q VPWR VGND sg13cmos5l_dlygate4sd3_1
Xhold1676 _5103_/A _6046_/Q VPWR VGND sg13cmos5l_dlygate4sd3_1
Xhold1654 _4893_/A1 _4883_/B VPWR VGND sg13cmos5l_dlygate4sd3_1
XFILLER_12_279 VPWR VGND sg13cmos5l_fill_1
XFILLER_40_588 VPWR VGND sg13cmos5l_fill_2
X_5922__297 _5922_/D VPWR VGND sg13cmos5l_tielo
XFILLER_4_489 VPWR VGND sg13cmos5l_fill_2
XFILLER_48_600 VPWR VGND sg13cmos5l_decap_8
XFILLER_44_872 VPWR VGND sg13cmos5l_fill_1
XFILLER_31_511 VPWR VGND sg13cmos5l_fill_1
X_4520_ _4521_/B _4503_/Y _4522_/S _4475_/B VPWR VGND sg13cmos5l_o21ai_1
XFILLER_7_272 VPWR VGND sg13cmos5l_fill_1
X_4451_ _4451_/Y _5926_/Q _4440_/Y _4450_/Y _4463_/B VPWR VGND sg13cmos5l_a22oi_1
X_3402_ _5699_/D _5421_/A1 _3402_/A1 _3407_/S VPWR VGND sg13cmos5l_mux2_1
X_4382_ _4395_/A _4373_/X _4378_/Y _4396_/B _4400_/A _4381_/Y VPWR VGND sg13cmos5l_a221oi_1
X_3333_ _5641_/D _5357_/A0 _3333_/A1 _3336_/S VPWR VGND sg13cmos5l_mux2_1
X_6052_ _6052_/Q _6063_/CLK _6052_/D _6052_/RESET_B VPWR VGND sg13cmos5l_dfrbpq_1
X_3264_ _5582_/D _3123_/Y _3267_/S _3263_/Y VPWR VGND sg13cmos5l_o21ai_1
X_5003_ _5003_/Y _5995_/Q _5003_/A2 _4827_/A VPWR VGND sg13cmos5l_o21ai_1
X_3195_ _3197_/A _5929_/Q _6024_/Q _5992_/Q VPWR VGND sg13cmos5l_nor3_1
XFILLER_27_828 VPWR VGND sg13cmos5l_fill_1
XFILLER_22_500 VPWR VGND sg13cmos5l_fill_2
X_5905_ _5905_/Q _5994_/CLK _5905_/D _5905_/RESET_B VPWR VGND sg13cmos5l_dfrbpq_1
X_5836_ _5836_/Q clkload5/A _5836_/D _5836_/RESET_B VPWR VGND sg13cmos5l_dfrbpq_1
X_5767_ _5767_/Q _5834_/CLK _5767_/D _5767_/RESET_B VPWR VGND sg13cmos5l_dfrbpq_1
X_5698_ _5698_/Q clkload4/A _5698_/D _5698_/RESET_B VPWR VGND sg13cmos5l_dfrbpq_1
X_4718_ _4732_/B _6007_/Q _4719_/B VPWR VGND sg13cmos5l_xnor2_1
X_4649_ _5965_/D _4649_/A _4649_/B VPWR VGND sg13cmos5l_and2_1
XFILLER_49_408 VPWR VGND sg13cmos5l_decap_8
Xhold1440 _3238_/A0 _5565_/Q VPWR VGND sg13cmos5l_dlygate4sd3_1
Xhold1451 _5321_/A0 _5456_/Q VPWR VGND sg13cmos5l_dlygate4sd3_1
Xhold1495 _6060_/D _5176_/X VPWR VGND sg13cmos5l_dlygate4sd3_1
Xhold1462 _3361_/A0 _5666_/Q VPWR VGND sg13cmos5l_dlygate4sd3_1
XFILLER_29_165 VPWR VGND sg13cmos5l_fill_1
Xhold1484 _5859_/D _4130_/Y VPWR VGND sg13cmos5l_dlygate4sd3_1
Xhold1473 _3311_/A1 _5622_/Q VPWR VGND sg13cmos5l_dlygate4sd3_1
XFILLER_45_658 VPWR VGND sg13cmos5l_decap_8
XFILLER_13_533 VPWR VGND sg13cmos5l_fill_1
XFILLER_40_352 VPWR VGND sg13cmos5l_fill_2
XFILLER_1_960 VPWR VGND sg13cmos5l_decap_8
XFILLER_49_931 VPWR VGND sg13cmos5l_decap_8
XFILLER_48_474 VPWR VGND sg13cmos5l_decap_8
X_3951_ _3951_/Y _5479_/Q _4079_/S VPWR VGND sg13cmos5l_nand2b_1
XFILLER_23_308 VPWR VGND sg13cmos5l_fill_1
XFILLER_32_842 VPWR VGND sg13cmos5l_decap_8
X_3882_ _3882_/X _5486_/Q _5469_/Q _5452_/Q _5435_/Q _3892_/S _4099_/A1 VPWR VGND
+ sg13cmos5l_mux4_1
XFILLER_32_864 VPWR VGND sg13cmos5l_fill_2
X_5621_ _5621_/Q _5864_/CLK _5621_/D _5621_/RESET_B VPWR VGND sg13cmos5l_dfrbpq_1
X_5552_ _5552_/Q _5555_/CLK _5552_/D _5552_/RESET_B VPWR VGND sg13cmos5l_dfrbpq_1
X_4503_ _4503_/Y _4504_/B VPWR VGND sg13cmos5l_inv_1
X_5483_ _5483_/Q clkload9/A _5483_/D _5483_/RESET_B VPWR VGND sg13cmos5l_dfrbpq_1
X_4434_ _4434_/Y _5944_/Q _4434_/B VPWR VGND sg13cmos5l_nand2_1
X_4365_ _4368_/B _5914_/Q _5915_/Q VPWR VGND sg13cmos5l_nor2_1
X_3316_ _5627_/D _5302_/A _3316_/A1 _3316_/S VPWR VGND sg13cmos5l_mux2_1
XFILLER_6_1020 VPWR VGND sg13cmos5l_decap_8
X_6035_ _6035_/Q _6061_/CLK _6035_/D _6035_/RESET_B VPWR VGND sg13cmos5l_dfrbpq_1
X_4296_ _5895_/D _4298_/A _4296_/B VPWR VGND sg13cmos5l_nor2_1
X_3247_ _5570_/D _3391_/A0 _3247_/A1 _3253_/B VPWR VGND sg13cmos5l_mux2_1
X_3178_ _3178_/Y _3178_/A _5636_/Q VPWR VGND sg13cmos5l_nor2b_1
XFILLER_39_496 VPWR VGND sg13cmos5l_decap_4
XFILLER_14_319 VPWR VGND sg13cmos5l_fill_1
XFILLER_26_179 VPWR VGND sg13cmos5l_fill_2
X_5819_ _5819_/Q clkload8/A _5819_/D _5819_/RESET_B VPWR VGND sg13cmos5l_dfrbpq_1
XFILLER_46_934 VPWR VGND sg13cmos5l_decap_8
XFILLER_18_603 VPWR VGND sg13cmos5l_fill_1
Xhold1270 _3331_/A1 _5639_/Q VPWR VGND sg13cmos5l_dlygate4sd3_1
Xhold1281 _3286_/A1 _5600_/Q VPWR VGND sg13cmos5l_dlygate4sd3_1
Xhold1292 _3346_/A0 _5653_/Q VPWR VGND sg13cmos5l_dlygate4sd3_1
XFILLER_45_466 VPWR VGND sg13cmos5l_decap_8
XFILLER_14_864 VPWR VGND sg13cmos5l_fill_2
XFILLER_13_363 VPWR VGND sg13cmos5l_decap_8
XFILLER_9_345 VPWR VGND sg13cmos5l_decap_8
X_5826__577 _5826_/RESET_B VPWR VGND sg13cmos5l_tiehi
X_4150_ _4264_/A _4311_/A _4265_/A VPWR VGND sg13cmos5l_nand2_1
X_3101_ _5111_/A _5138_/B VPWR VGND sg13cmos5l_inv_1
X_4081_ _4081_/Y _4111_/A1 _4079_/X _4080_/Y VPWR VGND sg13cmos5l_a21oi_1
XFILLER_36_488 VPWR VGND sg13cmos5l_decap_8
X_4983_ _4983_/Y _5142_/B _4993_/A VPWR VGND sg13cmos5l_nor2_1
X_3934_ _3934_/X _5560_/Q _5543_/Q _5526_/Q _5509_/Q _3172_/S _4076_/S1 VPWR VGND
+ sg13cmos5l_mux4_1
X_3865_ _3865_/Y _3865_/A _3865_/B VPWR VGND sg13cmos5l_nand2_1
XFILLER_31_160 VPWR VGND sg13cmos5l_fill_1
XFILLER_32_694 VPWR VGND sg13cmos5l_fill_1
X_5604_ _5604_/Q _5864_/CLK _5604_/D _5604_/RESET_B VPWR VGND sg13cmos5l_dfrbpq_1
X_3796_ _3796_/Y _3796_/A _3796_/B VPWR VGND sg13cmos5l_xnor2_1
XFILLER_9_890 VPWR VGND sg13cmos5l_decap_8
XFILLER_20_889 VPWR VGND sg13cmos5l_fill_1
X_5535_ _5535_/Q _5555_/CLK _5535_/D _5535_/RESET_B VPWR VGND sg13cmos5l_dfrbpq_1
X_5508__536 _5508_/RESET_B VPWR VGND sg13cmos5l_tiehi
X_5466_ _5466_/Q clkload9/A _5466_/D _5466_/RESET_B VPWR VGND sg13cmos5l_dfrbpq_1
X_4417_ _4423_/C _4412_/Y _4415_/Y _4416_/Y VPWR VGND sg13cmos5l_o21ai_1
X_5397_ _5524_/D _5416_/A0 _5397_/A1 _5398_/S VPWR VGND sg13cmos5l_mux2_1
XFILLER_28_1021 VPWR VGND sg13cmos5l_fill_2
X_4348_ _4348_/Y _4330_/A _4332_/Y _4335_/Y _4342_/Y _4346_/Y VPWR VGND sg13cmos5l_a221oi_1
X_4279_ _4279_/Y _4247_/A _4283_/B _4277_/Y VPWR VGND sg13cmos5l_o21ai_1
XFILLER_46_219 VPWR VGND sg13cmos5l_fill_2
X_6018_ _6018_/Q _6067_/CLK _6018_/D _6018_/RESET_B VPWR VGND sg13cmos5l_dfrbpq_1
XFILLER_28_934 VPWR VGND sg13cmos5l_decap_8
XFILLER_36_35 VPWR VGND sg13cmos5l_fill_2
XFILLER_43_959 VPWR VGND sg13cmos5l_decap_8
XFILLER_43_937 VPWR VGND sg13cmos5l_fill_2
XFILLER_10_355 VPWR VGND sg13cmos5l_fill_2
XFILLER_18_400 VPWR VGND sg13cmos5l_fill_2
XFILLER_19_923 VPWR VGND sg13cmos5l_fill_1
XFILLER_34_904 VPWR VGND sg13cmos5l_fill_1
XFILLER_9_164 VPWR VGND sg13cmos5l_decap_8
X_3650_ _3650_/Y _5741_/Q _3710_/S VPWR VGND sg13cmos5l_nand2b_1
X_3581_ _5782_/D _3618_/A1 _3580_/B _3580_/Y VPWR VGND sg13cmos5l_o21ai_1
X_5320_ _5455_/D _5320_/A0 _5367_/A1 _5322_/S VPWR VGND sg13cmos5l_mux2_1
X_5251_ _5252_/B _5251_/A _5251_/B VPWR VGND sg13cmos5l_nand2_1
X_4202_ _4211_/A _4202_/A _4202_/B VPWR VGND sg13cmos5l_nor2_1
X_5182_ _5195_/A _5182_/A _5190_/B VPWR VGND sg13cmos5l_nor2_1
X_4133_ _4145_/B _5885_/Q _5884_/Q VPWR VGND sg13cmos5l_nor2_1
X_4064_ _4065_/B _5631_/Q _5614_/Q _5589_/Q _5580_/Q _3178_/A _4086_/A1 VPWR VGND
+ sg13cmos5l_mux4_1
XFILLER_3_1023 VPWR VGND sg13cmos5l_decap_4
XFILLER_25_937 VPWR VGND sg13cmos5l_fill_2
XFILLER_40_918 VPWR VGND sg13cmos5l_fill_1
X_4966_ _4966_/Y _5175_/A _5989_/Q _5988_/Q _5174_/A _4965_/Y VPWR VGND sg13cmos5l_a221oi_1
X_3917_ _3918_/B _5556_/Q _5539_/Q _5522_/Q _5505_/Q _4100_/S0 _4100_/S1 VPWR VGND
+ sg13cmos5l_mux4_1
X_4897_ _4914_/B _6011_/Q _6010_/Q _6009_/Q VPWR VGND sg13cmos5l_or3_1
X_3848_ _4160_/B _4193_/A _4207_/A VPWR VGND sg13cmos5l_nand2b_1
X_3779_ _3779_/Y _3782_/A _3778_/Y _3779_/B1 VPWR VGND sg13cmos5l_o21ai_1
X_5518_ _5518_/Q _5555_/CLK _5518_/D _5518_/RESET_B VPWR VGND sg13cmos5l_dfrbpq_1
X_5449_ _5449_/Q _5555_/CLK _5449_/D _5449_/RESET_B VPWR VGND sg13cmos5l_dfrbpq_1
Xfanout121 _3824_/B _5371_/B VPWR VGND sg13cmos5l_buf_1
Xfanout110 _4829_/A hold1651/X VPWR VGND sg13cmos5l_buf_1
Xfanout132 _3718_/A1 _5806_/Q VPWR VGND sg13cmos5l_buf_1
Xfanout143 _3931_/A _4102_/A VPWR VGND sg13cmos5l_buf_1
Xfanout165 _4100_/S1 _4043_/S1 VPWR VGND sg13cmos5l_buf_1
Xfanout154 _4011_/A _4042_/A1 VPWR VGND sg13cmos5l_buf_1
Xfanout198 _5429_/A _3110_/Y VPWR VGND sg13cmos5l_buf_1
Xfanout176 _3979_/S _4083_/A1 VPWR VGND sg13cmos5l_buf_1
Xfanout187 _3971_/S _3892_/S VPWR VGND sg13cmos5l_buf_1
XFILLER_47_539 VPWR VGND sg13cmos5l_decap_8
XFILLER_43_712 VPWR VGND sg13cmos5l_fill_2
XFILLER_24_992 VPWR VGND sg13cmos5l_decap_8
XFILLER_10_141 VPWR VGND sg13cmos5l_fill_2
XFILLER_6_134 VPWR VGND sg13cmos5l_fill_1
XFILLER_3_896 VPWR VGND sg13cmos5l_fill_2
XFILLER_46_561 VPWR VGND sg13cmos5l_decap_8
XFILLER_19_775 VPWR VGND sg13cmos5l_fill_2
XFILLER_19_797 VPWR VGND sg13cmos5l_fill_1
X_4820_ _4820_/Y _3074_/Y _5172_/A2 _4819_/Y VPWR VGND sg13cmos5l_a21oi_1
XFILLER_21_406 VPWR VGND sg13cmos5l_fill_1
XFILLER_21_417 VPWR VGND sg13cmos5l_decap_8
XFILLER_33_266 VPWR VGND sg13cmos5l_fill_1
X_4751_ _4838_/A _4732_/A _4730_/Y _4750_/X VPWR VGND sg13cmos5l_a21oi_1
X_3702_ _3702_/Y _3688_/Y _3700_/Y _3701_/Y _3691_/Y _3720_/A VPWR VGND sg13cmos5l_a221oi_1
X_4682_ _4682_/Y _4682_/A _4682_/B VPWR VGND sg13cmos5l_xnor2_1
X_3633_ _3633_/Y _3083_/Y _3630_/B _3632_/Y VPWR VGND sg13cmos5l_a21oi_1
X_3564_ _3564_/Y _3564_/A _3566_/S VPWR VGND sg13cmos5l_nand2_1
X_3495_ _3495_/Y _3595_/A _3507_/B VPWR VGND sg13cmos5l_nand2_1
X_5303_ _5303_/Y _3121_/Y _5302_/B _5302_/Y VPWR VGND sg13cmos5l_o21ai_1
X_5234_ _5241_/B _5223_/Y _5230_/X _5233_/Y VPWR VGND sg13cmos5l_o21ai_1
X_5165_ _5165_/Y _5152_/Y _5165_/A2 _5266_/A VPWR VGND sg13cmos5l_a21oi_1
X_4116_ _4125_/B _4015_/Y _4052_/Y _4115_/Y _3621_/A VPWR VGND sg13cmos5l_a22oi_1
X_5096_ _5096_/Y _5119_/A _5089_/X _5100_/A _5122_/A VPWR VGND sg13cmos5l_a22oi_1
X_4047_ _4047_/Y _4045_/B _5457_/Q _4049_/A1 VPWR VGND sg13cmos5l_o21ai_1
XFILLER_24_211 VPWR VGND sg13cmos5l_decap_8
XFILLER_24_222 VPWR VGND sg13cmos5l_fill_2
X_5998_ _5998_/Q _6007_/CLK _5998_/D _5998_/RESET_B VPWR VGND sg13cmos5l_dfrbpq_1
XFILLER_40_704 VPWR VGND sg13cmos5l_decap_8
X_4949_ _4949_/Y _5983_/Q _5982_/Q VPWR VGND sg13cmos5l_xnor2_1
XFILLER_32_1028 VPWR VGND sg13cmos5l_fill_1
XFILLER_3_115 VPWR VGND sg13cmos5l_fill_2
XFILLER_47_347 VPWR VGND sg13cmos5l_decap_4
XFILLER_47_325 VPWR VGND sg13cmos5l_fill_1
XFILLER_43_542 VPWR VGND sg13cmos5l_decap_8
XFILLER_15_277 VPWR VGND sg13cmos5l_decap_4
XFILLER_48_1013 VPWR VGND sg13cmos5l_decap_8
X_3280_ _3288_/S _5409_/C _3308_/C _5390_/C VPWR VGND sg13cmos5l_nand3_1
XFILLER_2_170 VPWR VGND sg13cmos5l_fill_1
XFILLER_24_4 VPWR VGND sg13cmos5l_fill_2
XFILLER_39_804 VPWR VGND sg13cmos5l_fill_2
X_5921_ _5921_/Q _5943_/CLK _5921_/D _5921_/RESET_B VPWR VGND sg13cmos5l_dfrbpq_1
XFILLER_0_1026 VPWR VGND sg13cmos5l_fill_2
XFILLER_34_531 VPWR VGND sg13cmos5l_fill_1
XFILLER_34_553 VPWR VGND sg13cmos5l_fill_2
X_5852_ _5852_/Q _5906_/CLK _5852_/D _5852_/RESET_B VPWR VGND sg13cmos5l_dfrbpq_1
X_5783_ _5783_/Q _5822_/CLK _5783_/D _5783_/RESET_B VPWR VGND sg13cmos5l_dfrbpq_1
X_4803_ _4803_/Y _4810_/A1 _4794_/Y _4802_/Y _5988_/Q VPWR VGND sg13cmos5l_a22oi_1
X_4734_ _4748_/S _4750_/A _4743_/B _4742_/A VPWR VGND sg13cmos5l_o21ai_1
X_4665_ _4665_/Y _4665_/A _5935_/Q VPWR VGND sg13cmos5l_nand2_1
X_4596_ _4656_/D _4594_/A _4594_/B _4362_/Y VPWR VGND sg13cmos5l_o21ai_1
X_3616_ _3616_/X _3591_/A _3616_/A1 _3616_/S VPWR VGND sg13cmos5l_mux2_1
X_3547_ _5765_/D _3609_/A1 _3555_/B _3546_/Y VPWR VGND sg13cmos5l_a21oi_1
Xhold988 _3600_/A _5791_/Q VPWR VGND sg13cmos5l_dlygate4sd3_1
Xhold966 _4825_/B _5964_/Q VPWR VGND sg13cmos5l_dlygate4sd3_1
Xhold977 _4472_/B _5903_/Q VPWR VGND sg13cmos5l_dlygate4sd3_1
X_3478_ _3478_/Y _3478_/A _3481_/B VPWR VGND sg13cmos5l_nand2_1
Xhold999 _5750_/D _3515_/Y VPWR VGND sg13cmos5l_dlygate4sd3_1
X_5217_ _5218_/B _5231_/A _5231_/C _6018_/Q VPWR VGND sg13cmos5l_a21oi_1
Xhold1600 _4355_/A1 _4335_/Y VPWR VGND sg13cmos5l_dlygate4sd3_1
Xhold1622 _3724_/B _5813_/Q VPWR VGND sg13cmos5l_dlygate4sd3_1
X_5148_ _5148_/Y _5148_/A _5148_/B VPWR VGND sg13cmos5l_nor2_1
Xhold1633 _5182_/A _6061_/Q VPWR VGND sg13cmos5l_dlygate4sd3_1
Xhold1611 _4152_/B _4208_/A VPWR VGND sg13cmos5l_dlygate4sd3_1
Xhold1644 _4157_/A2 _4148_/Y VPWR VGND sg13cmos5l_dlygate4sd3_1
Xhold1666 _4226_/A _5890_/Q VPWR VGND sg13cmos5l_dlygate4sd3_1
Xhold1677 _3457_/B _5824_/Q VPWR VGND sg13cmos5l_dlygate4sd3_1
X_5079_ _5081_/B _6062_/Q _6041_/Q VPWR VGND sg13cmos5l_nand2_1
Xhold1655 _4861_/A _6000_/Q VPWR VGND sg13cmos5l_dlygate4sd3_1
XFILLER_44_35 VPWR VGND sg13cmos5l_fill_1
XFILLER_13_726 VPWR VGND sg13cmos5l_fill_2
XFILLER_12_258 VPWR VGND sg13cmos5l_fill_1
XFILLER_12_269 VPWR VGND sg13cmos5l_fill_2
XFILLER_5_18 VPWR VGND sg13cmos5l_fill_1
XFILLER_4_435 VPWR VGND sg13cmos5l_fill_1
XFILLER_4_479 VPWR VGND sg13cmos5l_fill_1
XFILLER_47_111 VPWR VGND sg13cmos5l_fill_1
XFILLER_35_328 VPWR VGND sg13cmos5l_fill_1
XFILLER_43_361 VPWR VGND sg13cmos5l_fill_1
XFILLER_16_553 VPWR VGND sg13cmos5l_fill_1
X_4450_ _4450_/Y _5944_/Q _5943_/Q VPWR VGND sg13cmos5l_nand2b_1
X_4381_ _4381_/Y _4381_/A _4381_/B VPWR VGND sg13cmos5l_nor2_1
X_3401_ _5698_/D _5420_/A1 _3401_/A1 _3407_/S VPWR VGND sg13cmos5l_mux2_1
X_3332_ _5640_/D _3393_/A0 _3332_/A1 _3336_/S VPWR VGND sg13cmos5l_mux2_1
X_6051_ _6051_/Q _6063_/CLK _6051_/D _6051_/RESET_B VPWR VGND sg13cmos5l_dfrbpq_1
X_3263_ _3263_/Y _3384_/A _3267_/S VPWR VGND sg13cmos5l_nand2_1
X_3194_ _5274_/B _3622_/A _3194_/B VPWR VGND sg13cmos5l_nor2_1
X_5002_ _6026_/D _3062_/Y _5004_/A2 _5001_/Y VPWR VGND sg13cmos5l_a21oi_1
X_5836__557 _5836_/RESET_B VPWR VGND sg13cmos5l_tiehi
XFILLER_27_807 VPWR VGND sg13cmos5l_decap_4
XFILLER_19_380 VPWR VGND sg13cmos5l_decap_8
Xclkbuf_3_5__f_clk clkbuf_3_5__f_clk/X clkbuf_0_clk/X VPWR VGND sg13cmos5l_buf_8
X_5904_ _5904_/Q _5994_/CLK _5904_/D _5904_/RESET_B VPWR VGND sg13cmos5l_dfrbpq_1
X_5835_ _5835_/Q clkload7/A _5835_/D _5835_/RESET_B VPWR VGND sg13cmos5l_dfrbpq_1
X_5766_ _5766_/Q _5834_/CLK _5766_/D _5766_/RESET_B VPWR VGND sg13cmos5l_dfrbpq_1
X_5697_ _5697_/Q clkload2/A _5697_/D _5697_/RESET_B VPWR VGND sg13cmos5l_dfrbpq_1
X_4717_ _4732_/A _4717_/A _4727_/A VPWR VGND sg13cmos5l_xnor2_1
X_4648_ _5964_/D _4998_/A _4648_/B VPWR VGND sg13cmos5l_and2_1
X_4579_ _4579_/Y _4580_/B VPWR VGND sg13cmos5l_inv_1
XFILLER_2_917 VPWR VGND sg13cmos5l_decap_8
Xhold1441 _3504_/A1 _5745_/Q VPWR VGND sg13cmos5l_dlygate4sd3_1
Xhold1452 _3236_/A0 _5563_/Q VPWR VGND sg13cmos5l_dlygate4sd3_1
Xhold1430 _5389_/A0 _5517_/Q VPWR VGND sg13cmos5l_dlygate4sd3_1
Xhold1463 _3454_/A0 _5721_/Q VPWR VGND sg13cmos5l_dlygate4sd3_1
Xhold1474 _4311_/A _5883_/Q VPWR VGND sg13cmos5l_dlygate4sd3_1
Xhold1485 _4313_/A _5885_/Q VPWR VGND sg13cmos5l_dlygate4sd3_1
Xhold1496 _4828_/A _5972_/Q VPWR VGND sg13cmos5l_dlygate4sd3_1
X_5928__441 _5928_/RESET_B VPWR VGND sg13cmos5l_tiehi
XFILLER_41_898 VPWR VGND sg13cmos5l_decap_8
XFILLER_4_276 VPWR VGND sg13cmos5l_fill_1
XFILLER_49_910 VPWR VGND sg13cmos5l_decap_8
XFILLER_48_453 VPWR VGND sg13cmos5l_decap_8
XFILLER_49_987 VPWR VGND sg13cmos5l_decap_8
X_3950_ _3950_/X _5564_/Q _5547_/Q _5530_/Q _5513_/Q _3172_/S _4053_/S1 VPWR VGND
+ sg13cmos5l_mux4_1
XFILLER_44_692 VPWR VGND sg13cmos5l_fill_2
XFILLER_32_810 VPWR VGND sg13cmos5l_fill_1
X_3881_ _3881_/Y _3881_/A _3881_/B _3881_/C VPWR VGND sg13cmos5l_nor3_1
X_5620_ _5620_/Q _5860_/CLK _5620_/D _5620_/RESET_B VPWR VGND sg13cmos5l_dfrbpq_1
X_5551_ _5551_/Q clkload4/A _5551_/D _5551_/RESET_B VPWR VGND sg13cmos5l_dfrbpq_1
X_4502_ _4504_/B _4425_/B _4393_/B _4502_/S VPWR VGND sg13cmos5l_mux2_1
X_5482_ _5482_/Q _5559_/CLK _5482_/D _5482_/RESET_B VPWR VGND sg13cmos5l_dfrbpq_1
XFILLER_6_61 VPWR VGND sg13cmos5l_fill_1
XFILLER_6_50 VPWR VGND sg13cmos5l_fill_2
XFILLER_6_72 VPWR VGND sg13cmos5l_fill_2
X_4433_ _4434_/B _5898_/Q _5943_/Q VPWR VGND sg13cmos5l_nand2_1
X_4364_ _4364_/Y _4584_/A VPWR VGND sg13cmos5l_inv_1
X_5697__723 _5697_/RESET_B VPWR VGND sg13cmos5l_tiehi
X_4295_ _4295_/X _4289_/B _4445_/B _4297_/S VPWR VGND sg13cmos5l_mux2_1
X_3315_ _5626_/D _3374_/A _3315_/A1 _3316_/S VPWR VGND sg13cmos5l_mux2_1
X_6034_ _6034_/Q _6061_/CLK _6034_/D _6034_/RESET_B VPWR VGND sg13cmos5l_dfrbpq_1
X_3246_ _5569_/D _5315_/A1 _3246_/A1 _3253_/B VPWR VGND sg13cmos5l_mux2_1
XFILLER_39_431 VPWR VGND sg13cmos5l_fill_1
X_3177_ _3177_/X _5594_/Q _5585_/Q _3178_/A VPWR VGND sg13cmos5l_mux2_1
XFILLER_39_475 VPWR VGND sg13cmos5l_decap_8
XFILLER_42_629 VPWR VGND sg13cmos5l_fill_1
X_5818_ _5818_/Q clkload8/A _5818_/D _5818_/RESET_B VPWR VGND sg13cmos5l_dfrbpq_1
XFILLER_23_898 VPWR VGND sg13cmos5l_decap_4
XFILLER_6_508 VPWR VGND sg13cmos5l_fill_1
X_5749_ _5749_/Q _6063_/CLK _5749_/D _5749_/RESET_B VPWR VGND sg13cmos5l_dfrbpq_1
XFILLER_22_397 VPWR VGND sg13cmos5l_decap_4
Xhold1260 _3293_/A1 _5606_/Q VPWR VGND sg13cmos5l_dlygate4sd3_1
XFILLER_45_445 VPWR VGND sg13cmos5l_decap_8
Xhold1282 _3313_/A1 _5624_/Q VPWR VGND sg13cmos5l_dlygate4sd3_1
Xhold1271 _5374_/A1 _5503_/Q VPWR VGND sg13cmos5l_dlygate4sd3_1
Xhold1293 _5327_/A0 _5461_/Q VPWR VGND sg13cmos5l_dlygate4sd3_1
XFILLER_32_106 VPWR VGND sg13cmos5l_fill_2
XFILLER_41_695 VPWR VGND sg13cmos5l_fill_1
XFILLER_40_150 VPWR VGND sg13cmos5l_fill_1
XFILLER_12_1026 VPWR VGND sg13cmos5l_fill_2
XFILLER_31_80 VPWR VGND sg13cmos5l_fill_1
X_3100_ _5143_/A _6064_/Q VPWR VGND sg13cmos5l_inv_1
X_4080_ _4080_/Y _4111_/A1 _4078_/Y _3918_/A VPWR VGND sg13cmos5l_o21ai_1
XFILLER_36_467 VPWR VGND sg13cmos5l_decap_8
X_4982_ _4982_/Y _5142_/B _4993_/A _4990_/A _3070_/Y VPWR VGND sg13cmos5l_a22oi_1
X_3933_ _3933_/Y _3933_/A VPWR VGND sg13cmos5l_inv_1
X_3864_ _3864_/X _3865_/A _3865_/B VPWR VGND sg13cmos5l_and2_1
XFILLER_20_824 VPWR VGND sg13cmos5l_fill_1
X_5603_ _5603_/Q _5906_/CLK _5603_/D _5603_/RESET_B VPWR VGND sg13cmos5l_dfrbpq_1
X_3795_ _5826_/D _3795_/A _3796_/B VPWR VGND sg13cmos5l_nor2b_1
X_5534_ _5534_/Q clkload4/A _5534_/D _5534_/RESET_B VPWR VGND sg13cmos5l_dfrbpq_1
X_5465_ _5465_/Q _5674_/CLK _5465_/D _5465_/RESET_B VPWR VGND sg13cmos5l_dfrbpq_1
X_4416_ _4416_/Y _4420_/B _4405_/Y _4413_/X _4247_/B VPWR VGND sg13cmos5l_a22oi_1
X_5396_ _5523_/D _3251_/A _5396_/A1 _5398_/S VPWR VGND sg13cmos5l_mux2_1
X_4347_ _4347_/Y _4335_/Y _4342_/Y _4328_/Y VPWR VGND sg13cmos5l_o21ai_1
X_5918__451 _5918_/RESET_B VPWR VGND sg13cmos5l_tiehi
X_4278_ _4278_/Y _4247_/A _4283_/B _4287_/B _5910_/Q VPWR VGND sg13cmos5l_a22oi_1
X_3229_ _5557_/D _3251_/A _3229_/A1 _3231_/S VPWR VGND sg13cmos5l_mux2_1
X_6017_ _6017_/Q _6067_/CLK _6017_/D _6017_/RESET_B VPWR VGND sg13cmos5l_dfrbpq_1
XFILLER_28_902 VPWR VGND sg13cmos5l_decap_4
XFILLER_28_957 VPWR VGND sg13cmos5l_fill_1
XFILLER_28_968 VPWR VGND sg13cmos5l_decap_4
XFILLER_43_927 VPWR VGND sg13cmos5l_decap_4
XFILLER_27_456 VPWR VGND sg13cmos5l_decap_8
XFILLER_36_69 VPWR VGND sg13cmos5l_fill_1
XFILLER_36_990 VPWR VGND sg13cmos5l_fill_2
XFILLER_10_323 VPWR VGND sg13cmos5l_fill_1
X_5925__444 _5925_/RESET_B VPWR VGND sg13cmos5l_tiehi
XFILLER_42_1019 VPWR VGND sg13cmos5l_decap_8
Xhold1090 _3553_/B1 _3552_/Y VPWR VGND sg13cmos5l_dlygate4sd3_1
XFILLER_34_916 VPWR VGND sg13cmos5l_fill_2
X_5687__733 _5687_/RESET_B VPWR VGND sg13cmos5l_tiehi
X_3580_ _3580_/Y _3580_/A _3580_/B VPWR VGND sg13cmos5l_nand2_1
X_5250_ _5250_/Y _5240_/Y _5243_/Y _5246_/A _5248_/A _5249_/Y VPWR VGND sg13cmos5l_a221oi_1
X_4201_ _4202_/B _4205_/A _4205_/B _4198_/Y _4205_/C VPWR VGND sg13cmos5l_a22oi_1
X_5181_ _5193_/B _5179_/Y _5180_/Y _5178_/Y VPWR VGND sg13cmos5l_a21oi_1
X_5694__726 _5694_/RESET_B VPWR VGND sg13cmos5l_tiehi
X_4132_ _4221_/A _4301_/B _4818_/A VPWR VGND sg13cmos5l_nand2b_1
XFILLER_3_1002 VPWR VGND sg13cmos5l_decap_8
X_4063_ _4075_/B _4063_/A _4063_/B _4063_/C VPWR VGND sg13cmos5l_nor3_1
X_4965_ _4965_/Y _6037_/Q _4977_/B _4970_/B _6036_/Q VPWR VGND sg13cmos5l_a22oi_1
X_3916_ _3916_/Y _4011_/A _3914_/X _3915_/Y VPWR VGND sg13cmos5l_o21ai_1
X_4896_ _4896_/Y _5166_/B _5007_/A VPWR VGND sg13cmos5l_nand2b_1
XFILLER_22_16 VPWR VGND sg13cmos5l_fill_1
X_3847_ _3849_/A _3847_/A _5846_/Q VPWR VGND sg13cmos5l_nor2b_1
X_3778_ _3778_/Y _3776_/Y _3778_/B VPWR VGND sg13cmos5l_nand2b_1
X_5517_ _5517_/Q clkload4/A _5517_/D _5517_/RESET_B VPWR VGND sg13cmos5l_dfrbpq_1
X_5448_ _5448_/Q _5555_/CLK _5448_/D _5448_/RESET_B VPWR VGND sg13cmos5l_dfrbpq_1
X_5379_ _5508_/D _5398_/A0 _5379_/A1 _5379_/S VPWR VGND sg13cmos5l_mux2_1
Xfanout100 _3565_/A1 _5162_/A1 VPWR VGND sg13cmos5l_buf_1
Xfanout122 _5371_/B _5837_/Q VPWR VGND sg13cmos5l_buf_1
Xfanout111 _4247_/A hold1649/X VPWR VGND sg13cmos5l_buf_1
Xfanout133 _3749_/B _3751_/S VPWR VGND sg13cmos5l_buf_1
Xfanout144 _4068_/A _4102_/A VPWR VGND sg13cmos5l_buf_1
Xfanout155 _3880_/A _4042_/A1 VPWR VGND sg13cmos5l_buf_1
XFILLER_47_518 VPWR VGND sg13cmos5l_decap_8
Xfanout177 _3178_/A _4083_/A1 VPWR VGND sg13cmos5l_buf_1
Xfanout188 _3892_/S fanout196/X VPWR VGND sg13cmos5l_buf_1
Xfanout199 _4131_/A _6074_/D VPWR VGND sg13cmos5l_buf_1
Xfanout166 _4043_/S1 fanout174/X VPWR VGND sg13cmos5l_buf_1
XFILLER_23_492 VPWR VGND sg13cmos5l_decap_8
XFILLER_10_164 VPWR VGND sg13cmos5l_decap_4
XFILLER_6_113 VPWR VGND sg13cmos5l_fill_2
XFILLER_11_698 VPWR VGND sg13cmos5l_fill_2
X_5526__434 _5526_/RESET_B VPWR VGND sg13cmos5l_tiehi
XFILLER_19_732 VPWR VGND sg13cmos5l_fill_1
XFILLER_34_702 VPWR VGND sg13cmos5l_fill_1
XFILLER_37_90 VPWR VGND sg13cmos5l_fill_2
XFILLER_18_1021 VPWR VGND sg13cmos5l_decap_8
X_4750_ _4750_/X _4750_/A _4750_/B VPWR VGND sg13cmos5l_and2_1
X_3701_ _3701_/Y _3718_/A1 _3689_/X _3762_/A VPWR VGND sg13cmos5l_a21oi_1
X_4681_ _4682_/B _5967_/Q _4685_/B _4665_/Y VPWR VGND sg13cmos5l_a21oi_1
X_3632_ _3632_/Y _3083_/Y _3630_/B _3744_/A VPWR VGND sg13cmos5l_o21ai_1
X_5908__461 _5908_/RESET_B VPWR VGND sg13cmos5l_tiehi
X_3563_ _5773_/D _3613_/A1 _3567_/B _3562_/Y VPWR VGND sg13cmos5l_o21ai_1
X_5302_ _5302_/Y _5302_/A _5302_/B VPWR VGND sg13cmos5l_nand2_1
XFILLER_45_0 VPWR VGND sg13cmos5l_fill_2
X_3494_ _3494_/Y _3518_/A1 _3493_/B _3494_/B1 VPWR VGND sg13cmos5l_o21ai_1
X_5233_ _5233_/Y _5118_/B _5228_/X _5251_/B _5252_/A VPWR VGND sg13cmos5l_a22oi_1
X_5164_ _5164_/Y _3064_/A _5164_/B VPWR VGND sg13cmos5l_nand2b_1
X_4115_ _4115_/Y _3908_/Y _4094_/Y _4114_/X _3620_/B _4075_/Y VPWR VGND sg13cmos5l_a221oi_1
X_5095_ _5122_/A _6045_/Q _5095_/B VPWR VGND sg13cmos5l_xnor2_1
X_5475__606 _5475_/RESET_B VPWR VGND sg13cmos5l_tiehi
X_5915__454 _5915_/RESET_B VPWR VGND sg13cmos5l_tiehi
X_4046_ _4046_/Y _4045_/B _5491_/Q _4045_/Y VPWR VGND sg13cmos5l_o21ai_1
XFILLER_12_407 VPWR VGND sg13cmos5l_fill_1
X_5997_ _5997_/Q _6007_/CLK _5997_/D _5997_/RESET_B VPWR VGND sg13cmos5l_dfrbpq_1
X_4948_ _4948_/Y _6004_/Q _5982_/Q VPWR VGND sg13cmos5l_nor2_1
X_4879_ _4880_/B _4879_/A _4879_/B VPWR VGND sg13cmos5l_xnor2_1
XFILLER_20_462 VPWR VGND sg13cmos5l_decap_8
X_5922__447 _5922_/RESET_B VPWR VGND sg13cmos5l_tiehi
XFILLER_3_138 VPWR VGND sg13cmos5l_fill_2
XFILLER_0_801 VPWR VGND sg13cmos5l_fill_2
XFILLER_0_823 VPWR VGND sg13cmos5l_decap_8
X_5677__743 _5677_/RESET_B VPWR VGND sg13cmos5l_tiehi
XFILLER_28_540 VPWR VGND sg13cmos5l_decap_8
XFILLER_43_510 VPWR VGND sg13cmos5l_fill_1
X_6046__954 _6046_/RESET_B VPWR VGND sg13cmos5l_tiehi
XFILLER_8_901 VPWR VGND sg13cmos5l_decap_8
XFILLER_12_952 VPWR VGND sg13cmos5l_fill_2
X_5684__736 _5684_/RESET_B VPWR VGND sg13cmos5l_tiehi
XFILLER_12_996 VPWR VGND sg13cmos5l_fill_2
XFILLER_8_967 VPWR VGND sg13cmos5l_decap_4
XFILLER_31_6 VPWR VGND sg13cmos5l_fill_1
XFILLER_17_4 VPWR VGND sg13cmos5l_fill_2
X_5691__729 _5691_/RESET_B VPWR VGND sg13cmos5l_tiehi
X_5920_ _5920_/Q _5943_/CLK _5920_/D _5920_/RESET_B VPWR VGND sg13cmos5l_dfrbpq_1
XFILLER_0_1005 VPWR VGND sg13cmos5l_decap_8
X_5851_ _5851_/Q _6080_/CLK _5851_/D _5851_/RESET_B VPWR VGND sg13cmos5l_dfrbpq_1
XFILLER_34_565 VPWR VGND sg13cmos5l_fill_2
X_5782_ _5782_/Q _5822_/CLK _5782_/D _5782_/RESET_B VPWR VGND sg13cmos5l_dfrbpq_1
XFILLER_21_226 VPWR VGND sg13cmos5l_fill_1
X_4802_ _4802_/Y _4639_/A _4800_/X _4801_/Y _4796_/C VPWR VGND sg13cmos5l_a22oi_1
X_4733_ _4742_/A _4733_/A _4733_/B _4733_/C VPWR VGND sg13cmos5l_or3_1
X_4664_ _4664_/X _4598_/B _4560_/B _4689_/S VPWR VGND sg13cmos5l_mux2_1
X_4595_ _4656_/C _4594_/A _4600_/B _4595_/C VPWR VGND sg13cmos5l_nand3b_1
X_3615_ _3615_/Y _3615_/A1 _3616_/S _3614_/Y VPWR VGND sg13cmos5l_o21ai_1
X_3546_ _3546_/Y _3546_/A _3555_/B VPWR VGND sg13cmos5l_nor2_1
Xhold989 _5791_/D _3601_/Y VPWR VGND sg13cmos5l_dlygate4sd3_1
Xhold967 _4649_/B _5934_/Q VPWR VGND sg13cmos5l_dlygate4sd3_1
Xhold978 _3108_/A _5858_/Q VPWR VGND sg13cmos5l_dlygate4sd3_1
X_5216_ _5226_/B _5212_/Y _5215_/X _4916_/Y VPWR VGND sg13cmos5l_o21ai_1
X_3477_ _3477_/Y _3501_/A1 _3480_/S _3477_/B1 VPWR VGND sg13cmos5l_o21ai_1
Xhold1601 _4593_/A _5923_/Q VPWR VGND sg13cmos5l_dlygate4sd3_1
Xhold1612 _4407_/A _5891_/Q VPWR VGND sg13cmos5l_dlygate4sd3_1
Xhold1634 _5273_/A2 _5197_/B VPWR VGND sg13cmos5l_dlygate4sd3_1
X_5147_ _5147_/Y _5147_/A _6067_/Q VPWR VGND sg13cmos5l_nor2_1
Xhold1623 _4505_/A _5936_/Q VPWR VGND sg13cmos5l_dlygate4sd3_1
X_5078_ _5078_/Y _5089_/B _5078_/B VPWR VGND sg13cmos5l_nand2_1
Xhold1678 _3519_/A _5827_/Q VPWR VGND sg13cmos5l_dlygate4sd3_1
Xhold1645 hold1645/X _5826_/Q VPWR VGND sg13cmos5l_dlygate4sd3_1
X_5852__530 _5852_/RESET_B VPWR VGND sg13cmos5l_tiehi
Xhold1656 _4862_/B _4861_/Y VPWR VGND sg13cmos5l_dlygate4sd3_1
Xhold1667 _4771_/A _5950_/Q VPWR VGND sg13cmos5l_dlygate4sd3_1
X_4029_ _4029_/X _5455_/Q _5438_/Q _4029_/S VPWR VGND sg13cmos5l_mux2_1
XFILLER_38_860 VPWR VGND sg13cmos5l_fill_1
X_5989__374 _5989_/RESET_B VPWR VGND sg13cmos5l_tiehi
XFILLER_25_576 VPWR VGND sg13cmos5l_decap_4
XFILLER_5_926 VPWR VGND sg13cmos5l_decap_8
XFILLER_4_469 VPWR VGND sg13cmos5l_fill_2
XFILLER_16_510 VPWR VGND sg13cmos5l_fill_1
X_5860__309 _5860_/D VPWR VGND sg13cmos5l_tielo
XFILLER_8_775 VPWR VGND sg13cmos5l_fill_1
X_5905__464 _5905_/RESET_B VPWR VGND sg13cmos5l_tiehi
X_4380_ _4380_/Y _4396_/B VPWR VGND sg13cmos5l_inv_1
X_3400_ _5697_/D _5419_/A1 _3400_/A1 _3407_/S VPWR VGND sg13cmos5l_mux2_1
X_3331_ _5639_/D _3392_/A0 _3331_/A1 _3336_/S VPWR VGND sg13cmos5l_mux2_1
XFILLER_4_992 VPWR VGND sg13cmos5l_decap_8
X_6050_ _6050_/Q _6063_/CLK _6050_/D _6050_/RESET_B VPWR VGND sg13cmos5l_dfrbpq_1
X_3262_ _5581_/D _3116_/Y _3266_/S _3261_/Y VPWR VGND sg13cmos5l_o21ai_1
X_3193_ _6078_/D _4131_/A _3193_/B VPWR VGND sg13cmos5l_nor2_1
X_5001_ _5001_/Y _5001_/A1 _5004_/A2 _5007_/A VPWR VGND sg13cmos5l_o21ai_1
XFILLER_22_1028 VPWR VGND sg13cmos5l_fill_1
XFILLER_39_668 VPWR VGND sg13cmos5l_fill_2
X_5912__457 _5912_/RESET_B VPWR VGND sg13cmos5l_tiehi
X_5903_ _5903_/Q _5994_/CLK _5903_/D _5903_/RESET_B VPWR VGND sg13cmos5l_dfrbpq_1
X_5834_ _5834_/Q _5834_/CLK _5834_/D _5834_/RESET_B VPWR VGND sg13cmos5l_dfrbpq_1
XFILLER_22_502 VPWR VGND sg13cmos5l_fill_1
XFILLER_22_513 VPWR VGND sg13cmos5l_decap_4
XFILLER_22_557 VPWR VGND sg13cmos5l_fill_1
X_5765_ _5765_/Q _5834_/CLK _5765_/D _5765_/RESET_B VPWR VGND sg13cmos5l_dfrbpq_1
X_5696_ _5696_/Q _5810_/CLK _5696_/D _5696_/RESET_B VPWR VGND sg13cmos5l_dfrbpq_1
X_5667__753 _5667_/RESET_B VPWR VGND sg13cmos5l_tiehi
X_4716_ _4729_/B _5979_/Q _5980_/Q _5978_/Q _5977_/Q VPWR VGND sg13cmos5l_nor4_1
X_4647_ _5963_/D _3072_/Y _5003_/A2 _4646_/Y VPWR VGND sg13cmos5l_a21oi_1
X_4578_ _4580_/B _5922_/Q _4584_/B VPWR VGND sg13cmos5l_xor2_1
X_3529_ _3529_/Y _3565_/A1 _3528_/B _3529_/B1 VPWR VGND sg13cmos5l_o21ai_1
Xhold1431 _5378_/A1 _5507_/Q VPWR VGND sg13cmos5l_dlygate4sd3_1
Xhold1442 _3234_/A0 _5561_/Q VPWR VGND sg13cmos5l_dlygate4sd3_1
Xhold1420 _3224_/A1 _5552_/Q VPWR VGND sg13cmos5l_dlygate4sd3_1
Xhold1453 _3336_/A1 _5644_/Q VPWR VGND sg13cmos5l_dlygate4sd3_1
Xhold1486 _3684_/A2 _5810_/Q VPWR VGND sg13cmos5l_dlygate4sd3_1
Xhold1464 _5721_/D _3454_/X VPWR VGND sg13cmos5l_dlygate4sd3_1
X_5674__746 _5674_/RESET_B VPWR VGND sg13cmos5l_tiehi
Xhold1475 _3093_/A _5912_/Q VPWR VGND sg13cmos5l_dlygate4sd3_1
Xhold1497 _5284_/A _6080_/Q VPWR VGND sg13cmos5l_dlygate4sd3_1
XFILLER_44_159 VPWR VGND sg13cmos5l_fill_2
XFILLER_26_874 VPWR VGND sg13cmos5l_fill_2
XFILLER_38_1024 VPWR VGND sg13cmos5l_decap_4
X_5887__489 _5887_/RESET_B VPWR VGND sg13cmos5l_tiehi
XFILLER_40_354 VPWR VGND sg13cmos5l_fill_1
X_6043__957 _6043_/RESET_B VPWR VGND sg13cmos5l_tiehi
X_5681__739 _5681_/RESET_B VPWR VGND sg13cmos5l_tiehi
XFILLER_45_1028 VPWR VGND sg13cmos5l_fill_1
XFILLER_1_995 VPWR VGND sg13cmos5l_decap_8
XFILLER_49_966 VPWR VGND sg13cmos5l_decap_8
XFILLER_48_432 VPWR VGND sg13cmos5l_decap_8
X_5501__554 _5501_/RESET_B VPWR VGND sg13cmos5l_tiehi
XFILLER_32_866 VPWR VGND sg13cmos5l_fill_1
X_3880_ _3881_/C _3880_/A _3880_/B VPWR VGND sg13cmos5l_nor2_1
XFILLER_12_590 VPWR VGND sg13cmos5l_fill_1
X_5550_ _5550_/Q clkload9/A _5550_/D _5550_/RESET_B VPWR VGND sg13cmos5l_dfrbpq_1
X_5481_ _5481_/Q _5559_/CLK _5481_/D _5481_/RESET_B VPWR VGND sg13cmos5l_dfrbpq_1
X_4501_ _4519_/A _4510_/B _4501_/B VPWR VGND sg13cmos5l_nor2_1
X_4432_ _4432_/Y _5897_/Q _4653_/A _4652_/A _5896_/Q _4431_/Y VPWR VGND sg13cmos5l_a221oi_1
X_4363_ _4584_/A _5942_/Q _5941_/Q VPWR VGND sg13cmos5l_xnor2_1
X_5979__384 _5979_/RESET_B VPWR VGND sg13cmos5l_tiehi
X_4294_ _4297_/S _5898_/Q _4294_/B VPWR VGND sg13cmos5l_nor2_1
X_3314_ _5625_/D _3251_/A _3314_/A1 _3316_/S VPWR VGND sg13cmos5l_mux2_1
X_6033_ _6033_/Q _6037_/CLK _6033_/D _6033_/RESET_B VPWR VGND sg13cmos5l_dfrbpq_1
X_3245_ _3255_/S _3824_/A _3824_/B _5409_/C _3308_/C VPWR VGND sg13cmos5l_nand4_1
X_3176_ _3176_/Y _4086_/A1 _3174_/Y _3175_/Y VPWR VGND sg13cmos5l_o21ai_1
XFILLER_27_627 VPWR VGND sg13cmos5l_decap_4
XFILLER_39_454 VPWR VGND sg13cmos5l_decap_8
X_5986__377 _5986_/RESET_B VPWR VGND sg13cmos5l_tiehi
X_5817_ _5817_/Q clkload8/A _5817_/D _5817_/RESET_B VPWR VGND sg13cmos5l_dfrbpq_1
X_5748_ _5748_/Q _6063_/CLK _5748_/D _5748_/RESET_B VPWR VGND sg13cmos5l_dfrbpq_1
X_5679_ _5679_/Q _5810_/CLK _5679_/D _5679_/RESET_B VPWR VGND sg13cmos5l_dfrbpq_1
Xhold1261 _3321_/A0 _5631_/Q VPWR VGND sg13cmos5l_dlygate4sd3_1
Xhold1250 _3358_/A0 _5663_/Q VPWR VGND sg13cmos5l_dlygate4sd3_1
XFILLER_46_969 VPWR VGND sg13cmos5l_decap_8
XFILLER_45_424 VPWR VGND sg13cmos5l_decap_8
Xhold1283 _3301_/A0 _5613_/Q VPWR VGND sg13cmos5l_dlygate4sd3_1
Xhold1272 _3304_/A0 _5616_/Q VPWR VGND sg13cmos5l_dlygate4sd3_1
Xhold1294 _5324_/A0 _5458_/Q VPWR VGND sg13cmos5l_dlygate4sd3_1
XFILLER_33_608 VPWR VGND sg13cmos5l_fill_1
XFILLER_14_800 VPWR VGND sg13cmos5l_fill_1
XFILLER_14_833 VPWR VGND sg13cmos5l_fill_2
XFILLER_41_674 VPWR VGND sg13cmos5l_fill_2
XFILLER_9_325 VPWR VGND sg13cmos5l_decap_4
XFILLER_49_730 VPWR VGND sg13cmos5l_decap_8
X_5657__763 _5657_/RESET_B VPWR VGND sg13cmos5l_tiehi
XFILLER_49_796 VPWR VGND sg13cmos5l_decap_4
XFILLER_36_446 VPWR VGND sg13cmos5l_decap_8
X_4981_ _4981_/Y _3070_/Y _4990_/A _4980_/Y VPWR VGND sg13cmos5l_o21ai_1
XFILLER_17_671 VPWR VGND sg13cmos5l_fill_1
X_3932_ _3933_/A _5492_/Q _5475_/Q _5458_/Q _5441_/Q _4105_/S _4107_/B1 VPWR VGND
+ sg13cmos5l_mux4_1
X_3863_ _5849_/D _4160_/B _3863_/A2 _3857_/A VPWR VGND sg13cmos5l_a21oi_1
X_5602_ _5602_/Q _5864_/CLK _5602_/D _5602_/RESET_B VPWR VGND sg13cmos5l_dfrbpq_1
X_3794_ _3795_/A _3569_/B _3793_/A _3417_/C VPWR VGND sg13cmos5l_o21ai_1
X_5533_ _5533_/Q clkload9/A _5533_/D _5533_/RESET_B VPWR VGND sg13cmos5l_dfrbpq_1
X_5664__756 _5664_/RESET_B VPWR VGND sg13cmos5l_tiehi
X_5464_ _5464_/Q _5559_/CLK _5464_/D _5464_/RESET_B VPWR VGND sg13cmos5l_dfrbpq_1
X_4415_ _4415_/Y _4247_/B _4413_/X _4414_/X VPWR VGND sg13cmos5l_o21ai_1
X_5395_ _5522_/D _5414_/A0 _5395_/A1 _5398_/S VPWR VGND sg13cmos5l_mux2_1
XFILLER_28_1023 VPWR VGND sg13cmos5l_fill_1
X_4346_ _4346_/Y _4346_/A _4346_/B VPWR VGND sg13cmos5l_nor2_1
X_5877__499 _5877_/RESET_B VPWR VGND sg13cmos5l_tiehi
X_4277_ _4277_/Y _4477_/A _5871_/Q VPWR VGND sg13cmos5l_nand2_1
X_3228_ _5556_/D _3382_/A _3228_/A1 _3231_/S VPWR VGND sg13cmos5l_mux2_1
X_6016_ _6016_/Q _6067_/CLK _6016_/D _6016_/RESET_B VPWR VGND sg13cmos5l_dfrbpq_1
X_3159_ _3159_/Y _6071_/Q _6072_/Q _3159_/C _3159_/D VPWR VGND sg13cmos5l_nor4_1
X_5671__749 _5671_/RESET_B VPWR VGND sg13cmos5l_tiehi
XFILLER_43_939 VPWR VGND sg13cmos5l_fill_1
XFILLER_36_980 VPWR VGND sg13cmos5l_fill_2
XFILLER_42_449 VPWR VGND sg13cmos5l_decap_8
Xclkbuf_leaf_34_clk clkload7/A clkbuf_leaf_4_clk/A VPWR VGND sg13cmos5l_buf_8
XFILLER_23_641 VPWR VGND sg13cmos5l_fill_1
X_5849__535 _5849_/RESET_B VPWR VGND sg13cmos5l_tiehi
X_6021__337 _6021_/RESET_B VPWR VGND sg13cmos5l_tiehi
Xhold1080 _3083_/A _5836_/Q VPWR VGND sg13cmos5l_dlygate4sd3_1
Xhold1091 _5768_/D _3553_/Y VPWR VGND sg13cmos5l_dlygate4sd3_1
Xclkbuf_leaf_25_clk _6056_/CLK clkbuf_3_5__f_clk/X VPWR VGND sg13cmos5l_buf_8
X_5969__394 _5969_/RESET_B VPWR VGND sg13cmos5l_tiehi
XFILLER_6_873 VPWR VGND sg13cmos5l_fill_2
XFILLER_47_4 VPWR VGND sg13cmos5l_fill_2
X_4200_ _4205_/C _4200_/A _4200_/B _4200_/C VPWR VGND sg13cmos5l_nand3_1
X_5180_ _5180_/Y _6054_/Q _6028_/Q VPWR VGND sg13cmos5l_xnor2_1
X_5976__387 _5976_/RESET_B VPWR VGND sg13cmos5l_tiehi
X_4131_ _4193_/B _4131_/A _4301_/B VPWR VGND sg13cmos5l_nor2_1
X_4062_ _4063_/C _4068_/A _4062_/B _4062_/C VPWR VGND sg13cmos5l_nor3_1
XFILLER_18_991 VPWR VGND sg13cmos5l_fill_1
X_4964_ _6017_/D _4964_/A _5053_/B VPWR VGND sg13cmos5l_nor2_1
XFILLER_36_298 VPWR VGND sg13cmos5l_fill_2
Xclkbuf_leaf_16_clk _5936_/CLK clkbuf_3_6__f_clk/X VPWR VGND sg13cmos5l_buf_8
X_3915_ _3915_/Y _4041_/A _3915_/B VPWR VGND sg13cmos5l_nor2_1
XFILLER_32_460 VPWR VGND sg13cmos5l_fill_1
X_4895_ _5011_/B _5278_/A _5166_/B VPWR VGND sg13cmos5l_nor2_1
X_3846_ _3851_/B _4207_/A _4193_/A VPWR VGND sg13cmos5l_nor2b_1
X_3777_ _3778_/B _5816_/Q _5815_/Q _3782_/D VPWR VGND sg13cmos5l_nand3_1
X_5516_ _5516_/Q clkload9/A _5516_/D _5516_/RESET_B VPWR VGND sg13cmos5l_dfrbpq_1
X_5447_ _5447_/Q _5559_/CLK _5447_/D _5447_/RESET_B VPWR VGND sg13cmos5l_dfrbpq_1
X_5378_ _5507_/D _5416_/A0 _5378_/A1 _5379_/S VPWR VGND sg13cmos5l_mux2_1
Xfanout112 _4410_/A _5911_/Q VPWR VGND sg13cmos5l_buf_1
Xfanout101 _5162_/A1 _3065_/Y VPWR VGND sg13cmos5l_buf_1
X_4329_ _4330_/A _4338_/B _4336_/B VPWR VGND sg13cmos5l_nand2_1
Xfanout134 _3734_/S _3751_/S VPWR VGND sg13cmos5l_buf_1
Xfanout123 _3569_/B hold1645/X VPWR VGND sg13cmos5l_buf_1
Xfanout145 _4102_/A _5804_/Q VPWR VGND sg13cmos5l_buf_1
Xfanout156 _4042_/A1 _3111_/A VPWR VGND sg13cmos5l_buf_1
Xfanout189 _4022_/B _4029_/S VPWR VGND sg13cmos5l_buf_1
Xfanout178 _4089_/B _4085_/S VPWR VGND sg13cmos5l_buf_1
Xfanout167 _4098_/A1 _4099_/A1 VPWR VGND sg13cmos5l_buf_1
XFILLER_43_714 VPWR VGND sg13cmos5l_fill_1
XFILLER_16_939 VPWR VGND sg13cmos5l_fill_1
XFILLER_43_758 VPWR VGND sg13cmos5l_decap_8
XFILLER_23_471 VPWR VGND sg13cmos5l_decap_8
XFILLER_10_143 VPWR VGND sg13cmos5l_fill_1
XFILLER_6_158 VPWR VGND sg13cmos5l_fill_2
X_5647__773 _5647_/RESET_B VPWR VGND sg13cmos5l_tiehi
X_5467__883 _5467_/RESET_B VPWR VGND sg13cmos5l_tiehi
XFILLER_5_0 VPWR VGND sg13cmos5l_fill_2
XFILLER_46_541 VPWR VGND sg13cmos5l_fill_2
XFILLER_19_777 VPWR VGND sg13cmos5l_fill_1
X_5654__766 _5654_/RESET_B VPWR VGND sg13cmos5l_tiehi
XFILLER_46_596 VPWR VGND sg13cmos5l_decap_4
XFILLER_18_1000 VPWR VGND sg13cmos5l_decap_8
X_3700_ _3700_/Y _3718_/A1 _3686_/X _3714_/A VPWR VGND sg13cmos5l_a21oi_1
XFILLER_15_994 VPWR VGND sg13cmos5l_decap_4
XFILLER_30_931 VPWR VGND sg13cmos5l_fill_2
X_4680_ _4696_/A _4688_/B VPWR VGND sg13cmos5l_inv_1
X_3631_ _5803_/D _5430_/A _5430_/B VPWR VGND sg13cmos5l_nor2_1
X_3562_ _3562_/Y _3562_/A _3567_/B VPWR VGND sg13cmos5l_nand2_1
X_5301_ _5439_/D _5301_/A0 _5359_/A0 _5301_/S VPWR VGND sg13cmos5l_mux2_1
X_5661__759 _5661_/RESET_B VPWR VGND sg13cmos5l_tiehi
X_3493_ _3493_/Y _3493_/A _3493_/B VPWR VGND sg13cmos5l_nand2_1
X_5232_ _5251_/B _5232_/A _5232_/B VPWR VGND sg13cmos5l_or2_1
Xclkbuf_leaf_5_clk _5853_/CLK clkbuf_leaf_6_clk/A VPWR VGND sg13cmos5l_buf_8
X_5163_ _6050_/D _5266_/A _5163_/B VPWR VGND sg13cmos5l_nor2_1
X_4114_ _4114_/X _4099_/Y _4102_/Y _4113_/Y VPWR VGND sg13cmos5l_a21o_1
X_5094_ _5103_/B _6045_/Q _5095_/B VPWR VGND sg13cmos5l_nor2b_1
X_4045_ _4045_/Y _5474_/Q _4045_/B VPWR VGND sg13cmos5l_nand2b_1
X_5996_ _5996_/Q _6056_/CLK _5996_/D _5996_/RESET_B VPWR VGND sg13cmos5l_dfrbpq_1
X_4947_ _4947_/Y _4785_/A _5983_/Q VPWR VGND sg13cmos5l_nand2b_1
XFILLER_20_441 VPWR VGND sg13cmos5l_decap_8
X_4878_ _4879_/B _4878_/A _4878_/B VPWR VGND sg13cmos5l_xor2_1
X_3829_ _5361_/D _5304_/A _5304_/B VPWR VGND sg13cmos5l_nand2_1
XFILLER_15_202 VPWR VGND sg13cmos5l_fill_2
XFILLER_28_585 VPWR VGND sg13cmos5l_fill_2
XFILLER_31_717 VPWR VGND sg13cmos5l_fill_1
XFILLER_43_599 VPWR VGND sg13cmos5l_decap_8
XFILLER_12_920 VPWR VGND sg13cmos5l_fill_2
XFILLER_12_931 VPWR VGND sg13cmos5l_decap_8
XFILLER_23_290 VPWR VGND sg13cmos5l_fill_2
X_5966__397 _5966_/RESET_B VPWR VGND sg13cmos5l_tiehi
XFILLER_3_684 VPWR VGND sg13cmos5l_fill_2
XFILLER_48_90 VPWR VGND sg13cmos5l_fill_1
XFILLER_47_872 VPWR VGND sg13cmos5l_decap_8
XFILLER_0_1028 VPWR VGND sg13cmos5l_fill_1
X_5850_ _5850_/Q _5906_/CLK _5850_/D _5850_/RESET_B VPWR VGND sg13cmos5l_dfrbpq_1
XFILLER_34_555 VPWR VGND sg13cmos5l_fill_1
X_5781_ _5781_/Q clkload7/A _5781_/D _5781_/RESET_B VPWR VGND sg13cmos5l_dfrbpq_1
X_4801_ _4801_/Y _5009_/A _4801_/B VPWR VGND sg13cmos5l_nor2_1
X_4732_ _4733_/C _4732_/A _4732_/B VPWR VGND sg13cmos5l_nor2_1
X_4663_ _4689_/S _4659_/Y _4661_/Y _4662_/Y VPWR VGND sg13cmos5l_o21ai_1
X_3614_ _3614_/Y _3614_/A _3616_/S VPWR VGND sg13cmos5l_nand2_1
X_4594_ _4603_/S _4594_/A _4594_/B VPWR VGND sg13cmos5l_nor2_1
X_3545_ _3554_/S _3582_/A _3545_/B _3545_/C VPWR VGND sg13cmos5l_nor3_1
X_3476_ _3476_/Y _3476_/A _3480_/S VPWR VGND sg13cmos5l_nand2_1
Xhold979 _5880_/D _4192_/Y VPWR VGND sg13cmos5l_dlygate4sd3_1
Xhold968 _4193_/A _5860_/Q VPWR VGND sg13cmos5l_dlygate4sd3_1
X_5215_ _5215_/X _5205_/Y _5213_/X _5214_/Y VPWR VGND sg13cmos5l_a21o_1
Xhold1602 _4606_/B _4693_/B VPWR VGND sg13cmos5l_dlygate4sd3_1
Xhold1635 _5106_/A _6062_/Q VPWR VGND sg13cmos5l_dlygate4sd3_1
X_5146_ _5146_/Y _6048_/Q _5140_/B _5145_/Y _6049_/Q _5141_/Y VPWR VGND sg13cmos5l_a221oi_1
Xhold1613 _4936_/A _6040_/Q VPWR VGND sg13cmos5l_dlygate4sd3_1
Xhold1624 hold1624/X _5839_/Q VPWR VGND sg13cmos5l_dlygate4sd3_1
Xhold1646 _4267_/A _5865_/Q VPWR VGND sg13cmos5l_dlygate4sd3_1
X_5077_ _5077_/X _5089_/B _5078_/B VPWR VGND sg13cmos5l_and2_1
Xhold1657 _4953_/A _5986_/Q VPWR VGND sg13cmos5l_dlygate4sd3_1
Xhold1668 hold1668/X _6005_/Q VPWR VGND sg13cmos5l_dlygate4sd3_1
Xhold1679 _3569_/A _5827_/Q VPWR VGND sg13cmos5l_dlygate4sd3_1
X_6069__922 _6069_/RESET_B VPWR VGND sg13cmos5l_tiehi
X_4028_ _4028_/Y _4029_/S _5489_/Q _4027_/Y VPWR VGND sg13cmos5l_o21ai_1
X_5637__783 _5637_/RESET_B VPWR VGND sg13cmos5l_tiehi
XFILLER_44_59 VPWR VGND sg13cmos5l_fill_1
X_5457__893 _5457_/RESET_B VPWR VGND sg13cmos5l_tiehi
X_5979_ _5979_/Q _6005_/CLK _5979_/D _5979_/RESET_B VPWR VGND sg13cmos5l_dfrbpq_1
XFILLER_40_503 VPWR VGND sg13cmos5l_decap_4
X_5644__776 _5644_/RESET_B VPWR VGND sg13cmos5l_tiehi
XFILLER_0_621 VPWR VGND sg13cmos5l_fill_1
X_5464__886 _5464_/RESET_B VPWR VGND sg13cmos5l_tiehi
X_5690__730 _5690_/RESET_B VPWR VGND sg13cmos5l_tiehi
XFILLER_44_842 VPWR VGND sg13cmos5l_fill_2
XFILLER_29_894 VPWR VGND sg13cmos5l_decap_4
XFILLER_44_853 VPWR VGND sg13cmos5l_fill_1
XFILLER_43_352 VPWR VGND sg13cmos5l_fill_2
XFILLER_43_341 VPWR VGND sg13cmos5l_fill_2
X_5651__769 _5651_/RESET_B VPWR VGND sg13cmos5l_tiehi
X_5471__879 _5471_/RESET_B VPWR VGND sg13cmos5l_tiehi
XFILLER_31_547 VPWR VGND sg13cmos5l_fill_1
XFILLER_12_761 VPWR VGND sg13cmos5l_fill_2
X_5547__939 _5547_/RESET_B VPWR VGND sg13cmos5l_tiehi
X_5799__621 _5799_/RESET_B VPWR VGND sg13cmos5l_tiehi
X_3330_ _5638_/D _3391_/A0 _3330_/A1 _3336_/S VPWR VGND sg13cmos5l_mux2_1
X_3261_ _3261_/Y _5298_/A _3267_/S VPWR VGND sg13cmos5l_nand2_1
X_5000_ _6025_/D _3063_/Y _5004_/A2 _4999_/Y VPWR VGND sg13cmos5l_a21oi_1
X_3192_ _3192_/Y _3185_/A _3622_/A _3204_/B _6076_/Q hold970/X VPWR VGND sg13cmos5l_a221oi_1
XFILLER_26_308 VPWR VGND sg13cmos5l_decap_8
XFILLER_47_691 VPWR VGND sg13cmos5l_fill_2
X_5902_ _5902_/Q _6080_/CLK _5902_/D _5902_/RESET_B VPWR VGND sg13cmos5l_dfrbpq_1
X_5833_ _5833_/Q clkload7/A _5833_/D _5833_/RESET_B VPWR VGND sg13cmos5l_dfrbpq_1
X_5764_ _5764_/Q clkload7/A _5764_/D _5764_/RESET_B VPWR VGND sg13cmos5l_dfrbpq_1
X_5695_ _5695_/Q _5695_/CLK _5695_/D _5695_/RESET_B VPWR VGND sg13cmos5l_dfrbpq_1
X_4715_ _4727_/A _5979_/Q _5978_/Q _5977_/Q VPWR VGND sg13cmos5l_or3_1
X_4646_ _4646_/Y _4491_/A _5004_/A2 _4649_/A VPWR VGND sg13cmos5l_o21ai_1
X_4577_ _4593_/B _5922_/Q _4584_/B VPWR VGND sg13cmos5l_nor2_1
X_3528_ _3528_/Y _3528_/A _3528_/B VPWR VGND sg13cmos5l_nand2_1
X_3459_ _3459_/Y _3459_/A _3468_/B VPWR VGND sg13cmos5l_nand2_1
Xhold1410 _3401_/A1 _5698_/Q VPWR VGND sg13cmos5l_dlygate4sd3_1
X_5129_ _5129_/Y _6023_/Q _6066_/Q VPWR VGND sg13cmos5l_nand2_1
Xhold1432 _5386_/A0 _5514_/Q VPWR VGND sg13cmos5l_dlygate4sd3_1
X_5991__287 _5991_/D VPWR VGND sg13cmos5l_tielo
Xhold1421 _3272_/A0 _5587_/Q VPWR VGND sg13cmos5l_dlygate4sd3_1
Xhold1443 _3621_/A _5843_/Q VPWR VGND sg13cmos5l_dlygate4sd3_1
Xhold1465 _3360_/A0 _5665_/Q VPWR VGND sg13cmos5l_dlygate4sd3_1
Xhold1454 _5405_/A0 _5531_/Q VPWR VGND sg13cmos5l_dlygate4sd3_1
Xhold1476 _4818_/B _5960_/Q VPWR VGND sg13cmos5l_dlygate4sd3_1
Xhold1498 _3089_/A _5809_/Q VPWR VGND sg13cmos5l_dlygate4sd3_1
Xhold1487 _5287_/A _6071_/Q VPWR VGND sg13cmos5l_dlygate4sd3_1
XFILLER_41_823 VPWR VGND sg13cmos5l_decap_4
XFILLER_41_867 VPWR VGND sg13cmos5l_fill_2
XFILLER_40_377 VPWR VGND sg13cmos5l_fill_2
XFILLER_40_399 VPWR VGND sg13cmos5l_fill_2
XFILLER_5_746 VPWR VGND sg13cmos5l_fill_1
XFILLER_4_267 VPWR VGND sg13cmos5l_decap_8
XFILLER_4_234 VPWR VGND sg13cmos5l_fill_1
XFILLER_45_1007 VPWR VGND sg13cmos5l_decap_8
XFILLER_48_411 VPWR VGND sg13cmos5l_decap_8
XFILLER_1_974 VPWR VGND sg13cmos5l_decap_8
XFILLER_49_945 VPWR VGND sg13cmos5l_decap_8
XFILLER_36_617 VPWR VGND sg13cmos5l_fill_1
XFILLER_48_488 VPWR VGND sg13cmos5l_decap_8
XFILLER_44_650 VPWR VGND sg13cmos5l_decap_8
XFILLER_44_661 VPWR VGND sg13cmos5l_fill_2
XFILLER_16_363 VPWR VGND sg13cmos5l_fill_2
XFILLER_16_396 VPWR VGND sg13cmos5l_fill_1
X_5480_ _5480_/Q _5559_/CLK _5480_/D _5480_/RESET_B VPWR VGND sg13cmos5l_dfrbpq_1
XFILLER_8_562 VPWR VGND sg13cmos5l_fill_2
X_4500_ _4501_/B _4500_/A _4500_/B VPWR VGND sg13cmos5l_xnor2_1
X_4431_ _4431_/Y _4442_/B _5941_/Q _5940_/Q _4445_/B VPWR VGND sg13cmos5l_a22oi_1
X_6059__932 _6059_/RESET_B VPWR VGND sg13cmos5l_tiehi
X_4362_ _4362_/Y _4651_/A _4400_/A VPWR VGND sg13cmos5l_nand2_1
X_5627__793 _5627_/RESET_B VPWR VGND sg13cmos5l_tiehi
X_4293_ _4294_/B _4299_/B _4290_/Y _4292_/Y VPWR VGND sg13cmos5l_o21ai_1
X_3313_ _5624_/D _5357_/A0 _3313_/A1 _3316_/S VPWR VGND sg13cmos5l_mux2_1
X_6032_ _6032_/Q _6037_/CLK _6032_/D _6032_/RESET_B VPWR VGND sg13cmos5l_dfrbpq_1
X_3244_ _3317_/D _5352_/A _5352_/B VPWR VGND sg13cmos5l_nand2b_1
X_3175_ _3175_/Y _4076_/S1 _3172_/X _4071_/A VPWR VGND sg13cmos5l_a21oi_1
X_6066__925 _6066_/RESET_B VPWR VGND sg13cmos5l_tiehi
X_5634__786 _5634_/RESET_B VPWR VGND sg13cmos5l_tiehi
X_5816_ _5816_/Q clkload8/A _5816_/D _5816_/RESET_B VPWR VGND sg13cmos5l_dfrbpq_1
X_5454__896 _5454_/RESET_B VPWR VGND sg13cmos5l_tiehi
X_5886__490 _5886_/RESET_B VPWR VGND sg13cmos5l_tiehi
X_5747_ _5747_/Q _6063_/CLK _5747_/D _5747_/RESET_B VPWR VGND sg13cmos5l_dfrbpq_1
X_5678_ _5678_/Q _5695_/CLK _5678_/D _5678_/RESET_B VPWR VGND sg13cmos5l_dfrbpq_1
X_5680__740 _5680_/RESET_B VPWR VGND sg13cmos5l_tiehi
X_4629_ _4631_/B _4625_/Y _4626_/Y _4628_/Y VPWR VGND sg13cmos5l_o21ai_1
X_5641__779 _5641_/RESET_B VPWR VGND sg13cmos5l_tiehi
X_5461__889 _5461_/RESET_B VPWR VGND sg13cmos5l_tiehi
X_5893__483 _5893_/RESET_B VPWR VGND sg13cmos5l_tiehi
Xhold1251 _5376_/A1 _5505_/Q VPWR VGND sg13cmos5l_dlygate4sd3_1
Xhold1240 _5348_/A0 _5480_/Q VPWR VGND sg13cmos5l_dlygate4sd3_1
Xhold1284 _3376_/A1 _5678_/Q VPWR VGND sg13cmos5l_dlygate4sd3_1
XFILLER_46_948 VPWR VGND sg13cmos5l_decap_8
XFILLER_45_414 VPWR VGND sg13cmos5l_decap_4
XFILLER_18_628 VPWR VGND sg13cmos5l_fill_1
Xhold1262 _5328_/A0 _5462_/Q VPWR VGND sg13cmos5l_dlygate4sd3_1
Xhold1273 _5375_/A1 _5504_/Q VPWR VGND sg13cmos5l_dlygate4sd3_1
Xhold1295 _5353_/A1 _5484_/Q VPWR VGND sg13cmos5l_dlygate4sd3_1
X_5789__631 _5789_/RESET_B VPWR VGND sg13cmos5l_tiehi
XFILLER_32_108 VPWR VGND sg13cmos5l_fill_1
XFILLER_41_620 VPWR VGND sg13cmos5l_fill_2
XFILLER_14_889 VPWR VGND sg13cmos5l_decap_4
X_5529__400 _5529_/RESET_B VPWR VGND sg13cmos5l_tiehi
X_5928__295 _5928_/D VPWR VGND sg13cmos5l_tielo
XFILLER_5_532 VPWR VGND sg13cmos5l_fill_2
XFILLER_12_1028 VPWR VGND sg13cmos5l_fill_1
X_5902__468 _5902_/RESET_B VPWR VGND sg13cmos5l_tiehi
X_5796__624 _5796_/RESET_B VPWR VGND sg13cmos5l_tiehi
XFILLER_49_775 VPWR VGND sg13cmos5l_decap_8
XFILLER_49_753 VPWR VGND sg13cmos5l_decap_8
XFILLER_37_915 VPWR VGND sg13cmos5l_decap_4
XFILLER_37_959 VPWR VGND sg13cmos5l_decap_8
X_4980_ _4980_/Y _6019_/Q _4980_/B VPWR VGND sg13cmos5l_nand2_1
X_3931_ _3937_/B _3931_/A _3931_/B _3931_/C VPWR VGND sg13cmos5l_nor3_1
X_3862_ _5848_/D _3859_/Y _3861_/Y _3857_/A VPWR VGND sg13cmos5l_a21oi_1
X_5601_ _5601_/Q _5864_/CLK _5601_/D _5601_/RESET_B VPWR VGND sg13cmos5l_dfrbpq_1
X_3793_ _5825_/D _3793_/A _3793_/B VPWR VGND sg13cmos5l_nor2_1
X_5532_ _5532_/Q clkload2/A _5532_/D _5532_/RESET_B VPWR VGND sg13cmos5l_dfrbpq_1
X_5463_ _5463_/Q _5559_/CLK _5463_/D _5463_/RESET_B VPWR VGND sg13cmos5l_dfrbpq_1
X_4414_ _4414_/X _4413_/B _4426_/B _4229_/Y VPWR VGND sg13cmos5l_a21o_1
X_5394_ _5521_/D _5413_/A0 _5394_/A1 _5398_/S VPWR VGND sg13cmos5l_mux2_1
X_4345_ _4346_/B _5908_/Q _4345_/B VPWR VGND sg13cmos5l_nand2_1
X_4276_ _5893_/D _4314_/B _4336_/B VPWR VGND sg13cmos5l_nor2_1
X_5992__371 _5992_/RESET_B VPWR VGND sg13cmos5l_tiehi
X_6015_ _6015_/Q _6061_/CLK _6015_/D _6015_/RESET_B VPWR VGND sg13cmos5l_dfrbpq_1
X_3227_ _5555_/D _5421_/A1 _3227_/A1 _3231_/S VPWR VGND sg13cmos5l_mux2_1
X_3158_ _3159_/D _5432_/B _6080_/Q VPWR VGND sg13cmos5l_nand2_1
XFILLER_43_918 VPWR VGND sg13cmos5l_fill_1
X_3089_ _3089_/Y _3089_/A VPWR VGND sg13cmos5l_inv_1
XFILLER_22_174 VPWR VGND sg13cmos5l_fill_2
XFILLER_2_535 VPWR VGND sg13cmos5l_fill_2
XFILLER_46_723 VPWR VGND sg13cmos5l_decap_8
XFILLER_19_937 VPWR VGND sg13cmos5l_fill_2
Xhold1070 _3612_/A _5797_/Q VPWR VGND sg13cmos5l_dlygate4sd3_1
Xhold1081 _5804_/D _3633_/Y VPWR VGND sg13cmos5l_dlygate4sd3_1
Xhold1092 _3536_/A _5760_/Q VPWR VGND sg13cmos5l_dlygate4sd3_1
XFILLER_33_406 VPWR VGND sg13cmos5l_fill_2
XFILLER_33_428 VPWR VGND sg13cmos5l_fill_2
X_5531__367 _5531_/RESET_B VPWR VGND sg13cmos5l_tiehi
XFILLER_41_472 VPWR VGND sg13cmos5l_decap_8
XFILLER_10_881 VPWR VGND sg13cmos5l_decap_8
X_4130_ _4130_/Y _3857_/B _4128_/Y _3857_/A VPWR VGND sg13cmos5l_a21oi_1
X_5624__796 _5624_/RESET_B VPWR VGND sg13cmos5l_tiehi
XFILLER_3_42 VPWR VGND sg13cmos5l_fill_1
X_4061_ _4062_/C _4061_/A _4061_/B VPWR VGND sg13cmos5l_nor2_1
XFILLER_49_583 VPWR VGND sg13cmos5l_decap_8
XFILLER_37_712 VPWR VGND sg13cmos5l_fill_2
XFILLER_18_981 VPWR VGND sg13cmos5l_fill_2
X_5670__750 _5670_/RESET_B VPWR VGND sg13cmos5l_tiehi
X_4963_ _5053_/B _4943_/Y _4963_/A2 _4750_/X VPWR VGND sg13cmos5l_a21oi_1
XFILLER_24_439 VPWR VGND sg13cmos5l_decap_8
X_3914_ _3914_/X _5692_/Q _5675_/Q _5658_/Q _5641_/Q _4022_/B _4031_/A1 VPWR VGND
+ sg13cmos5l_mux4_1
X_6063__928 _6063_/RESET_B VPWR VGND sg13cmos5l_tiehi
X_5631__789 _5631_/RESET_B VPWR VGND sg13cmos5l_tiehi
XFILLER_20_612 VPWR VGND sg13cmos5l_fill_2
X_4894_ _6007_/D _4883_/A _4890_/A _4893_/Y VPWR VGND sg13cmos5l_a21oi_1
XFILLER_33_995 VPWR VGND sg13cmos5l_decap_8
X_3845_ _3857_/A _4182_/B _4190_/A VPWR VGND sg13cmos5l_nand2b_1
X_5451__899 _5451_/RESET_B VPWR VGND sg13cmos5l_tiehi
X_3776_ _3776_/Y _5816_/Q _5815_/Q _3776_/C VPWR VGND sg13cmos5l_nor3_1
X_5883__493 _5883_/RESET_B VPWR VGND sg13cmos5l_tiehi
X_5515_ _5515_/Q clkload2/A _5515_/D _5515_/RESET_B VPWR VGND sg13cmos5l_dfrbpq_1
X_5446_ _5446_/Q _5674_/CLK _5446_/D _5446_/RESET_B VPWR VGND sg13cmos5l_dfrbpq_1
X_5377_ _5506_/D _3251_/A _5377_/A1 _5379_/S VPWR VGND sg13cmos5l_mux2_1
Xfanout102 _3518_/A1 _3064_/Y VPWR VGND sg13cmos5l_buf_1
X_5779__641 _5779_/RESET_B VPWR VGND sg13cmos5l_tiehi
Xfanout113 _4003_/A _4063_/A VPWR VGND sg13cmos5l_buf_1
Xfanout124 _3582_/A hold1632/X VPWR VGND sg13cmos5l_buf_1
Xfanout135 _3726_/A1 _3751_/S VPWR VGND sg13cmos5l_buf_1
Xfanout146 _3881_/A _4012_/A VPWR VGND sg13cmos5l_buf_1
X_4328_ _4328_/Y _4328_/A _4335_/A _4328_/C VPWR VGND sg13cmos5l_nand3_1
X_4259_ _4259_/Y _5884_/Q _4256_/Y _4257_/Y _4258_/Y VPWR VGND sg13cmos5l_a22oi_1
Xfanout179 _4085_/S _4083_/A1 VPWR VGND sg13cmos5l_buf_1
Xfanout157 _3111_/A _5803_/Q VPWR VGND sg13cmos5l_buf_1
Xfanout168 _4099_/A1 fanout174/X VPWR VGND sg13cmos5l_buf_1
X_5890__486 _5890_/RESET_B VPWR VGND sg13cmos5l_tiehi
XFILLER_27_244 VPWR VGND sg13cmos5l_fill_1
X_5519__476 _5519_/RESET_B VPWR VGND sg13cmos5l_tiehi
XFILLER_23_450 VPWR VGND sg13cmos5l_decap_8
XFILLER_24_951 VPWR VGND sg13cmos5l_decap_8
X_5786__634 _5786_/RESET_B VPWR VGND sg13cmos5l_tiehi
X_6079__935 _6079_/RESET_B VPWR VGND sg13cmos5l_tiehi
XFILLER_3_855 VPWR VGND sg13cmos5l_fill_1
XFILLER_3_833 VPWR VGND sg13cmos5l_decap_8
X_5793__627 _5793_/RESET_B VPWR VGND sg13cmos5l_tiehi
XFILLER_46_520 VPWR VGND sg13cmos5l_decap_8
XFILLER_46_575 VPWR VGND sg13cmos5l_decap_8
XFILLER_37_92 VPWR VGND sg13cmos5l_fill_1
XFILLER_15_973 VPWR VGND sg13cmos5l_decap_8
X_3630_ _5430_/B _3744_/A _3630_/B VPWR VGND sg13cmos5l_nand2_1
X_5982__381 _5982_/RESET_B VPWR VGND sg13cmos5l_tiehi
X_3561_ _5772_/D _3611_/A1 _3567_/B _3560_/Y VPWR VGND sg13cmos5l_o21ai_1
X_5300_ _5438_/D _5300_/A0 _3384_/A _5301_/S VPWR VGND sg13cmos5l_mux2_1
X_3492_ _3492_/X _3440_/A _3492_/A1 _3493_/B VPWR VGND sg13cmos5l_mux2_1
X_5231_ _5232_/B _5231_/A _6018_/Q _5231_/C VPWR VGND sg13cmos5l_nor3_1
X_5162_ _5163_/B _5149_/Y _5162_/A1 _5162_/S VPWR VGND sg13cmos5l_mux2_1
X_5093_ _5100_/A _6066_/Q _5093_/B VPWR VGND sg13cmos5l_xor2_1
X_4113_ _4113_/Y _4104_/Y _4106_/Y _4112_/Y VPWR VGND sg13cmos5l_a21oi_1
XFILLER_49_380 VPWR VGND sg13cmos5l_decap_8
X_4044_ _4044_/Y _4101_/A _4044_/B VPWR VGND sg13cmos5l_nor2_1
X_5538__329 _5538_/RESET_B VPWR VGND sg13cmos5l_tiehi
XFILLER_24_247 VPWR VGND sg13cmos5l_fill_2
X_5995_ _5995_/Q _6007_/CLK _5995_/D _5995_/RESET_B VPWR VGND sg13cmos5l_dfrbpq_1
XFILLER_40_718 VPWR VGND sg13cmos5l_fill_1
X_4946_ _4946_/X _4951_/B _4951_/C _4951_/A VPWR VGND sg13cmos5l_a21o_1
X_5846__539 _5846_/RESET_B VPWR VGND sg13cmos5l_tiehi
X_4877_ _4883_/A _4877_/A _4877_/B VPWR VGND sg13cmos5l_nor2_1
XFILLER_32_291 VPWR VGND sg13cmos5l_fill_2
X_3828_ _5839_/D _5428_/A _3828_/B _3828_/C VPWR VGND sg13cmos5l_nor3_1
X_3759_ _3759_/Y _3760_/A1 _3755_/X _3138_/Y VPWR VGND sg13cmos5l_o21ai_1
XFILLER_4_608 VPWR VGND sg13cmos5l_fill_1
X_5429_ _5834_/D _5429_/A _5429_/B VPWR VGND sg13cmos5l_nor2_1
XFILLER_0_836 VPWR VGND sg13cmos5l_decap_8
XFILLER_48_829 VPWR VGND sg13cmos5l_decap_8
XFILLER_16_704 VPWR VGND sg13cmos5l_fill_2
XFILLER_12_954 VPWR VGND sg13cmos5l_fill_1
XFILLER_12_965 VPWR VGND sg13cmos5l_fill_2
XFILLER_7_413 VPWR VGND sg13cmos5l_fill_1
XFILLER_11_475 VPWR VGND sg13cmos5l_fill_1
XFILLER_12_998 VPWR VGND sg13cmos5l_fill_1
XFILLER_7_435 VPWR VGND sg13cmos5l_fill_2
XFILLER_48_1027 VPWR VGND sg13cmos5l_fill_2
X_5660__760 _5660_/RESET_B VPWR VGND sg13cmos5l_tiehi
X_5621__799 _5621_/RESET_B VPWR VGND sg13cmos5l_tiehi
XFILLER_38_339 VPWR VGND sg13cmos5l_fill_1
X_4800_ _4800_/X _5956_/Q _4800_/B VPWR VGND sg13cmos5l_and2_1
X_5780_ _5780_/Q _5825_/CLK _5780_/D _5780_/RESET_B VPWR VGND sg13cmos5l_dfrbpq_1
X_5769__651 _5769_/RESET_B VPWR VGND sg13cmos5l_tiehi
X_4731_ _4733_/B _4750_/A _4743_/B VPWR VGND sg13cmos5l_and2_1
X_4662_ _4662_/Y _4693_/A _4693_/B VPWR VGND sg13cmos5l_nand2b_1
X_3613_ _5797_/D _3613_/A1 _3617_/B _3612_/Y VPWR VGND sg13cmos5l_o21ai_1
X_4593_ _4600_/B _4593_/A _4593_/B VPWR VGND sg13cmos5l_xnor2_1
X_3544_ _5764_/D _3618_/A1 _3543_/B _3543_/Y VPWR VGND sg13cmos5l_a21oi_1
X_5880__496 _5880_/RESET_B VPWR VGND sg13cmos5l_tiehi
X_3475_ _5730_/D _5158_/A1 _3481_/B _3474_/Y VPWR VGND sg13cmos5l_o21ai_1
Xhold969 _5882_/D _4193_/X VPWR VGND sg13cmos5l_dlygate4sd3_1
X_5214_ _5214_/Y _6017_/Q _5201_/B _3147_/Y VPWR VGND sg13cmos5l_o21ai_1
X_5776__644 _5776_/RESET_B VPWR VGND sg13cmos5l_tiehi
Xhold1603 _3415_/A _5827_/Q VPWR VGND sg13cmos5l_dlygate4sd3_1
X_5145_ _5145_/Y _5145_/A VPWR VGND sg13cmos5l_inv_1
Xhold1625 _4924_/A _6009_/Q VPWR VGND sg13cmos5l_dlygate4sd3_1
Xhold1614 hold1614/X _6053_/Q VPWR VGND sg13cmos5l_dlygate4sd3_1
Xhold1669 _4557_/A _5945_/Q VPWR VGND sg13cmos5l_dlygate4sd3_1
X_5076_ _5078_/B _6041_/Q _6042_/Q _6043_/Q VPWR VGND sg13cmos5l_o21ai_1
Xhold1636 _5109_/B _5108_/A VPWR VGND sg13cmos5l_dlygate4sd3_1
Xhold1658 _4963_/A2 _4953_/Y VPWR VGND sg13cmos5l_dlygate4sd3_1
Xhold1647 _4327_/A _5906_/Q VPWR VGND sg13cmos5l_dlygate4sd3_1
X_4027_ _4027_/Y _5472_/Q _4029_/S VPWR VGND sg13cmos5l_nand2b_1
XFILLER_25_523 VPWR VGND sg13cmos5l_fill_1
XFILLER_25_589 VPWR VGND sg13cmos5l_fill_2
X_5978_ _5978_/Q _6005_/CLK _5978_/D _5978_/RESET_B VPWR VGND sg13cmos5l_dfrbpq_1
X_4929_ _5015_/B _5174_/A _4932_/B _4924_/C _4924_/B VPWR VGND sg13cmos5l_a22oi_1
XFILLER_12_239 VPWR VGND sg13cmos5l_fill_1
X_5783__637 _5783_/RESET_B VPWR VGND sg13cmos5l_tiehi
XFILLER_21_751 VPWR VGND sg13cmos5l_fill_1
X_5972__391 _5972_/RESET_B VPWR VGND sg13cmos5l_tiehi
XFILLER_16_501 VPWR VGND sg13cmos5l_fill_2
XFILLER_8_799 VPWR VGND sg13cmos5l_decap_8
X_3260_ _5580_/D _3260_/A0 _5375_/A0 _3267_/S VPWR VGND sg13cmos5l_mux2_1
X_3191_ _3204_/B _3191_/A _5279_/C VPWR VGND sg13cmos5l_nor2_1
XFILLER_22_4 VPWR VGND sg13cmos5l_fill_2
XFILLER_39_626 VPWR VGND sg13cmos5l_fill_2
X_5901_ _5901_/Q _6080_/CLK _5901_/D _5901_/RESET_B VPWR VGND sg13cmos5l_dfrbpq_1
XFILLER_19_394 VPWR VGND sg13cmos5l_decap_8
X_5832_ _5832_/Q clkload3/A _5832_/D _5832_/RESET_B VPWR VGND sg13cmos5l_dfrbpq_1
X_5763_ _5763_/Q _5834_/CLK _5763_/D _5763_/RESET_B VPWR VGND sg13cmos5l_dfrbpq_1
X_4714_ _4714_/Y _5008_/A _4750_/A VPWR VGND sg13cmos5l_nand2_1
X_5694_ _5694_/Q _5695_/CLK _5694_/D _5694_/RESET_B VPWR VGND sg13cmos5l_dfrbpq_1
X_4645_ _5962_/D _3073_/Y _5004_/A2 _4644_/Y VPWR VGND sg13cmos5l_a21oi_1
X_4576_ _4584_/B _5921_/Q _5920_/Q _5919_/Q VPWR VGND sg13cmos5l_or3_1
X_3527_ _3527_/Y _3613_/A1 _3528_/B _3526_/Y VPWR VGND sg13cmos5l_o21ai_1
X_3458_ _3467_/S _3445_/C _3607_/A VPWR VGND sg13cmos5l_nand2b_1
Xhold1400 _5392_/A1 _5519_/Q VPWR VGND sg13cmos5l_dlygate4sd3_1
X_6017__343 _6017_/RESET_B VPWR VGND sg13cmos5l_tiehi
X_3389_ _3397_/S _3389_/A _5352_/D _3398_/D VPWR VGND sg13cmos5l_nand3_1
Xhold1433 _3397_/A1 _5695_/Q VPWR VGND sg13cmos5l_dlygate4sd3_1
Xhold1411 _3338_/A0 _5645_/Q VPWR VGND sg13cmos5l_dlygate4sd3_1
X_5128_ _5128_/Y _6021_/Q _5143_/A _5127_/Y VPWR VGND sg13cmos5l_o21ai_1
Xhold1422 _3323_/A0 _5633_/Q VPWR VGND sg13cmos5l_dlygate4sd3_1
Xhold1455 _5366_/A0 _5496_/Q VPWR VGND sg13cmos5l_dlygate4sd3_1
Xhold1466 _4128_/A _5854_/Q VPWR VGND sg13cmos5l_dlygate4sd3_1
Xhold1444 _3281_/A1 _5595_/Q VPWR VGND sg13cmos5l_dlygate4sd3_1
Xhold1477 _4173_/A _5869_/Q VPWR VGND sg13cmos5l_dlygate4sd3_1
X_5059_ _5059_/Y _6035_/Q _5059_/B _5059_/C VPWR VGND sg13cmos5l_nor3_1
Xhold1488 _6071_/D _5286_/Y VPWR VGND sg13cmos5l_dlygate4sd3_1
Xhold1499 _4475_/A _5910_/Q VPWR VGND sg13cmos5l_dlygate4sd3_1
XFILLER_26_898 VPWR VGND sg13cmos5l_decap_8
X_5650__770 _5650_/RESET_B VPWR VGND sg13cmos5l_tiehi
XFILLER_41_879 VPWR VGND sg13cmos5l_fill_2
X_5470__880 _5470_/RESET_B VPWR VGND sg13cmos5l_tiehi
XFILLER_1_931 VPWR VGND sg13cmos5l_decap_4
XFILLER_1_953 VPWR VGND sg13cmos5l_decap_8
XFILLER_49_924 VPWR VGND sg13cmos5l_decap_8
X_5759__661 _5759_/RESET_B VPWR VGND sg13cmos5l_tiehi
XFILLER_48_467 VPWR VGND sg13cmos5l_decap_8
XFILLER_32_857 VPWR VGND sg13cmos5l_fill_2
XFILLER_31_356 VPWR VGND sg13cmos5l_fill_1
XFILLER_32_879 VPWR VGND sg13cmos5l_decap_8
XFILLER_12_581 VPWR VGND sg13cmos5l_fill_1
X_5766__654 _5766_/RESET_B VPWR VGND sg13cmos5l_tiehi
X_4430_ _4430_/Y _5897_/Q _4653_/A VPWR VGND sg13cmos5l_nor2_1
XFILLER_6_20 VPWR VGND sg13cmos5l_fill_2
X_4361_ _4400_/A _5944_/Q _4361_/B VPWR VGND sg13cmos5l_xnor2_1
XFILLER_6_97 VPWR VGND sg13cmos5l_fill_2
X_3312_ _5623_/D _5356_/A0 _3312_/A1 _3316_/S VPWR VGND sg13cmos5l_mux2_1
X_4292_ _4292_/Y _4285_/Y _4289_/Y _4291_/Y VPWR VGND sg13cmos5l_o21ai_1
X_6031_ _6031_/Q _6037_/CLK _6031_/D _6031_/RESET_B VPWR VGND sg13cmos5l_dfrbpq_1
X_3243_ _3308_/C _5352_/A _5352_/B VPWR VGND sg13cmos5l_nor2b_1
XFILLER_6_1013 VPWR VGND sg13cmos5l_decap_8
X_3174_ _3174_/Y _3178_/A _5687_/Q _3173_/Y VPWR VGND sg13cmos5l_a21oi_1
X_5773__647 _5773_/RESET_B VPWR VGND sg13cmos5l_tiehi
XFILLER_39_489 VPWR VGND sg13cmos5l_decap_8
X_5815_ _5815_/Q clkload8/A _5815_/D _5815_/RESET_B VPWR VGND sg13cmos5l_dfrbpq_1
XFILLER_22_334 VPWR VGND sg13cmos5l_fill_2
XFILLER_22_367 VPWR VGND sg13cmos5l_fill_2
X_5746_ _5746_/Q _6063_/CLK _5746_/D _5746_/RESET_B VPWR VGND sg13cmos5l_dfrbpq_1
X_5677_ _5677_/Q _5695_/CLK _5677_/D _5677_/RESET_B VPWR VGND sg13cmos5l_dfrbpq_1
X_4628_ _4628_/Y _5957_/Q _4617_/Y _4627_/Y _4639_/B VPWR VGND sg13cmos5l_a22oi_1
X_4559_ _4560_/B _4656_/A _4656_/B VPWR VGND sg13cmos5l_and2_1
Xhold1230 _3353_/A1 _5659_/Q VPWR VGND sg13cmos5l_dlygate4sd3_1
Xhold1252 _3279_/A0 _5594_/Q VPWR VGND sg13cmos5l_dlygate4sd3_1
Xhold1241 _3566_/A1 _5775_/Q VPWR VGND sg13cmos5l_dlygate4sd3_1
Xhold1285 _5402_/A0 _5528_/Q VPWR VGND sg13cmos5l_dlygate4sd3_1
Xhold1263 _5307_/A1 _5443_/Q VPWR VGND sg13cmos5l_dlygate4sd3_1
Xhold1274 _3370_/A1 _5674_/Q VPWR VGND sg13cmos5l_dlygate4sd3_1
XFILLER_45_459 VPWR VGND sg13cmos5l_decap_8
Xhold1296 _3237_/A0 _5564_/Q VPWR VGND sg13cmos5l_dlygate4sd3_1
XFILLER_14_824 VPWR VGND sg13cmos5l_fill_1
XFILLER_15_62 VPWR VGND sg13cmos5l_fill_2
XFILLER_41_687 VPWR VGND sg13cmos5l_fill_2
XFILLER_37_905 VPWR VGND sg13cmos5l_decap_4
X_3930_ _3931_/C _4067_/A _3930_/B VPWR VGND sg13cmos5l_nor2_1
XFILLER_45_993 VPWR VGND sg13cmos5l_decap_8
XFILLER_44_492 VPWR VGND sg13cmos5l_decap_8
X_3861_ _3861_/Y _4207_/A _3863_/A2 _4207_/B VPWR VGND sg13cmos5l_o21ai_1
X_5600_ _5600_/Q _5692_/CLK _5600_/D _5600_/RESET_B VPWR VGND sg13cmos5l_dfrbpq_1
X_3792_ _3793_/B _3582_/A _3791_/A _3417_/C VPWR VGND sg13cmos5l_o21ai_1
X_5531_ _5531_/Q clkload1/A _5531_/D _5531_/RESET_B VPWR VGND sg13cmos5l_dfrbpq_1
X_6007__353 _6007_/RESET_B VPWR VGND sg13cmos5l_tiehi
XFILLER_9_883 VPWR VGND sg13cmos5l_fill_2
X_5462_ _5462_/Q _5674_/CLK _5462_/D _5462_/RESET_B VPWR VGND sg13cmos5l_dfrbpq_1
X_4413_ _4413_/X _5894_/Q _4413_/B VPWR VGND sg13cmos5l_xor2_1
X_5393_ _5520_/D _5412_/A0 _5393_/A1 _5398_/S VPWR VGND sg13cmos5l_mux2_1
X_4344_ _4351_/B _4246_/B _4343_/B _4343_/Y VPWR VGND sg13cmos5l_a21oi_1
X_5482__592 _5482_/RESET_B VPWR VGND sg13cmos5l_tiehi
X_4275_ _4336_/B _4275_/A _4275_/B VPWR VGND sg13cmos5l_nor2_1
X_6014_ _6014_/Q _6061_/CLK _6014_/D _6014_/RESET_B VPWR VGND sg13cmos5l_dfrbpq_1
X_5640__780 _5640_/RESET_B VPWR VGND sg13cmos5l_tiehi
X_5460__890 _5460_/RESET_B VPWR VGND sg13cmos5l_tiehi
X_3226_ _5554_/D _5374_/A0 _3226_/A1 _3231_/S VPWR VGND sg13cmos5l_mux2_1
X_6014__346 _6014_/RESET_B VPWR VGND sg13cmos5l_tiehi
X_3157_ _3157_/Y _5287_/A _5287_/B _3159_/C VPWR VGND sg13cmos5l_nor3_1
XFILLER_28_927 VPWR VGND sg13cmos5l_decap_8
XFILLER_28_949 VPWR VGND sg13cmos5l_fill_1
X_3088_ _3724_/A input4/X VPWR VGND sg13cmos5l_inv_1
XFILLER_10_348 VPWR VGND sg13cmos5l_decap_8
XFILLER_10_337 VPWR VGND sg13cmos5l_fill_2
X_5729_ _5729_/Q _5825_/CLK _5729_/D _5729_/RESET_B VPWR VGND sg13cmos5l_dfrbpq_1
X_5749__671 _5749_/RESET_B VPWR VGND sg13cmos5l_tiehi
Xhold1060 _3494_/B1 _3493_/Y VPWR VGND sg13cmos5l_dlygate4sd3_1
X_5756__664 _5756_/RESET_B VPWR VGND sg13cmos5l_tiehi
XFILLER_46_768 VPWR VGND sg13cmos5l_fill_2
Xhold1082 _3119_/A _5676_/Q VPWR VGND sg13cmos5l_dlygate4sd3_1
Xhold1071 _3567_/A _5776_/Q VPWR VGND sg13cmos5l_dlygate4sd3_1
Xhold1093 _3434_/A _5712_/Q VPWR VGND sg13cmos5l_dlygate4sd3_1
XFILLER_42_941 VPWR VGND sg13cmos5l_decap_8
XFILLER_41_451 VPWR VGND sg13cmos5l_decap_8
XFILLER_9_157 VPWR VGND sg13cmos5l_decap_8
XFILLER_6_831 VPWR VGND sg13cmos5l_decap_4
X_5763__657 _5763_/RESET_B VPWR VGND sg13cmos5l_tiehi
X_6056__936 _6056_/RESET_B VPWR VGND sg13cmos5l_tiehi
X_4060_ _4061_/B _5697_/Q _5680_/Q _5663_/Q _5646_/Q _4085_/S _4091_/A1 VPWR VGND
+ sg13cmos5l_mux4_1
XFILLER_49_562 VPWR VGND sg13cmos5l_decap_8
XFILLER_3_1027 VPWR VGND sg13cmos5l_fill_2
XFILLER_3_1016 VPWR VGND sg13cmos5l_decap_8
XFILLER_37_757 VPWR VGND sg13cmos5l_fill_2
XFILLER_18_960 VPWR VGND sg13cmos5l_fill_1
X_4962_ _6016_/D _4964_/A _5048_/A VPWR VGND sg13cmos5l_nor2_1
X_3913_ _3915_/B _4040_/S1 _3909_/X _3912_/Y VPWR VGND sg13cmos5l_a21oi_1
X_4893_ _4893_/Y _4893_/A1 _4890_/A _4783_/A VPWR VGND sg13cmos5l_o21ai_1
XFILLER_33_963 VPWR VGND sg13cmos5l_fill_2
X_3844_ _5844_/D _3844_/A _3844_/B VPWR VGND sg13cmos5l_nor2_1
XFILLER_20_646 VPWR VGND sg13cmos5l_fill_2
X_3775_ _5816_/D _5428_/A _3775_/B VPWR VGND sg13cmos5l_nor2_1
X_5514_ _5514_/Q clkload1/A _5514_/D _5514_/RESET_B VPWR VGND sg13cmos5l_dfrbpq_1
X_5445_ _5445_/Q _5674_/CLK _5445_/D _5445_/RESET_B VPWR VGND sg13cmos5l_dfrbpq_1
X_5376_ _5505_/D _5414_/A0 _5376_/A1 _5379_/S VPWR VGND sg13cmos5l_mux2_1
Xfanout103 _3618_/A1 _3064_/Y VPWR VGND sg13cmos5l_buf_1
Xfanout125 _3714_/A _5808_/Q VPWR VGND sg13cmos5l_buf_1
Xfanout136 _3751_/S fanout142/X VPWR VGND sg13cmos5l_buf_1
Xfanout114 _4063_/A _5841_/Q VPWR VGND sg13cmos5l_buf_1
X_4327_ _4328_/C _4327_/A _4327_/B VPWR VGND sg13cmos5l_or2_1
Xfanout147 _4041_/A _4012_/A VPWR VGND sg13cmos5l_buf_1
XFILLER_47_16 VPWR VGND sg13cmos5l_fill_2
X_4258_ _4258_/Y _5883_/Q _5865_/Q VPWR VGND sg13cmos5l_nor2_1
XFILLER_41_1011 VPWR VGND sg13cmos5l_decap_8
Xfanout158 _4076_/S1 fanout162/X VPWR VGND sg13cmos5l_buf_1
Xfanout169 _4031_/A1 _4039_/A1 VPWR VGND sg13cmos5l_buf_1
X_3209_ _3209_/Y _5304_/C _3824_/C VPWR VGND sg13cmos5l_nand2_1
X_4189_ _5877_/D _4190_/A _4189_/B VPWR VGND sg13cmos5l_and2_1
XFILLER_27_223 VPWR VGND sg13cmos5l_fill_2
XFILLER_43_705 VPWR VGND sg13cmos5l_decap_8
XFILLER_24_985 VPWR VGND sg13cmos5l_decap_8
XFILLER_19_713 VPWR VGND sg13cmos5l_fill_1
XFILLER_46_554 VPWR VGND sg13cmos5l_decap_8
XFILLER_18_256 VPWR VGND sg13cmos5l_fill_2
XFILLER_15_941 VPWR VGND sg13cmos5l_fill_2
XFILLER_14_484 VPWR VGND sg13cmos5l_fill_2
X_5630__790 _5630_/RESET_B VPWR VGND sg13cmos5l_tiehi
X_3560_ _3560_/Y _3560_/A _3567_/B VPWR VGND sg13cmos5l_nand2_1
X_6004__356 _6004_/RESET_B VPWR VGND sg13cmos5l_tiehi
X_5230_ _5230_/X _5113_/X _5220_/A _5229_/Y VPWR VGND sg13cmos5l_a21o_1
X_3491_ _3491_/Y _3615_/A1 _3490_/B _3490_/Y VPWR VGND sg13cmos5l_o21ai_1
X_5161_ _5161_/Y _3066_/Y _5162_/S _5160_/Y VPWR VGND sg13cmos5l_a21oi_1
X_5092_ _5098_/B _6065_/Q _6066_/Q _6064_/Q _5138_/B VPWR VGND sg13cmos5l_nor4_1
X_4112_ _4112_/Y _4108_/Y _4111_/Y _4102_/A VPWR VGND sg13cmos5l_o21ai_1
X_4043_ _4044_/B _5559_/Q _5542_/Q _5525_/Q _5508_/Q _4069_/S0 _4043_/S1 VPWR VGND
+ sg13cmos5l_mux4_1
X_5739__681 _5739_/RESET_B VPWR VGND sg13cmos5l_tiehi
X_6011__349 _6011_/RESET_B VPWR VGND sg13cmos5l_tiehi
X_5994_ _5994_/Q _5994_/CLK _5994_/D _5994_/RESET_B VPWR VGND sg13cmos5l_dfrbpq_1
X_4945_ _4951_/C _5983_/Q _5982_/Q _4945_/B1 VPWR VGND sg13cmos5l_o21ai_1
X_4876_ _4876_/Y _4866_/Y _4869_/Y _4871_/X _4891_/A _4875_/Y VPWR VGND sg13cmos5l_a221oi_1
X_3827_ _3828_/C _5304_/B _5304_/D VPWR VGND sg13cmos5l_and2_1
X_3758_ _3763_/A _3720_/A _3756_/X _3757_/Y _3752_/X _3714_/A VPWR VGND sg13cmos5l_a221oi_1
X_5746__674 _5746_/RESET_B VPWR VGND sg13cmos5l_tiehi
X_3689_ _3689_/X _5713_/Q _5707_/Q _3731_/S VPWR VGND sg13cmos5l_mux2_1
X_5428_ _5833_/D _5428_/A _5428_/B _5428_/C VPWR VGND sg13cmos5l_nor3_1
X_5359_ _5490_/D _5359_/A0 _5359_/A1 _5360_/S VPWR VGND sg13cmos5l_mux2_1
X_5753__667 _5753_/RESET_B VPWR VGND sg13cmos5l_tiehi
XFILLER_16_716 VPWR VGND sg13cmos5l_fill_1
XFILLER_28_554 VPWR VGND sg13cmos5l_decap_4
XFILLER_16_727 VPWR VGND sg13cmos5l_fill_2
XFILLER_15_248 VPWR VGND sg13cmos5l_fill_1
XFILLER_12_922 VPWR VGND sg13cmos5l_fill_1
XFILLER_23_292 VPWR VGND sg13cmos5l_fill_1
XFILLER_8_948 VPWR VGND sg13cmos5l_fill_2
XFILLER_8_937 VPWR VGND sg13cmos5l_fill_2
XFILLER_48_1006 VPWR VGND sg13cmos5l_decap_8
XFILLER_3_686 VPWR VGND sg13cmos5l_fill_1
XFILLER_19_543 VPWR VGND sg13cmos5l_fill_2
XFILLER_0_1019 VPWR VGND sg13cmos5l_decap_8
X_4730_ _4730_/Y _4743_/B VPWR VGND sg13cmos5l_inv_1
X_4661_ _4661_/Y _4570_/A _4604_/B _4660_/Y VPWR VGND sg13cmos5l_o21ai_1
X_3612_ _3612_/Y _3612_/A _3617_/B VPWR VGND sg13cmos5l_nand2_1
XFILLER_30_785 VPWR VGND sg13cmos5l_fill_1
X_5845__540 _5845_/RESET_B VPWR VGND sg13cmos5l_tiehi
X_4592_ _4594_/B _4593_/A _4593_/B VPWR VGND sg13cmos5l_xor2_1
X_3543_ _3543_/Y _3543_/A _3543_/B VPWR VGND sg13cmos5l_nor2_1
XFILLER_43_0 VPWR VGND sg13cmos5l_fill_2
X_3474_ _3474_/Y _3474_/A _3481_/B VPWR VGND sg13cmos5l_nand2_1
X_5213_ _5213_/X _5226_/A _5231_/C VPWR VGND sg13cmos5l_or2_1
XFILLER_9_1000 VPWR VGND sg13cmos5l_fill_2
X_5144_ _5145_/A _5148_/B _5143_/Y _5142_/Y VPWR VGND sg13cmos5l_a21o_1
Xhold1604 _3797_/B _3796_/Y VPWR VGND sg13cmos5l_dlygate4sd3_1
Xhold1626 _4926_/A _4924_/Y VPWR VGND sg13cmos5l_dlygate4sd3_1
Xhold1615 _4203_/A _5880_/Q VPWR VGND sg13cmos5l_dlygate4sd3_1
Xhold1648 _4595_/C _5919_/Q VPWR VGND sg13cmos5l_dlygate4sd3_1
X_5075_ _5089_/B _6043_/Q _6041_/Q _6042_/Q VPWR VGND sg13cmos5l_or3_1
Xhold1659 _5042_/A _6031_/Q VPWR VGND sg13cmos5l_dlygate4sd3_1
Xhold1637 _4324_/A _5909_/Q VPWR VGND sg13cmos5l_dlygate4sd3_1
X_5954__292 _5954_/D VPWR VGND sg13cmos5l_tielo
X_4026_ _4026_/Y _4021_/Y _4024_/Y _4025_/Y VPWR VGND sg13cmos5l_o21ai_1
X_5977_ _5977_/Q _6005_/CLK _5977_/D _5977_/RESET_B VPWR VGND sg13cmos5l_dfrbpq_1
X_4928_ _5015_/A _4928_/A _4928_/B _4928_/C VPWR VGND sg13cmos5l_nor3_1
XFILLER_12_229 VPWR VGND sg13cmos5l_fill_1
X_4859_ _4880_/A _4857_/X _4858_/X _4850_/Y VPWR VGND sg13cmos5l_o21ai_1
Xclkbuf_3_0__f_clk clkbuf_leaf_2_clk/A clkbuf_0_clk/X VPWR VGND sg13cmos5l_buf_8
XFILLER_0_601 VPWR VGND sg13cmos5l_fill_2
XFILLER_29_841 VPWR VGND sg13cmos5l_fill_2
XFILLER_44_844 VPWR VGND sg13cmos5l_fill_1
XFILLER_15_1027 VPWR VGND sg13cmos5l_fill_2
X_5729__691 _5729_/RESET_B VPWR VGND sg13cmos5l_tiehi
X_6001__359 _6001_/RESET_B VPWR VGND sg13cmos5l_tiehi
X_3190_ _5279_/C _3190_/A _6069_/Q VPWR VGND sg13cmos5l_or2_1
X_5736__684 _5736_/RESET_B VPWR VGND sg13cmos5l_tiehi
X_5900_ _5900_/Q _6080_/CLK _5900_/D _5900_/RESET_B VPWR VGND sg13cmos5l_dfrbpq_1
XFILLER_34_321 VPWR VGND sg13cmos5l_fill_1
X_5831_ _5831_/Q clkload3/A _5831_/D _5831_/RESET_B VPWR VGND sg13cmos5l_dfrbpq_1
X_5762_ _5762_/Q _6074_/CLK _5762_/D _5762_/RESET_B VPWR VGND sg13cmos5l_dfrbpq_1
X_4713_ _4750_/A _6008_/Q _4713_/B VPWR VGND sg13cmos5l_xnor2_1
X_5693_ _5693_/Q _5695_/CLK _5693_/D _5693_/RESET_B VPWR VGND sg13cmos5l_dfrbpq_1
X_4644_ _4644_/Y _4644_/A1 _5004_/A2 _4649_/A VPWR VGND sg13cmos5l_o21ai_1
X_4575_ _5948_/D _4638_/A _4693_/A VPWR VGND sg13cmos5l_nor2_1
X_5743__677 _5743_/RESET_B VPWR VGND sg13cmos5l_tiehi
X_3526_ _3526_/Y _3526_/A _3531_/B VPWR VGND sg13cmos5l_nand2_1
X_3457_ _3607_/A _3582_/A _3457_/B _3767_/A VPWR VGND sg13cmos5l_nor3_1
X_3388_ _5687_/D _3388_/A0 _3407_/A0 _3388_/S VPWR VGND sg13cmos5l_mux2_1
Xhold1401 _3404_/A1 _5701_/Q VPWR VGND sg13cmos5l_dlygate4sd3_1
X_5127_ _5127_/Y _6022_/Q _6065_/Q VPWR VGND sg13cmos5l_nand2b_1
Xhold1434 _5381_/A0 _5509_/Q VPWR VGND sg13cmos5l_dlygate4sd3_1
Xhold1423 _5419_/A0 _5544_/Q VPWR VGND sg13cmos5l_dlygate4sd3_1
Xhold1412 _5308_/A1 _5444_/Q VPWR VGND sg13cmos5l_dlygate4sd3_1
X_5058_ _5058_/Y _5047_/Y _5049_/X _5057_/X VPWR VGND sg13cmos5l_o21ai_1
Xhold1467 _5359_/A1 _5490_/Q VPWR VGND sg13cmos5l_dlygate4sd3_1
XFILLER_29_137 VPWR VGND sg13cmos5l_fill_2
Xhold1445 _3390_/A1 _5688_/Q VPWR VGND sg13cmos5l_dlygate4sd3_1
Xhold1456 _3329_/A1 _5637_/Q VPWR VGND sg13cmos5l_dlygate4sd3_1
Xhold1489 _5008_/A _6004_/Q VPWR VGND sg13cmos5l_dlygate4sd3_1
X_4009_ _4012_/B _4009_/A _4009_/B VPWR VGND sg13cmos5l_nor2_1
Xhold1478 _5869_/D _4177_/Y VPWR VGND sg13cmos5l_dlygate4sd3_1
XFILLER_41_803 VPWR VGND sg13cmos5l_decap_4
XFILLER_13_516 VPWR VGND sg13cmos5l_fill_1
XFILLER_26_888 VPWR VGND sg13cmos5l_fill_1
X_5492__572 _5492_/RESET_B VPWR VGND sg13cmos5l_tiehi
XFILLER_41_869 VPWR VGND sg13cmos5l_fill_1
XFILLER_21_560 VPWR VGND sg13cmos5l_fill_2
XFILLER_40_379 VPWR VGND sg13cmos5l_fill_1
XFILLER_49_903 VPWR VGND sg13cmos5l_decap_8
XFILLER_48_446 VPWR VGND sg13cmos5l_decap_8
XFILLER_17_833 VPWR VGND sg13cmos5l_decap_8
XFILLER_43_140 VPWR VGND sg13cmos5l_fill_2
XFILLER_43_184 VPWR VGND sg13cmos5l_fill_1
XFILLER_12_571 VPWR VGND sg13cmos5l_fill_1
X_4360_ _4361_/B _5942_/Q _5941_/Q _5943_/Q VPWR VGND sg13cmos5l_nor3_1
X_3311_ _5622_/D _5355_/A0 _3311_/A1 _3316_/S VPWR VGND sg13cmos5l_mux2_1
X_4291_ _4291_/Y _5896_/Q _4285_/B _4290_/Y _5897_/Q VPWR VGND sg13cmos5l_a22oi_1
X_6030_ _6030_/Q _6056_/CLK _6030_/D _6030_/RESET_B VPWR VGND sg13cmos5l_dfrbpq_1
X_3242_ _5380_/C _5371_/A _5371_/B VPWR VGND sg13cmos5l_nand2_1
X_3173_ _3173_/Y _3178_/A _5704_/Q VPWR VGND sg13cmos5l_nor2b_1
XFILLER_27_608 VPWR VGND sg13cmos5l_fill_2
XFILLER_39_468 VPWR VGND sg13cmos5l_decap_8
X_5814__601 _5814_/RESET_B VPWR VGND sg13cmos5l_tiehi
XFILLER_47_490 VPWR VGND sg13cmos5l_decap_8
X_5814_ _5814_/Q clkload8/A _5814_/D _5814_/RESET_B VPWR VGND sg13cmos5l_dfrbpq_1
XFILLER_10_508 VPWR VGND sg13cmos5l_fill_1
X_5745_ _5745_/Q _6063_/CLK _5745_/D _5745_/RESET_B VPWR VGND sg13cmos5l_dfrbpq_1
X_5676_ _5676_/Q _5692_/CLK _5676_/D _5676_/RESET_B VPWR VGND sg13cmos5l_dfrbpq_1
X_4627_ _4627_/Y _5975_/Q _4832_/A _4463_/A _5927_/Q VPWR VGND sg13cmos5l_a22oi_1
X_4558_ _4656_/B _4555_/A _4555_/B _4557_/Y VPWR VGND sg13cmos5l_o21ai_1
X_4489_ _4509_/A _5938_/Q _4505_/B VPWR VGND sg13cmos5l_xnor2_1
X_3509_ _5747_/D _3509_/A1 _3514_/B _3508_/Y VPWR VGND sg13cmos5l_o21ai_1
XFILLER_44_1020 VPWR VGND sg13cmos5l_decap_8
Xhold1220 _5363_/A0 _5493_/Q VPWR VGND sg13cmos5l_dlygate4sd3_1
Xhold1242 _5775_/D _3566_/X VPWR VGND sg13cmos5l_dlygate4sd3_1
Xhold1231 _3332_/A1 _5640_/Q VPWR VGND sg13cmos5l_dlygate4sd3_1
Xhold1264 _3380_/A0 _5681_/Q VPWR VGND sg13cmos5l_dlygate4sd3_1
Xhold1275 _3239_/A0 _5566_/Q VPWR VGND sg13cmos5l_dlygate4sd3_1
Xhold1253 _3291_/A1 _5604_/Q VPWR VGND sg13cmos5l_dlygate4sd3_1
XFILLER_45_438 VPWR VGND sg13cmos5l_decap_8
Xclkbuf_leaf_37_clk clkload3/A clkbuf_leaf_2_clk/A VPWR VGND sg13cmos5l_buf_8
Xhold1286 _5400_/A0 _5526_/Q VPWR VGND sg13cmos5l_dlygate4sd3_1
Xhold1297 _5294_/A0 _5433_/Q VPWR VGND sg13cmos5l_dlygate4sd3_1
XFILLER_41_600 VPWR VGND sg13cmos5l_decap_8
XFILLER_41_622 VPWR VGND sg13cmos5l_fill_1
XFILLER_41_611 VPWR VGND sg13cmos5l_fill_1
XFILLER_14_847 VPWR VGND sg13cmos5l_fill_1
XFILLER_25_184 VPWR VGND sg13cmos5l_fill_1
XFILLER_40_143 VPWR VGND sg13cmos5l_fill_2
XFILLER_22_880 VPWR VGND sg13cmos5l_fill_2
XFILLER_40_198 VPWR VGND sg13cmos5l_fill_1
XFILLER_5_534 VPWR VGND sg13cmos5l_fill_1
X_5726__694 _5726_/RESET_B VPWR VGND sg13cmos5l_tiehi
XFILLER_49_744 VPWR VGND sg13cmos5l_decap_4
XFILLER_36_405 VPWR VGND sg13cmos5l_fill_2
Xclkbuf_leaf_28_clk _6067_/CLK clkbuf_3_5__f_clk/X VPWR VGND sg13cmos5l_buf_8
XFILLER_17_641 VPWR VGND sg13cmos5l_fill_1
XFILLER_45_972 VPWR VGND sg13cmos5l_decap_8
X_5866__307 _5866_/D VPWR VGND sg13cmos5l_tielo
XFILLER_44_471 VPWR VGND sg13cmos5l_decap_8
X_5733__687 _5733_/RESET_B VPWR VGND sg13cmos5l_tiehi
X_3860_ _3860_/Y _5850_/Q _3860_/B VPWR VGND sg13cmos5l_nand2b_1
X_3791_ _3791_/Y _3791_/A _3791_/B VPWR VGND sg13cmos5l_nor2_1
XFILLER_32_699 VPWR VGND sg13cmos5l_fill_2
X_5530_ _5530_/Q clkload1/A _5530_/D _5530_/RESET_B VPWR VGND sg13cmos5l_dfrbpq_1
X_5449__901 _5449_/RESET_B VPWR VGND sg13cmos5l_tiehi
XFILLER_8_361 VPWR VGND sg13cmos5l_fill_1
X_5461_ _5461_/Q _5555_/CLK _5461_/D _5461_/RESET_B VPWR VGND sg13cmos5l_dfrbpq_1
X_4412_ _4412_/Y _4229_/Y _4409_/X _4410_/Y _4411_/Y VPWR VGND sg13cmos5l_a22oi_1
X_5392_ _5519_/D _5411_/A0 _5392_/A1 _5398_/S VPWR VGND sg13cmos5l_mux2_1
X_4343_ _4343_/Y _4343_/A _4343_/B VPWR VGND sg13cmos5l_nor2_1
X_4274_ _4275_/B _4261_/B _4261_/C _4271_/A VPWR VGND sg13cmos5l_a21oi_1
X_6013_ _6013_/Q _6067_/CLK _6013_/D _6013_/RESET_B VPWR VGND sg13cmos5l_dfrbpq_1
X_3225_ _5553_/D _5419_/A1 _3225_/A1 _3231_/S VPWR VGND sg13cmos5l_mux2_1
XFILLER_28_906 VPWR VGND sg13cmos5l_fill_1
X_3156_ _6079_/D _5432_/A _5432_/B VPWR VGND sg13cmos5l_and2_1
Xclkbuf_leaf_19_clk _5973_/CLK clkload0/A VPWR VGND sg13cmos5l_buf_8
X_3087_ _3087_/Y _3087_/A VPWR VGND sg13cmos5l_inv_1
XFILLER_27_449 VPWR VGND sg13cmos5l_decap_8
XFILLER_35_471 VPWR VGND sg13cmos5l_decap_8
XFILLER_22_176 VPWR VGND sg13cmos5l_fill_1
X_5728_ _5728_/Q _6047_/CLK _5728_/D _5728_/RESET_B VPWR VGND sg13cmos5l_dfrbpq_1
X_3989_ _3989_/Y _3908_/Y _3968_/Y _3988_/X _3620_/B _3949_/Y VPWR VGND sg13cmos5l_a221oi_1
X_5659_ _5659_/Q _5695_/CLK _5659_/D _5659_/RESET_B VPWR VGND sg13cmos5l_dfrbpq_1
X_6077__842 _6077_/RESET_B VPWR VGND sg13cmos5l_tiehi
XFILLER_2_537 VPWR VGND sg13cmos5l_fill_1
X_5901__470 _5901_/RESET_B VPWR VGND sg13cmos5l_tiehi
Xhold1050 _3472_/A _5729_/Q VPWR VGND sg13cmos5l_dlygate4sd3_1
XFILLER_18_416 VPWR VGND sg13cmos5l_fill_1
Xhold1083 _3113_/A _5677_/Q VPWR VGND sg13cmos5l_dlygate4sd3_1
Xhold1072 _3610_/A _5796_/Q VPWR VGND sg13cmos5l_dlygate4sd3_1
Xhold1061 _5740_/D _3494_/Y VPWR VGND sg13cmos5l_dlygate4sd3_1
Xhold1094 _4207_/A _5859_/Q VPWR VGND sg13cmos5l_dlygate4sd3_1
XFILLER_34_909 VPWR VGND sg13cmos5l_decap_8
XFILLER_27_961 VPWR VGND sg13cmos5l_decap_8
XFILLER_9_147 VPWR VGND sg13cmos5l_fill_1
XFILLER_49_541 VPWR VGND sg13cmos5l_decap_8
XFILLER_37_714 VPWR VGND sg13cmos5l_fill_1
XFILLER_37_747 VPWR VGND sg13cmos5l_fill_2
XFILLER_25_909 VPWR VGND sg13cmos5l_fill_1
X_4961_ _5048_/A _4746_/X _4957_/S _4960_/Y VPWR VGND sg13cmos5l_a21oi_1
X_3912_ _3912_/Y _4040_/S1 _3911_/Y _4042_/A1 VPWR VGND sg13cmos5l_o21ai_1
X_4892_ _6006_/D _4892_/A _4892_/B _4892_/C VPWR VGND sg13cmos5l_nor3_1
X_3843_ _5843_/D _3843_/A _3844_/B _3843_/C VPWR VGND sg13cmos5l_nor3_1
X_3774_ _3775_/B _3771_/A _3773_/A _3773_/Y VPWR VGND sg13cmos5l_o21ai_1
X_5513_ _5513_/Q clkload2/A _5513_/D _5513_/RESET_B VPWR VGND sg13cmos5l_dfrbpq_1
XFILLER_8_191 VPWR VGND sg13cmos5l_fill_2
Xclkbuf_leaf_8_clk _5555_/CLK clkbuf_leaf_9_clk/A VPWR VGND sg13cmos5l_buf_8
X_5444_ _5444_/Q _5555_/CLK _5444_/D _5444_/RESET_B VPWR VGND sg13cmos5l_dfrbpq_1
Xfanout104 _5138_/B _6063_/Q VPWR VGND sg13cmos5l_buf_1
X_5375_ _5504_/D _5375_/A0 _5375_/A1 _5379_/S VPWR VGND sg13cmos5l_mux2_1
Xfanout137 _3753_/B fanout142/X VPWR VGND sg13cmos5l_buf_1
Xfanout126 _3139_/A _5808_/Q VPWR VGND sg13cmos5l_buf_1
Xfanout115 _5304_/A hold1619/X VPWR VGND sg13cmos5l_buf_1
X_4326_ _4335_/A _4324_/A _4327_/B _4332_/A _4325_/Y VPWR VGND sg13cmos5l_a22oi_1
X_4257_ _4257_/Y _5884_/Q _5866_/Q VPWR VGND sg13cmos5l_nand2b_1
Xfanout159 _4053_/S1 fanout162/X VPWR VGND sg13cmos5l_buf_1
Xfanout148 _4012_/A _5804_/Q VPWR VGND sg13cmos5l_buf_1
X_3208_ _3824_/C input3/X _3208_/B VPWR VGND sg13cmos5l_and2_1
X_4188_ _5876_/D _3078_/Y _4304_/A2 _4187_/Y VPWR VGND sg13cmos5l_a21oi_1
X_3139_ _3762_/A _3139_/A VPWR VGND sg13cmos5l_inv_1
XFILLER_42_205 VPWR VGND sg13cmos5l_fill_2
XFILLER_23_485 VPWR VGND sg13cmos5l_decap_8
XFILLER_10_157 VPWR VGND sg13cmos5l_decap_8
X_5723__697 _5723_/RESET_B VPWR VGND sg13cmos5l_tiehi
X_5619__801 _5619_/RESET_B VPWR VGND sg13cmos5l_tiehi
X_5439__911 _5439_/RESET_B VPWR VGND sg13cmos5l_tiehi
XFILLER_34_717 VPWR VGND sg13cmos5l_fill_2
XFILLER_37_61 VPWR VGND sg13cmos5l_fill_2
XFILLER_18_1014 VPWR VGND sg13cmos5l_decap_8
X_5446__904 _5446_/RESET_B VPWR VGND sg13cmos5l_tiehi
X_3490_ _3490_/Y _3490_/A _3490_/B VPWR VGND sg13cmos5l_nand2_1
X_5160_ _5160_/Y _5145_/A _5162_/S _5176_/B VPWR VGND sg13cmos5l_o21ai_1
X_5091_ _5091_/Y _5119_/A _5089_/X _5090_/X VPWR VGND sg13cmos5l_o21ai_1
X_4111_ _4111_/Y _4111_/A1 _4110_/Y _3918_/A VPWR VGND sg13cmos5l_o21ai_1
X_4042_ _4042_/Y _4042_/A1 _4040_/X _4041_/Y VPWR VGND sg13cmos5l_o21ai_1
X_5993_ _5993_/Q _6077_/CLK _5993_/D _5993_/RESET_B VPWR VGND sg13cmos5l_dfrbpq_1
X_4944_ _4944_/Y _4750_/B _4943_/A _4750_/A VPWR VGND sg13cmos5l_o21ai_1
X_4875_ _4875_/Y _4866_/B _4866_/C _4866_/A VPWR VGND sg13cmos5l_a21oi_1
XFILLER_32_293 VPWR VGND sg13cmos5l_fill_1
XFILLER_20_455 VPWR VGND sg13cmos5l_decap_8
X_3826_ _3828_/B _5352_/B _5304_/D VPWR VGND sg13cmos5l_nor2_1
X_3757_ _3757_/Y _3752_/A _3750_/Y _3720_/A VPWR VGND sg13cmos5l_a21oi_1
X_3688_ _3688_/Y _3726_/A1 _5773_/Q _3687_/Y VPWR VGND sg13cmos5l_o21ai_1
X_5822__585 _5822_/RESET_B VPWR VGND sg13cmos5l_tiehi
X_5427_ _5823_/D _3087_/Y _3643_/B _3645_/Y VPWR VGND sg13cmos5l_a21oi_1
XFILLER_0_816 VPWR VGND sg13cmos5l_decap_8
X_5358_ _5489_/D _5423_/A1 _5358_/A1 _5360_/S VPWR VGND sg13cmos5l_mux2_1
X_4309_ _5904_/D _4358_/B _4309_/B VPWR VGND sg13cmos5l_and2_1
X_5289_ _5290_/C _5287_/A _5287_/B _3159_/C VPWR VGND sg13cmos5l_o21ai_1
XFILLER_43_503 VPWR VGND sg13cmos5l_decap_8
XFILLER_12_945 VPWR VGND sg13cmos5l_decap_8
XFILLER_12_967 VPWR VGND sg13cmos5l_fill_1
XFILLER_7_437 VPWR VGND sg13cmos5l_fill_1
XFILLER_3_0 VPWR VGND sg13cmos5l_fill_2
XFILLER_47_842 VPWR VGND sg13cmos5l_fill_1
XFILLER_19_511 VPWR VGND sg13cmos5l_fill_1
X_6010__350 _6010_/RESET_B VPWR VGND sg13cmos5l_tiehi
X_4660_ _4660_/Y _4693_/B _4693_/A VPWR VGND sg13cmos5l_nand2b_1
X_3611_ _5796_/D _3611_/A1 _3617_/B _3610_/Y VPWR VGND sg13cmos5l_o21ai_1
XFILLER_31_1000 VPWR VGND sg13cmos5l_fill_2
X_4591_ _4594_/A _4580_/Y _4589_/X _4590_/Y VPWR VGND sg13cmos5l_a21oi_1
X_3542_ _3542_/X _3542_/A0 _3591_/A _3542_/S VPWR VGND sg13cmos5l_mux2_1
X_3473_ _5729_/D _3509_/A1 _3481_/B _3472_/Y VPWR VGND sg13cmos5l_o21ai_1
X_5212_ _5212_/Y _4902_/Y _5204_/Y _5211_/Y _5201_/X _5209_/Y VPWR VGND sg13cmos5l_a221oi_1
X_5143_ _5143_/Y _5143_/A _6067_/Q VPWR VGND sg13cmos5l_nor2_1
XFILLER_36_0 VPWR VGND sg13cmos5l_fill_2
Xhold1605 hold1605/X _6077_/Q VPWR VGND sg13cmos5l_dlygate4sd3_1
Xhold1616 _4210_/A _5881_/Q VPWR VGND sg13cmos5l_dlygate4sd3_1
X_5074_ _5116_/A _6064_/Q _5138_/B VPWR VGND sg13cmos5l_xnor2_1
Xhold1627 _4682_/A _5968_/Q VPWR VGND sg13cmos5l_dlygate4sd3_1
Xhold1638 _4332_/B _4335_/A VPWR VGND sg13cmos5l_dlygate4sd3_1
Xhold1649 hold1649/X _5911_/Q VPWR VGND sg13cmos5l_dlygate4sd3_1
X_5479__598 _5479_/RESET_B VPWR VGND sg13cmos5l_tiehi
X_4025_ _4025_/Y _4017_/Y _4019_/Y _4012_/A VPWR VGND sg13cmos5l_a21oi_1
XFILLER_12_208 VPWR VGND sg13cmos5l_fill_2
XFILLER_25_569 VPWR VGND sg13cmos5l_decap_8
X_5976_ _5976_/Q _6007_/CLK _5976_/D _5976_/RESET_B VPWR VGND sg13cmos5l_dfrbpq_1
X_4927_ _6009_/D _5071_/A _4927_/B VPWR VGND sg13cmos5l_nor2_1
X_4858_ _4858_/X _6002_/Q _4878_/B _4849_/Y VPWR VGND sg13cmos5l_a21o_1
X_3809_ _3809_/Y _3813_/B _3809_/B VPWR VGND sg13cmos5l_nand2_1
XFILLER_5_919 VPWR VGND sg13cmos5l_decap_8
X_4789_ _4789_/Y _6008_/Q _4639_/A _4788_/Y VPWR VGND sg13cmos5l_a21oi_1
X_5609__811 _5609_/RESET_B VPWR VGND sg13cmos5l_tiehi
X_5616__804 _5616_/RESET_B VPWR VGND sg13cmos5l_tiehi
XFILLER_16_503 VPWR VGND sg13cmos5l_fill_1
X_5436__914 _5436_/RESET_B VPWR VGND sg13cmos5l_tiehi
XFILLER_44_878 VPWR VGND sg13cmos5l_fill_2
X_5443__907 _5443_/RESET_B VPWR VGND sg13cmos5l_tiehi
XFILLER_39_628 VPWR VGND sg13cmos5l_fill_1
X_5830_ _5830_/Q clkload3/A _5830_/D _5830_/RESET_B VPWR VGND sg13cmos5l_dfrbpq_1
XFILLER_22_517 VPWR VGND sg13cmos5l_fill_1
X_5761_ _5761_/Q _6074_/CLK _5761_/D _5761_/RESET_B VPWR VGND sg13cmos5l_dfrbpq_1
X_4712_ _4713_/B _6006_/Q _4785_/A _6007_/Q VPWR VGND sg13cmos5l_nor3_1
X_5692_ _5692_/Q _5692_/CLK _5692_/D _5692_/RESET_B VPWR VGND sg13cmos5l_dfrbpq_1
X_4643_ _5961_/D _3074_/Y _5003_/A2 _4642_/Y VPWR VGND sg13cmos5l_a21oi_1
X_4574_ _4693_/A _4561_/B _4757_/A _4573_/Y VPWR VGND sg13cmos5l_a21oi_1
X_3525_ _5754_/D _3611_/A1 _3531_/B _3524_/Y VPWR VGND sg13cmos5l_o21ai_1
X_3456_ _3456_/Y _3518_/A1 _3455_/B _3456_/B1 VPWR VGND sg13cmos5l_a21oi_1
X_3387_ _5686_/D _3387_/A0 _5398_/A0 _3387_/S VPWR VGND sg13cmos5l_mux2_1
Xhold1402 _5369_/A0 _5499_/Q VPWR VGND sg13cmos5l_dlygate4sd3_1
X_5126_ _5126_/Y _6021_/Q _5143_/A _5111_/A _6020_/Q _5125_/Y VPWR VGND sg13cmos5l_a221oi_1
Xhold1424 _3162_/B _5830_/Q VPWR VGND sg13cmos5l_dlygate4sd3_1
Xhold1413 _5336_/A0 _5469_/Q VPWR VGND sg13cmos5l_dlygate4sd3_1
Xhold1446 _3352_/A1 _5658_/Q VPWR VGND sg13cmos5l_dlygate4sd3_1
Xhold1435 _3334_/A1 _5642_/Q VPWR VGND sg13cmos5l_dlygate4sd3_1
Xhold1457 _3225_/A1 _5553_/Q VPWR VGND sg13cmos5l_dlygate4sd3_1
X_5057_ _5057_/X _5070_/A _5057_/B VPWR VGND sg13cmos5l_or2_1
Xhold1468 _5345_/A0 _5477_/Q VPWR VGND sg13cmos5l_dlygate4sd3_1
Xhold1479 _3061_/A _6027_/Q VPWR VGND sg13cmos5l_dlygate4sd3_1
X_4008_ _4009_/B _5623_/Q _5606_/Q _5598_/Q _5572_/Q _4029_/S _4031_/A1 VPWR VGND
+ sg13cmos5l_mux4_1
XFILLER_38_1017 VPWR VGND sg13cmos5l_decap_8
XFILLER_38_1028 VPWR VGND sg13cmos5l_fill_1
X_5959_ _5959_/Q _6037_/CLK _5959_/D _5959_/RESET_B VPWR VGND sg13cmos5l_dfrbpq_1
X_5546__942 _5546_/RESET_B VPWR VGND sg13cmos5l_tiehi
X_6000__360 _6000_/RESET_B VPWR VGND sg13cmos5l_tiehi
XFILLER_1_988 VPWR VGND sg13cmos5l_decap_8
XFILLER_49_959 VPWR VGND sg13cmos5l_decap_8
XFILLER_48_425 VPWR VGND sg13cmos5l_decap_8
XFILLER_35_119 VPWR VGND sg13cmos5l_fill_2
XFILLER_44_620 VPWR VGND sg13cmos5l_decap_8
XFILLER_28_193 VPWR VGND sg13cmos5l_decap_8
XFILLER_44_675 VPWR VGND sg13cmos5l_fill_1
XFILLER_31_369 VPWR VGND sg13cmos5l_fill_2
XFILLER_6_99 VPWR VGND sg13cmos5l_fill_1
X_3310_ _5621_/D _5354_/A0 _3310_/A1 _3316_/S VPWR VGND sg13cmos5l_mux2_1
X_4290_ _4290_/Y _3127_/Y _3128_/A _4423_/B VPWR VGND sg13cmos5l_a21oi_1
X_3241_ _5568_/D _3241_/A0 _5408_/A1 _3241_/S VPWR VGND sg13cmos5l_mux2_1
X_3172_ _3172_/X _5670_/Q _5653_/Q _3172_/S VPWR VGND sg13cmos5l_mux2_1
XFILLER_26_108 VPWR VGND sg13cmos5l_fill_2
XFILLER_48_992 VPWR VGND sg13cmos5l_decap_8
X_5813_ _5813_/Q clkload7/A _5813_/D _5813_/RESET_B VPWR VGND sg13cmos5l_dfrbpq_1
X_5744_ _5744_/Q _6063_/CLK _5744_/D _5744_/RESET_B VPWR VGND sg13cmos5l_dfrbpq_1
XFILLER_22_369 VPWR VGND sg13cmos5l_fill_1
X_5675_ _5675_/Q _5692_/CLK _5675_/D _5675_/RESET_B VPWR VGND sg13cmos5l_dfrbpq_1
XFILLER_31_892 VPWR VGND sg13cmos5l_fill_1
X_4626_ _4626_/Y _5956_/Q _4621_/Y _4618_/Y VPWR VGND sg13cmos5l_o21ai_1
X_5606__814 _5606_/RESET_B VPWR VGND sg13cmos5l_tiehi
X_4557_ _4557_/Y _4557_/A _4573_/B VPWR VGND sg13cmos5l_nor2_1
X_3508_ _3508_/Y _3508_/A _3514_/B VPWR VGND sg13cmos5l_nand2_1
X_4488_ _4505_/B _4486_/Y _4487_/Y _4485_/Y VPWR VGND sg13cmos5l_a21oi_1
X_3439_ _3439_/Y _5162_/A1 _3440_/B _3438_/Y VPWR VGND sg13cmos5l_a21oi_1
Xhold1221 _5347_/A0 _5479_/Q VPWR VGND sg13cmos5l_dlygate4sd3_1
Xhold1243 _5414_/A1 _5539_/Q VPWR VGND sg13cmos5l_dlygate4sd3_1
X_5109_ _6041_/D _5272_/A _5109_/B VPWR VGND sg13cmos5l_nor2_1
Xhold1232 _5305_/A1 _5441_/Q VPWR VGND sg13cmos5l_dlygate4sd3_1
Xhold1210 _3369_/A1 _5673_/Q VPWR VGND sg13cmos5l_dlygate4sd3_1
Xhold1254 _5317_/A0 _5452_/Q VPWR VGND sg13cmos5l_dlygate4sd3_1
Xhold1265 _3077_/A _5900_/Q VPWR VGND sg13cmos5l_dlygate4sd3_1
Xhold1276 _5297_/A0 _5436_/Q VPWR VGND sg13cmos5l_dlygate4sd3_1
Xhold1287 _3240_/A0 _5567_/Q VPWR VGND sg13cmos5l_dlygate4sd3_1
Xhold1298 _5295_/A0 _5434_/Q VPWR VGND sg13cmos5l_dlygate4sd3_1
XFILLER_38_491 VPWR VGND sg13cmos5l_decap_8
X_5613__807 _5613_/RESET_B VPWR VGND sg13cmos5l_tiehi
XFILLER_13_314 VPWR VGND sg13cmos5l_fill_1
X_5433__917 _5433_/RESET_B VPWR VGND sg13cmos5l_tiehi
XFILLER_41_667 VPWR VGND sg13cmos5l_decap_8
XFILLER_15_64 VPWR VGND sg13cmos5l_fill_1
XFILLER_40_188 VPWR VGND sg13cmos5l_fill_2
XFILLER_31_30 VPWR VGND sg13cmos5l_fill_2
XFILLER_31_63 VPWR VGND sg13cmos5l_fill_1
XFILLER_49_723 VPWR VGND sg13cmos5l_decap_8
XFILLER_49_767 VPWR VGND sg13cmos5l_decap_4
XFILLER_0_295 VPWR VGND sg13cmos5l_fill_1
XFILLER_49_789 VPWR VGND sg13cmos5l_decap_8
XFILLER_45_951 VPWR VGND sg13cmos5l_decap_8
XFILLER_44_450 VPWR VGND sg13cmos5l_decap_8
X_3790_ _3790_/Y _3412_/A _3413_/B _3417_/C VPWR VGND sg13cmos5l_o21ai_1
XFILLER_13_870 VPWR VGND sg13cmos5l_decap_4
XFILLER_31_188 VPWR VGND sg13cmos5l_fill_2
X_5981__289 _5981_/D VPWR VGND sg13cmos5l_tielo
X_5460_ _5460_/Q clkload9/A _5460_/D _5460_/RESET_B VPWR VGND sg13cmos5l_dfrbpq_1
X_4411_ _4411_/Y _4410_/A _4410_/B _4407_/Y VPWR VGND sg13cmos5l_o21ai_1
XFILLER_8_384 VPWR VGND sg13cmos5l_fill_1
X_5391_ _5518_/D _5410_/A0 _5391_/A1 _5398_/S VPWR VGND sg13cmos5l_mux2_1
X_4342_ _4342_/Y _4273_/B _4343_/B _4341_/Y VPWR VGND sg13cmos5l_o21ai_1
X_4273_ _5892_/D _4314_/B _4273_/B VPWR VGND sg13cmos5l_nor2_1
X_6012_ _6012_/Q _6067_/CLK _6012_/D _6012_/RESET_B VPWR VGND sg13cmos5l_dfrbpq_1
X_3224_ _5552_/D _5372_/A0 _3224_/A1 _3231_/S VPWR VGND sg13cmos5l_mux2_1
.ends
