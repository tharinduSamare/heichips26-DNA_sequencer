* NGSPICE file created from heichips26_dna_sequencer.ext - technology: ihp-sg13cmos5l

* Black-box entry subcircuit for sg13cmos5l_decap_8 abstract view
.subckt sg13cmos5l_decap_8 VDD VSS
.ends

* Black-box entry subcircuit for sg13cmos5l_fill_2 abstract view
.subckt sg13cmos5l_fill_2 VDD VSS
.ends

* Black-box entry subcircuit for sg13cmos5l_tiehi abstract view
.subckt sg13cmos5l_tiehi L_HI VDD VSS
.ends

* Black-box entry subcircuit for sg13cmos5l_or2_1 abstract view
.subckt sg13cmos5l_or2_1 X A B VDD VSS
.ends

* Black-box entry subcircuit for sg13cmos5l_a21oi_1 abstract view
.subckt sg13cmos5l_a21oi_1 Y A1 A2 B1 VDD VSS
.ends

* Black-box entry subcircuit for sg13cmos5l_decap_4 abstract view
.subckt sg13cmos5l_decap_4 VDD VSS
.ends

* Black-box entry subcircuit for sg13cmos5l_dfrbpq_1 abstract view
.subckt sg13cmos5l_dfrbpq_1 Q CLK D RESET_B VDD VSS
.ends

* Black-box entry subcircuit for sg13cmos5l_xor2_1 abstract view
.subckt sg13cmos5l_xor2_1 X A B VDD VSS
.ends

* Black-box entry subcircuit for sg13cmos5l_fill_1 abstract view
.subckt sg13cmos5l_fill_1 VDD VSS
.ends

* Black-box entry subcircuit for sg13cmos5l_nor2_1 abstract view
.subckt sg13cmos5l_nor2_1 Y A B VDD VSS
.ends

* Black-box entry subcircuit for sg13cmos5l_a22oi_1 abstract view
.subckt sg13cmos5l_a22oi_1 Y A1 A2 B1 B2 VDD VSS
.ends

* Black-box entry subcircuit for sg13cmos5l_mux4_1 abstract view
.subckt sg13cmos5l_mux4_1 X A0 A1 A2 A3 S0 S1 VDD VSS
.ends

* Black-box entry subcircuit for sg13cmos5l_buf_1 abstract view
.subckt sg13cmos5l_buf_1 X A VDD VSS
.ends

* Black-box entry subcircuit for sg13cmos5l_a21o_1 abstract view
.subckt sg13cmos5l_a21o_1 X A1 A2 B1 VDD VSS
.ends

* Black-box entry subcircuit for sg13cmos5l_xnor2_1 abstract view
.subckt sg13cmos5l_xnor2_1 Y A B VDD VSS
.ends

* Black-box entry subcircuit for sg13cmos5l_a221oi_1 abstract view
.subckt sg13cmos5l_a221oi_1 Y A1 A2 B1 B2 C1 VDD VSS
.ends

* Black-box entry subcircuit for sg13cmos5l_mux2_1 abstract view
.subckt sg13cmos5l_mux2_1 X A0 A1 S VDD VSS
.ends

* Black-box entry subcircuit for sg13cmos5l_inv_1 abstract view
.subckt sg13cmos5l_inv_1 Y A VDD VSS
.ends

* Black-box entry subcircuit for sg13cmos5l_o21ai_1 abstract view
.subckt sg13cmos5l_o21ai_1 Y A1 A2 B1 VDD VSS
.ends

* Black-box entry subcircuit for sg13cmos5l_dlygate4sd3_1 abstract view
.subckt sg13cmos5l_dlygate4sd3_1 X A VDD VSS
.ends

* Black-box entry subcircuit for sg13cmos5l_nand2_1 abstract view
.subckt sg13cmos5l_nand2_1 Y A B VDD VSS
.ends

* Black-box entry subcircuit for sg13cmos5l_and2_1 abstract view
.subckt sg13cmos5l_and2_1 X A B VDD VSS
.ends

* Black-box entry subcircuit for sg13cmos5l_or3_1 abstract view
.subckt sg13cmos5l_or3_1 X A B C VDD VSS
.ends

* Black-box entry subcircuit for sg13cmos5l_nand2b_1 abstract view
.subckt sg13cmos5l_nand2b_1 Y A_N B VDD VSS
.ends

* Black-box entry subcircuit for sg13cmos5l_tielo abstract view
.subckt sg13cmos5l_tielo L_LO VDD VSS
.ends

* Black-box entry subcircuit for sg13cmos5l_and3_1 abstract view
.subckt sg13cmos5l_and3_1 X A B C VDD VSS
.ends

* Black-box entry subcircuit for sg13cmos5l_nor2b_1 abstract view
.subckt sg13cmos5l_nor2b_1 Y A B_N VDD VSS
.ends

* Black-box entry subcircuit for sg13cmos5l_nand3b_1 abstract view
.subckt sg13cmos5l_nand3b_1 Y A_N B C VDD VSS
.ends

* Black-box entry subcircuit for sg13cmos5l_nand3_1 abstract view
.subckt sg13cmos5l_nand3_1 Y A B C VDD VSS
.ends

* Black-box entry subcircuit for sg13cmos5l_nor3_1 abstract view
.subckt sg13cmos5l_nor3_1 Y A B C VDD VSS
.ends

* Black-box entry subcircuit for sg13cmos5l_buf_8 abstract view
.subckt sg13cmos5l_buf_8 X A VDD VSS
.ends

* Black-box entry subcircuit for sg13cmos5l_nand4_1 abstract view
.subckt sg13cmos5l_nand4_1 Y A B C D VDD VSS
.ends

* Black-box entry subcircuit for sg13cmos5l_nor4_1 abstract view
.subckt sg13cmos5l_nor4_1 Y A B C D VDD VSS
.ends

* Black-box entry subcircuit for sg13cmos5l_inv_2 abstract view
.subckt sg13cmos5l_inv_2 Y A VDD VSS
.ends

* Black-box entry subcircuit for sg13cmos5l_and4_1 abstract view
.subckt sg13cmos5l_and4_1 X A B C D VDD VSS
.ends

.subckt heichips26_dna_sequencer VGND VPWR clk ena rst_n ui_in[0] ui_in[1] ui_in[2]
+ ui_in[3] ui_in[4] ui_in[5] ui_in[6] ui_in[7] uio_in[0] uio_in[1] uio_in[2] uio_in[3]
+ uio_in[4] uio_in[5] uio_in[6] uio_in[7] uio_oe[0] uio_oe[1] uio_oe[2] uio_oe[3]
+ uio_oe[4] uio_oe[5] uio_oe[6] uio_oe[7] uio_out[0] uio_out[1] uio_out[2] uio_out[3]
+ uio_out[4] uio_out[5] uio_out[6] uio_out[7] uo_out[0] uo_out[1] uo_out[2] uo_out[3]
+ uo_out[4] uo_out[5] uo_out[6] uo_out[7]
XFILLER_39_255 VPWR VGND sg13cmos5l_decap_8
XFILLER_28_929 VPWR VGND sg13cmos5l_fill_2
X_4094__565 _4094_/RESET_B VPWR VGND sg13cmos5l_tiehi
X_3155_ _3155_/X _3155_/A _3167_/B VPWR VGND sg13cmos5l_or2_1
X_3086_ _3086_/Y _3053_/X _3088_/A _3047_/B VPWR VGND sg13cmos5l_a21oi_1
XFILLER_36_940 VPWR VGND sg13cmos5l_decap_8
XFILLER_42_409 VPWR VGND sg13cmos5l_decap_8
XFILLER_22_133 VPWR VGND sg13cmos5l_decap_4
XFILLER_23_656 VPWR VGND sg13cmos5l_decap_8
X_3988_ _3988_/Q _4011_/CLK _3988_/D _3988_/RESET_B VPWR VGND sg13cmos5l_dfrbpq_1
X_2939_ _2952_/B _4115_/Q _2945_/A VPWR VGND sg13cmos5l_xor2_1
XFILLER_46_715 VPWR VGND sg13cmos5l_decap_4
XFILLER_46_737 VPWR VGND sg13cmos5l_decap_8
XFILLER_45_225 VPWR VGND sg13cmos5l_decap_4
XFILLER_18_439 VPWR VGND sg13cmos5l_fill_1
XFILLER_27_973 VPWR VGND sg13cmos5l_decap_8
XFILLER_26_450 VPWR VGND sg13cmos5l_decap_8
XFILLER_42_954 VPWR VGND sg13cmos5l_decap_8
XFILLER_13_122 VPWR VGND sg13cmos5l_decap_8
XFILLER_13_166 VPWR VGND sg13cmos5l_decap_4
XFILLER_10_851 VPWR VGND sg13cmos5l_fill_1
XFILLER_6_844 VPWR VGND sg13cmos5l_decap_8
XFILLER_1_560 VPWR VGND sg13cmos5l_decap_4
XFILLER_49_542 VPWR VGND sg13cmos5l_decap_8
XFILLER_49_575 VPWR VGND sg13cmos5l_decap_8
XFILLER_3_1007 VPWR VGND sg13cmos5l_decap_8
XFILLER_37_759 VPWR VGND sg13cmos5l_decap_8
XFILLER_37_737 VPWR VGND sg13cmos5l_decap_4
X_4269__513 _4269_/RESET_B VPWR VGND sg13cmos5l_tiehi
XFILLER_44_280 VPWR VGND sg13cmos5l_decap_8
X_3911_ _3911_/Q clkload7/A _3911_/D _3911_/RESET_B VPWR VGND sg13cmos5l_dfrbpq_1
XFILLER_32_420 VPWR VGND sg13cmos5l_fill_2
X_3842_ _4270_/D _4272_/D _3842_/B VPWR VGND sg13cmos5l_nor2_1
XFILLER_32_453 VPWR VGND sg13cmos5l_fill_2
XFILLER_33_976 VPWR VGND sg13cmos5l_decap_8
X_3773_ _3773_/Y _3779_/A _3779_/B _3772_/X _3651_/B VPWR VGND sg13cmos5l_a22oi_1
X_2724_ _2775_/D _2702_/Y _2707_/Y _2837_/A _2704_/Y VPWR VGND sg13cmos5l_a22oi_1
X_2655_ _2655_/X _3997_/Q _3980_/Q _3963_/Q _3946_/Q _2667_/A1 _2670_/B2 VPWR VGND
+ sg13cmos5l_mux4_1
X_2586_ _2586_/Y _2662_/A _2585_/X _2584_/Y VPWR VGND sg13cmos5l_a21oi_1
Xfanout116 _2418_/A0 input11/X VPWR VGND sg13cmos5l_buf_1
Xfanout105 _2416_/A0 input9/X VPWR VGND sg13cmos5l_buf_1
Xfanout127 _3827_/B1 input1/X VPWR VGND sg13cmos5l_buf_1
X_4256_ _4256_/Q _4259_/CLK _4256_/D _4256_/RESET_B VPWR VGND sg13cmos5l_dfrbpq_1
XFILLER_41_1013 VPWR VGND sg13cmos5l_decap_8
X_4187_ _4187_/Q _4259_/CLK _4187_/D _4187_/RESET_B VPWR VGND sg13cmos5l_dfrbpq_1
X_3207_ _4160_/D _2180_/Y _3553_/A2 _3206_/Y VPWR VGND sg13cmos5l_a21oi_1
X_3138_ _3138_/X _3137_/B _3137_/C _3137_/A VPWR VGND sg13cmos5l_a21o_1
XFILLER_43_718 VPWR VGND sg13cmos5l_decap_4
XFILLER_15_409 VPWR VGND sg13cmos5l_decap_8
XFILLER_42_228 VPWR VGND sg13cmos5l_decap_8
XFILLER_42_217 VPWR VGND sg13cmos5l_fill_1
XFILLER_24_921 VPWR VGND sg13cmos5l_decap_4
X_3069_ _3069_/Y _3069_/A _3069_/B VPWR VGND sg13cmos5l_xnor2_1
XFILLER_42_239 VPWR VGND sg13cmos5l_fill_2
XFILLER_23_431 VPWR VGND sg13cmos5l_decap_4
XFILLER_24_943 VPWR VGND sg13cmos5l_decap_8
XFILLER_23_442 VPWR VGND sg13cmos5l_decap_8
XFILLER_11_637 VPWR VGND sg13cmos5l_fill_2
XFILLER_10_158 VPWR VGND sg13cmos5l_decap_4
XFILLER_10_169 VPWR VGND sg13cmos5l_fill_2
XFILLER_3_825 VPWR VGND sg13cmos5l_decap_8
XFILLER_46_501 VPWR VGND sg13cmos5l_decap_4
XFILLER_19_704 VPWR VGND sg13cmos5l_fill_1
XFILLER_46_523 VPWR VGND sg13cmos5l_decap_8
XFILLER_37_40 VPWR VGND sg13cmos5l_fill_1
XFILLER_15_932 VPWR VGND sg13cmos5l_fill_1
XFILLER_15_943 VPWR VGND sg13cmos5l_decap_8
XFILLER_18_1004 VPWR VGND sg13cmos5l_decap_8
X_2440_ _2440_/Y _2195_/Y _2435_/B _2441_/B _2290_/C _2439_/Y VPWR VGND sg13cmos5l_a221oi_1
X_2371_ _3969_/D _3854_/A1 hold777/X _2371_/S VPWR VGND sg13cmos5l_mux2_1
XFILLER_38_4 VPWR VGND sg13cmos5l_decap_8
X_4110_ _4110_/Q _4136_/CLK _4110_/D _4110_/RESET_B VPWR VGND sg13cmos5l_dfrbpq_1
XFILLER_2_891 VPWR VGND sg13cmos5l_decap_8
XFILLER_25_1008 VPWR VGND sg13cmos5l_decap_8
X_4041_ _4041_/Q clkload2/A _4041_/D _4041_/RESET_B VPWR VGND sg13cmos5l_dfrbpq_1
XFILLER_24_217 VPWR VGND sg13cmos5l_decap_8
XFILLER_33_784 VPWR VGND sg13cmos5l_decap_8
X_3825_ _3825_/Y _3825_/A _4266_/Q VPWR VGND sg13cmos5l_xnor2_1
X_3756_ _3756_/Y _3756_/A _3756_/B VPWR VGND sg13cmos5l_nor2_1
X_2707_ _2707_/Y _2707_/A VPWR VGND sg13cmos5l_inv_1
X_3687_ _3690_/B _3545_/Y _3686_/B _3686_/Y VPWR VGND sg13cmos5l_o21ai_1
X_2638_ _2638_/Y _2639_/A _3924_/Q _2654_/A1 VPWR VGND sg13cmos5l_a21oi_1
X_2569_ _2569_/Y _2568_/A _3889_/Q _2568_/Y VPWR VGND sg13cmos5l_a21oi_1
X_4239_ _4239_/Q _4265_/CLK _4239_/D _4239_/RESET_B VPWR VGND sg13cmos5l_dfrbpq_1
XFILLER_28_523 VPWR VGND sg13cmos5l_fill_2
XFILLER_16_729 VPWR VGND sg13cmos5l_decap_8
XFILLER_12_913 VPWR VGND sg13cmos5l_decap_8
XFILLER_12_935 VPWR VGND sg13cmos5l_decap_8
XFILLER_12_946 VPWR VGND sg13cmos5l_fill_1
XFILLER_23_261 VPWR VGND sg13cmos5l_fill_2
XFILLER_11_445 VPWR VGND sg13cmos5l_decap_4
XFILLER_12_979 VPWR VGND sg13cmos5l_decap_8
XFILLER_23_64 VPWR VGND sg13cmos5l_decap_4
XFILLER_7_449 VPWR VGND sg13cmos5l_decap_8
XFILLER_2_154 VPWR VGND sg13cmos5l_decap_8
XFILLER_2_187 VPWR VGND sg13cmos5l_fill_2
XFILLER_38_309 VPWR VGND sg13cmos5l_decap_4
XFILLER_19_523 VPWR VGND sg13cmos5l_decap_8
XFILLER_47_854 VPWR VGND sg13cmos5l_decap_8
XFILLER_0_35 VPWR VGND sg13cmos5l_decap_4
XFILLER_19_556 VPWR VGND sg13cmos5l_decap_4
XFILLER_9_11 VPWR VGND sg13cmos5l_decap_8
XFILLER_9_33 VPWR VGND sg13cmos5l_decap_8
XFILLER_14_250 VPWR VGND sg13cmos5l_decap_8
XFILLER_14_261 VPWR VGND sg13cmos5l_fill_1
XFILLER_9_88 VPWR VGND sg13cmos5l_decap_8
X_3610_ _3610_/Y _3570_/Y _3608_/Y _3540_/A VPWR VGND sg13cmos5l_a21oi_1
X_3541_ _3541_/Y hold877/X _3539_/S _3560_/B VPWR VGND sg13cmos5l_o21ai_1
XFILLER_11_990 VPWR VGND sg13cmos5l_decap_8
XFILLER_7_972 VPWR VGND sg13cmos5l_decap_8
XFILLER_6_471 VPWR VGND sg13cmos5l_fill_2
Xhold917 _2236_/A _4185_/Q VPWR VGND sg13cmos5l_dlygate4sd3_1
Xhold906 hold906/X _2870_/Y VPWR VGND sg13cmos5l_dlygate4sd3_1
Xhold928 _4031_/D _2478_/Y VPWR VGND sg13cmos5l_dlygate4sd3_1
XFILLER_6_482 VPWR VGND sg13cmos5l_fill_2
X_3472_ _3472_/Y _3480_/B _3775_/B VPWR VGND sg13cmos5l_nand2_1
Xhold939 _2199_/A _4024_/Q VPWR VGND sg13cmos5l_dlygate4sd3_1
X_2423_ _2518_/B _2516_/A _2647_/A VPWR VGND sg13cmos5l_and2_1
X_2354_ _3954_/D _2414_/A0 hold733/X _2361_/S VPWR VGND sg13cmos5l_mux2_1
X_2285_ _3846_/D input2/X _2285_/B VPWR VGND sg13cmos5l_nor2_1
X_4024_ _4024_/Q _4027_/CLK _4024_/D _4024_/RESET_B VPWR VGND sg13cmos5l_dfrbpq_1
XFILLER_40_529 VPWR VGND sg13cmos5l_fill_2
XFILLER_33_592 VPWR VGND sg13cmos5l_fill_2
X_3808_ _3809_/B _3734_/Y _3790_/X _3814_/S VPWR VGND sg13cmos5l_mux2_1
XFILLER_21_787 VPWR VGND sg13cmos5l_fill_2
X_3739_ _3739_/Y _3740_/B VPWR VGND sg13cmos5l_inv_1
XFILLER_16_504 VPWR VGND sg13cmos5l_fill_1
XFILLER_44_835 VPWR VGND sg13cmos5l_decap_8
XFILLER_12_710 VPWR VGND sg13cmos5l_fill_1
XFILLER_8_736 VPWR VGND sg13cmos5l_fill_2
XFILLER_11_264 VPWR VGND sg13cmos5l_decap_8
X_4222__408 _4222_/RESET_B VPWR VGND sg13cmos5l_tiehi
XFILLER_4_931 VPWR VGND sg13cmos5l_decap_8
XFILLER_3_474 VPWR VGND sg13cmos5l_fill_1
XFILLER_47_684 VPWR VGND sg13cmos5l_decap_4
XFILLER_46_150 VPWR VGND sg13cmos5l_fill_1
XFILLER_34_301 VPWR VGND sg13cmos5l_decap_8
XFILLER_22_507 VPWR VGND sg13cmos5l_fill_1
XFILLER_35_868 VPWR VGND sg13cmos5l_fill_2
X_2972_ _2994_/A _2972_/A _2975_/B VPWR VGND sg13cmos5l_nor2_1
Xhold703 hold703/X _3931_/Q VPWR VGND sg13cmos5l_dlygate4sd3_1
Xhold725 hold725/X _3950_/Q VPWR VGND sg13cmos5l_dlygate4sd3_1
X_3524_ _3525_/A _3528_/S _3523_/Y _3522_/Y VPWR VGND sg13cmos5l_a21o_1
Xhold736 hold736/X _3973_/Q VPWR VGND sg13cmos5l_dlygate4sd3_1
Xhold714 hold714/X _3992_/Q VPWR VGND sg13cmos5l_dlygate4sd3_1
X_3455_ _3473_/A _4209_/Q _4208_/Q _4207_/Q VPWR VGND sg13cmos5l_or3_1
Xhold758 hold758/X _3936_/Q VPWR VGND sg13cmos5l_dlygate4sd3_1
Xhold769 hold769/X _4005_/Q VPWR VGND sg13cmos5l_dlygate4sd3_1
Xhold747 _2179_/A _4130_/Q VPWR VGND sg13cmos5l_dlygate4sd3_1
X_2406_ _3998_/D _2415_/A0 hold785/X _2411_/S VPWR VGND sg13cmos5l_mux2_1
X_3386_ _4193_/D _2176_/Y _3708_/A2 _3385_/Y VPWR VGND sg13cmos5l_a21oi_1
X_2337_ _3940_/D _3871_/A0 hold779/X _2341_/S VPWR VGND sg13cmos5l_mux2_1
XFILLER_29_117 VPWR VGND sg13cmos5l_fill_2
X_2268_ _2497_/B _2510_/A _2268_/B VPWR VGND sg13cmos5l_nor2_1
XFILLER_26_813 VPWR VGND sg13cmos5l_decap_8
X_4007_ _4007_/Q clkload5/A _4007_/D _4007_/RESET_B VPWR VGND sg13cmos5l_dfrbpq_1
X_2199_ _2461_/A _2199_/A VPWR VGND sg13cmos5l_inv_1
XFILLER_26_835 VPWR VGND sg13cmos5l_decap_8
XFILLER_41_816 VPWR VGND sg13cmos5l_decap_8
XFILLER_25_345 VPWR VGND sg13cmos5l_fill_2
XFILLER_25_356 VPWR VGND sg13cmos5l_decap_8
XFILLER_25_367 VPWR VGND sg13cmos5l_fill_1
XFILLER_13_529 VPWR VGND sg13cmos5l_fill_2
XFILLER_20_65 VPWR VGND sg13cmos5l_decap_4
X_4024__259 _4024_/RESET_B VPWR VGND sg13cmos5l_tiehi
XFILLER_49_905 VPWR VGND sg13cmos5l_decap_8
XFILLER_1_967 VPWR VGND sg13cmos5l_decap_8
XFILLER_48_404 VPWR VGND sg13cmos5l_decap_4
XFILLER_0_466 VPWR VGND sg13cmos5l_decap_8
XFILLER_48_437 VPWR VGND sg13cmos5l_decap_8
XFILLER_17_813 VPWR VGND sg13cmos5l_decap_8
XFILLER_21_1022 VPWR VGND sg13cmos5l_decap_8
XFILLER_29_662 VPWR VGND sg13cmos5l_fill_2
XFILLER_31_304 VPWR VGND sg13cmos5l_fill_1
XFILLER_8_500 VPWR VGND sg13cmos5l_fill_2
XFILLER_40_893 VPWR VGND sg13cmos5l_decap_4
XFILLER_8_544 VPWR VGND sg13cmos5l_decap_8
XFILLER_4_750 VPWR VGND sg13cmos5l_decap_8
X_3240_ _3258_/A _3240_/A _3240_/B VPWR VGND sg13cmos5l_nor2_1
XFILLER_39_415 VPWR VGND sg13cmos5l_decap_8
XFILLER_20_4 VPWR VGND sg13cmos5l_decap_8
X_3171_ _3171_/Y _3392_/A _4124_/Q _4123_/Q _3391_/A _3170_/Y VPWR VGND sg13cmos5l_a221oi_1
XFILLER_39_437 VPWR VGND sg13cmos5l_decap_8
XFILLER_48_993 VPWR VGND sg13cmos5l_decap_8
XFILLER_47_470 VPWR VGND sg13cmos5l_decap_8
XFILLER_19_161 VPWR VGND sg13cmos5l_decap_8
XFILLER_23_805 VPWR VGND sg13cmos5l_fill_2
XFILLER_34_153 VPWR VGND sg13cmos5l_fill_1
X_2955_ _2960_/B _2964_/A _2955_/B VPWR VGND sg13cmos5l_and2_1
XFILLER_31_882 VPWR VGND sg13cmos5l_decap_8
X_2886_ _2887_/C _2914_/A _2889_/B VPWR VGND sg13cmos5l_nand2_1
X_3507_ _4213_/D _3560_/B _3564_/B VPWR VGND sg13cmos5l_and2_1
Xhold588 _3388_/B _4163_/Q VPWR VGND sg13cmos5l_dlygate4sd3_1
X_3438_ _3438_/X _4201_/Q _3438_/B _3438_/C VPWR VGND sg13cmos5l_or3_1
Xhold599 _2750_/B _4049_/Q VPWR VGND sg13cmos5l_dlygate4sd3_1
X_3369_ _3371_/B _3365_/Y _3366_/Y _3368_/Y VPWR VGND sg13cmos5l_o21ai_1
XFILLER_46_919 VPWR VGND sg13cmos5l_decap_8
XFILLER_39_993 VPWR VGND sg13cmos5l_decap_8
XFILLER_38_492 VPWR VGND sg13cmos5l_decap_8
XFILLER_41_624 VPWR VGND sg13cmos5l_decap_8
XFILLER_15_21 VPWR VGND sg13cmos5l_fill_1
XFILLER_25_175 VPWR VGND sg13cmos5l_decap_8
XFILLER_26_698 VPWR VGND sg13cmos5l_fill_1
XFILLER_41_668 VPWR VGND sg13cmos5l_decap_8
XFILLER_40_145 VPWR VGND sg13cmos5l_fill_1
XFILLER_22_871 VPWR VGND sg13cmos5l_fill_1
XFILLER_31_20 VPWR VGND sg13cmos5l_fill_2
XFILLER_31_31 VPWR VGND sg13cmos5l_decap_4
XFILLER_31_42 VPWR VGND sg13cmos5l_fill_2
XFILLER_5_525 VPWR VGND sg13cmos5l_fill_2
XFILLER_0_241 VPWR VGND sg13cmos5l_fill_2
XFILLER_1_764 VPWR VGND sg13cmos5l_decap_8
XFILLER_49_779 VPWR VGND sg13cmos5l_decap_8
XFILLER_36_418 VPWR VGND sg13cmos5l_fill_2
XFILLER_45_985 VPWR VGND sg13cmos5l_decap_8
XFILLER_44_484 VPWR VGND sg13cmos5l_decap_4
XFILLER_31_134 VPWR VGND sg13cmos5l_fill_2
X_4087__573 _4087_/RESET_B VPWR VGND sg13cmos5l_tiehi
X_2740_ _2740_/Y _2857_/B _2740_/B VPWR VGND sg13cmos5l_nor2_1
X_2671_ _2671_/Y _2603_/A _3933_/Q VPWR VGND sg13cmos5l_nand2b_1
X_4272_ _4272_/Q _4277_/CLK _4272_/D _4272_/RESET_B VPWR VGND sg13cmos5l_dfrbpq_1
X_3223_ _3224_/C _3255_/A _3223_/B VPWR VGND sg13cmos5l_nor2_1
XFILLER_27_407 VPWR VGND sg13cmos5l_decap_4
X_3154_ _3157_/A _3154_/A _3154_/B VPWR VGND sg13cmos5l_nor2_1
XFILLER_48_790 VPWR VGND sg13cmos5l_decap_8
X_3085_ _3085_/Y _3078_/A _3073_/X _3088_/A VPWR VGND sg13cmos5l_a21oi_1
XFILLER_36_996 VPWR VGND sg13cmos5l_decap_8
XFILLER_11_819 VPWR VGND sg13cmos5l_decap_8
X_3987_ _3987_/Q _4027_/CLK _3987_/D _3987_/RESET_B VPWR VGND sg13cmos5l_dfrbpq_1
X_2938_ _3147_/A _2931_/B _2938_/B VPWR VGND sg13cmos5l_nand2b_1
X_2869_ _4094_/D _2885_/B _2869_/B VPWR VGND sg13cmos5l_nor2_1
XFILLER_2_506 VPWR VGND sg13cmos5l_decap_8
XFILLER_2_517 VPWR VGND sg13cmos5l_fill_2
XFILLER_45_204 VPWR VGND sg13cmos5l_fill_2
XFILLER_26_462 VPWR VGND sg13cmos5l_decap_8
XFILLER_42_933 VPWR VGND sg13cmos5l_decap_8
XFILLER_9_116 VPWR VGND sg13cmos5l_decap_8
XFILLER_42_96 VPWR VGND sg13cmos5l_decap_8
XFILLER_5_300 VPWR VGND sg13cmos5l_decap_8
XFILLER_10_885 VPWR VGND sg13cmos5l_decap_8
XFILLER_10_896 VPWR VGND sg13cmos5l_fill_2
X_4065__178 _4065_/D VPWR VGND sg13cmos5l_tielo
XFILLER_6_878 VPWR VGND sg13cmos5l_decap_4
XFILLER_5_388 VPWR VGND sg13cmos5l_decap_8
XFILLER_3_13 VPWR VGND sg13cmos5l_fill_1
XFILLER_3_46 VPWR VGND sg13cmos5l_fill_1
X_4119__525 _4119_/RESET_B VPWR VGND sg13cmos5l_tiehi
XFILLER_37_716 VPWR VGND sg13cmos5l_fill_2
XFILLER_37_705 VPWR VGND sg13cmos5l_decap_8
X_4193__443 _4193_/RESET_B VPWR VGND sg13cmos5l_tiehi
XFILLER_49_587 VPWR VGND sg13cmos5l_decap_8
XFILLER_36_226 VPWR VGND sg13cmos5l_decap_8
XFILLER_17_451 VPWR VGND sg13cmos5l_fill_1
XFILLER_17_462 VPWR VGND sg13cmos5l_fill_2
X_3910_ _3910_/Q _4027_/CLK _3910_/D _3910_/RESET_B VPWR VGND sg13cmos5l_dfrbpq_1
XFILLER_17_495 VPWR VGND sg13cmos5l_decap_8
XFILLER_33_955 VPWR VGND sg13cmos5l_decap_8
X_3841_ _3841_/Y _2247_/B _3834_/X _3836_/Y _3840_/X VPWR VGND sg13cmos5l_a22oi_1
XFILLER_20_616 VPWR VGND sg13cmos5l_fill_1
X_3772_ _3772_/X _3770_/B _3768_/Y _3776_/S VPWR VGND sg13cmos5l_mux2_1
X_2723_ _4060_/D _2789_/A _2775_/C VPWR VGND sg13cmos5l_nor2_1
X_4126__518 _4126_/RESET_B VPWR VGND sg13cmos5l_tiehi
X_2654_ _2654_/Y _2654_/A1 _2651_/Y _2652_/Y _2653_/Y _2662_/A VPWR VGND sg13cmos5l_a221oi_1
X_2585_ _2585_/X _3996_/Q _3979_/Q _3962_/Q _3945_/Q _2634_/A _2678_/S1 VPWR VGND
+ sg13cmos5l_mux4_1
Xfanout117 _3872_/A0 input11/X VPWR VGND sg13cmos5l_buf_1
Xfanout106 _2415_/A0 input8/X VPWR VGND sg13cmos5l_buf_1
Xfanout128 _3273_/B _3212_/A VPWR VGND sg13cmos5l_buf_1
X_4255_ _4255_/Q _4259_/CLK _4255_/D _4255_/RESET_B VPWR VGND sg13cmos5l_dfrbpq_1
X_4186_ _4186_/Q _4259_/CLK _4186_/D _4186_/RESET_B VPWR VGND sg13cmos5l_dfrbpq_1
X_3206_ _3206_/Y _2177_/A _3553_/A2 _3555_/A VPWR VGND sg13cmos5l_o21ai_1
X_3137_ _3137_/X _3137_/A _3137_/B _3137_/C VPWR VGND sg13cmos5l_and3_1
XFILLER_28_738 VPWR VGND sg13cmos5l_decap_8
XFILLER_27_259 VPWR VGND sg13cmos5l_decap_8
XFILLER_24_900 VPWR VGND sg13cmos5l_decap_8
X_3068_ _3069_/B _4134_/Q _3073_/B _3054_/Y VPWR VGND sg13cmos5l_a21oi_1
XFILLER_23_410 VPWR VGND sg13cmos5l_decap_8
XFILLER_35_292 VPWR VGND sg13cmos5l_fill_1
XFILLER_23_465 VPWR VGND sg13cmos5l_fill_1
XFILLER_24_966 VPWR VGND sg13cmos5l_decap_4
XFILLER_11_616 VPWR VGND sg13cmos5l_fill_1
XFILLER_11_649 VPWR VGND sg13cmos5l_decap_8
XFILLER_12_11 VPWR VGND sg13cmos5l_decap_4
XFILLER_3_804 VPWR VGND sg13cmos5l_decap_8
XFILLER_2_303 VPWR VGND sg13cmos5l_decap_8
XFILLER_2_314 VPWR VGND sg13cmos5l_fill_1
XFILLER_12_99 VPWR VGND sg13cmos5l_fill_1
XFILLER_2_369 VPWR VGND sg13cmos5l_decap_8
XFILLER_18_215 VPWR VGND sg13cmos5l_fill_2
XFILLER_19_716 VPWR VGND sg13cmos5l_decap_8
X_4077__583 _4077_/RESET_B VPWR VGND sg13cmos5l_tiehi
XFILLER_18_248 VPWR VGND sg13cmos5l_decap_8
XFILLER_46_579 VPWR VGND sg13cmos5l_fill_2
XFILLER_42_741 VPWR VGND sg13cmos5l_fill_2
XFILLER_15_988 VPWR VGND sg13cmos5l_decap_8
XFILLER_26_292 VPWR VGND sg13cmos5l_fill_1
XFILLER_14_476 VPWR VGND sg13cmos5l_decap_4
X_4084__576 _4084_/RESET_B VPWR VGND sg13cmos5l_tiehi
XFILLER_6_686 VPWR VGND sg13cmos5l_decap_8
XFILLER_6_675 VPWR VGND sg13cmos5l_fill_1
X_2370_ _3968_/D _2419_/A0 hold745/X _2371_/S VPWR VGND sg13cmos5l_mux2_1
XFILLER_2_870 VPWR VGND sg13cmos5l_decap_8
X_4040_ _4040_/Q clkload2/A _4040_/D _4040_/RESET_B VPWR VGND sg13cmos5l_dfrbpq_1
XFILLER_49_373 VPWR VGND sg13cmos5l_decap_4
X_3878__442 _3878_/RESET_B VPWR VGND sg13cmos5l_tiehi
X_4091__569 _4091_/RESET_B VPWR VGND sg13cmos5l_tiehi
XFILLER_21_903 VPWR VGND sg13cmos5l_fill_1
XFILLER_20_424 VPWR VGND sg13cmos5l_decap_8
X_3824_ _3829_/B _4267_/Q _4266_/Q _4274_/Q VPWR VGND sg13cmos5l_o21ai_1
X_3755_ _3755_/X _3755_/A _3768_/B VPWR VGND sg13cmos5l_and2_1
XFILLER_20_479 VPWR VGND sg13cmos5l_fill_2
X_2706_ _2707_/A _2706_/A _2705_/Y VPWR VGND sg13cmos5l_nor2b_1
X_3686_ _3686_/Y _4265_/Q _3686_/B _3686_/C VPWR VGND sg13cmos5l_nand3b_1
X_2637_ _2637_/Y _2639_/A _3941_/Q VPWR VGND sg13cmos5l_nand2b_1
X_2568_ _2568_/Y _2568_/A _3906_/Q VPWR VGND sg13cmos5l_nor2b_1
X_2499_ _2505_/A _3833_/B _2451_/A hold935/X VPWR VGND sg13cmos5l_o21ai_1
X_4238_ _4238_/Q _4259_/CLK _4238_/D _4238_/RESET_B VPWR VGND sg13cmos5l_dfrbpq_1
XFILLER_28_502 VPWR VGND sg13cmos5l_decap_8
XFILLER_28_546 VPWR VGND sg13cmos5l_decap_8
X_4169_ _4169_/Q _4173_/CLK _4169_/D _4169_/RESET_B VPWR VGND sg13cmos5l_dfrbpq_1
XFILLER_43_505 VPWR VGND sg13cmos5l_decap_8
XFILLER_24_741 VPWR VGND sg13cmos5l_decap_4
XFILLER_11_413 VPWR VGND sg13cmos5l_decap_8
XFILLER_24_774 VPWR VGND sg13cmos5l_decap_8
XFILLER_12_958 VPWR VGND sg13cmos5l_decap_8
XFILLER_23_32 VPWR VGND sg13cmos5l_decap_8
X_4109__535 _4109_/RESET_B VPWR VGND sg13cmos5l_tiehi
XFILLER_3_623 VPWR VGND sg13cmos5l_fill_1
XFILLER_47_833 VPWR VGND sg13cmos5l_decap_8
XFILLER_48_95 VPWR VGND sg13cmos5l_fill_1
XFILLER_19_513 VPWR VGND sg13cmos5l_fill_1
X_4116__528 _4116_/RESET_B VPWR VGND sg13cmos5l_tiehi
XFILLER_0_14 VPWR VGND sg13cmos5l_decap_8
X_4034__239 _4034_/RESET_B VPWR VGND sg13cmos5l_tiehi
X_4270__481 _4270_/RESET_B VPWR VGND sg13cmos5l_tiehi
XFILLER_15_752 VPWR VGND sg13cmos5l_decap_4
XFILLER_31_1013 VPWR VGND sg13cmos5l_decap_8
XFILLER_7_951 VPWR VGND sg13cmos5l_decap_8
X_3540_ _4217_/D _3540_/A _3540_/B VPWR VGND sg13cmos5l_nor2_1
Xhold918 _3373_/B _3372_/X VPWR VGND sg13cmos5l_dlygate4sd3_1
Xhold907 _4095_/D _2871_/Y VPWR VGND sg13cmos5l_dlygate4sd3_1
XFILLER_6_494 VPWR VGND sg13cmos5l_decap_8
X_3471_ _3471_/Y _3467_/Y _3469_/Y _3470_/Y _4235_/Q VPWR VGND sg13cmos5l_a22oi_1
Xhold929 _3256_/A _4168_/Q VPWR VGND sg13cmos5l_dlygate4sd3_1
X_2422_ _2647_/A _2422_/A _2422_/B VPWR VGND sg13cmos5l_and2_1
XFILLER_9_1025 VPWR VGND sg13cmos5l_decap_4
X_2353_ _3953_/D _2413_/A0 hold693/X _2361_/S VPWR VGND sg13cmos5l_mux2_1
X_4023_ _4023_/Q _4265_/CLK _4023_/D _4023_/RESET_B VPWR VGND sg13cmos5l_dfrbpq_1
X_2284_ _2285_/B input3/X _2519_/A _2290_/C VPWR VGND sg13cmos5l_nand3_1
XFILLER_38_855 VPWR VGND sg13cmos5l_decap_8
XFILLER_38_833 VPWR VGND sg13cmos5l_decap_4
XFILLER_37_365 VPWR VGND sg13cmos5l_decap_8
XFILLER_37_343 VPWR VGND sg13cmos5l_fill_1
XFILLER_40_519 VPWR VGND sg13cmos5l_fill_2
XFILLER_21_755 VPWR VGND sg13cmos5l_decap_8
X_3807_ _3814_/S _3804_/Y _3806_/Y _3736_/Y VPWR VGND sg13cmos5l_o21ai_1
XFILLER_20_298 VPWR VGND sg13cmos5l_fill_1
X_3738_ _3740_/B _3738_/A _3738_/B VPWR VGND sg13cmos5l_xnor2_1
X_3669_ _3669_/Y _4220_/Q _2204_/Y _4265_/Q _3668_/Y VPWR VGND sg13cmos5l_a22oi_1
X_4126__167 _4126_/D VPWR VGND sg13cmos5l_tielo
XFILLER_0_626 VPWR VGND sg13cmos5l_decap_8
XFILLER_47_107 VPWR VGND sg13cmos5l_decap_8
XFILLER_29_844 VPWR VGND sg13cmos5l_fill_2
X_3900__479 _3900_/RESET_B VPWR VGND sg13cmos5l_tiehi
XFILLER_44_869 VPWR VGND sg13cmos5l_decap_8
XFILLER_34_20 VPWR VGND sg13cmos5l_fill_2
XFILLER_34_97 VPWR VGND sg13cmos5l_decap_4
XFILLER_7_236 VPWR VGND sg13cmos5l_decap_8
XFILLER_4_910 VPWR VGND sg13cmos5l_decap_8
X_4081__579 _4081_/RESET_B VPWR VGND sg13cmos5l_tiehi
XFILLER_4_987 VPWR VGND sg13cmos5l_decap_8
XFILLER_3_497 VPWR VGND sg13cmos5l_decap_4
X_4255__218 _4255_/RESET_B VPWR VGND sg13cmos5l_tiehi
XFILLER_47_652 VPWR VGND sg13cmos5l_fill_1
XFILLER_19_365 VPWR VGND sg13cmos5l_fill_1
XFILLER_35_847 VPWR VGND sg13cmos5l_decap_8
XFILLER_34_357 VPWR VGND sg13cmos5l_fill_2
X_2971_ _2984_/B _4091_/Q _4089_/Q _4090_/Q VPWR VGND sg13cmos5l_or3_1
XFILLER_15_560 VPWR VGND sg13cmos5l_decap_4
XFILLER_43_891 VPWR VGND sg13cmos5l_decap_8
XFILLER_15_593 VPWR VGND sg13cmos5l_fill_2
XFILLER_7_770 VPWR VGND sg13cmos5l_decap_8
Xhold715 hold715/X _3984_/Q VPWR VGND sg13cmos5l_dlygate4sd3_1
X_3523_ _3523_/Y _3713_/A _3531_/A VPWR VGND sg13cmos5l_nor2_1
Xhold726 _2516_/A _4042_/Q VPWR VGND sg13cmos5l_dlygate4sd3_1
Xhold737 hold737/X _3889_/Q VPWR VGND sg13cmos5l_dlygate4sd3_1
Xhold704 hold704/X _3945_/Q VPWR VGND sg13cmos5l_dlygate4sd3_1
Xhold748 hold748/X _3999_/Q VPWR VGND sg13cmos5l_dlygate4sd3_1
Xhold759 hold759/X _3880_/Q VPWR VGND sg13cmos5l_dlygate4sd3_1
X_3454_ _3756_/A _3764_/C _3485_/B VPWR VGND sg13cmos5l_nand2b_1
X_2405_ _3997_/D _2414_/A0 hold788/X _2411_/S VPWR VGND sg13cmos5l_mux2_1
X_3385_ _3385_/Y _2170_/A _3708_/A2 _3389_/A VPWR VGND sg13cmos5l_o21ai_1
X_2336_ _3939_/D _3859_/A0 hold728/X _2341_/S VPWR VGND sg13cmos5l_mux2_1
X_2267_ _2496_/A _3833_/B _2267_/B VPWR VGND sg13cmos5l_nand2b_1
X_4006_ _4006_/Q _4011_/CLK _4006_/D _4006_/RESET_B VPWR VGND sg13cmos5l_dfrbpq_1
XFILLER_37_173 VPWR VGND sg13cmos5l_fill_1
XFILLER_37_162 VPWR VGND sg13cmos5l_decap_8
X_2198_ _2198_/Y _2198_/A VPWR VGND sg13cmos5l_inv_1
XFILLER_38_1019 VPWR VGND sg13cmos5l_decap_8
XFILLER_4_239 VPWR VGND sg13cmos5l_decap_8
XFILLER_20_11 VPWR VGND sg13cmos5l_decap_8
X_4106__538 _4106_/RESET_B VPWR VGND sg13cmos5l_tiehi
XFILLER_0_445 VPWR VGND sg13cmos5l_decap_8
XFILLER_1_946 VPWR VGND sg13cmos5l_decap_8
XFILLER_29_31 VPWR VGND sg13cmos5l_decap_8
XFILLER_48_449 VPWR VGND sg13cmos5l_decap_4
XFILLER_21_1001 VPWR VGND sg13cmos5l_decap_8
XFILLER_45_30 VPWR VGND sg13cmos5l_fill_2
XFILLER_45_74 VPWR VGND sg13cmos5l_decap_8
XFILLER_44_699 VPWR VGND sg13cmos5l_fill_1
XFILLER_43_154 VPWR VGND sg13cmos5l_decap_8
XFILLER_43_198 VPWR VGND sg13cmos5l_decap_8
XFILLER_43_187 VPWR VGND sg13cmos5l_fill_1
XFILLER_3_294 VPWR VGND sg13cmos5l_decap_8
XFILLER_6_1028 VPWR VGND sg13cmos5l_fill_1
XFILLER_6_1017 VPWR VGND sg13cmos5l_decap_8
X_3170_ _3170_/Y _4171_/Q _3185_/B _3176_/B _4170_/Q VPWR VGND sg13cmos5l_a22oi_1
XFILLER_13_4 VPWR VGND sg13cmos5l_decap_4
XFILLER_48_972 VPWR VGND sg13cmos5l_decap_8
XFILLER_35_633 VPWR VGND sg13cmos5l_decap_4
XFILLER_34_132 VPWR VGND sg13cmos5l_decap_8
XFILLER_35_666 VPWR VGND sg13cmos5l_decap_8
XFILLER_35_699 VPWR VGND sg13cmos5l_decap_8
X_2954_ _2965_/S _2955_/B _2960_/A VPWR VGND sg13cmos5l_nor2_1
X_2885_ _4107_/D _2885_/A _2885_/B VPWR VGND sg13cmos5l_nor2_1
X_3506_ _3564_/B _3498_/Y _3304_/X _3509_/S VPWR VGND sg13cmos5l_mux2_1
X_3437_ _3440_/B _3425_/Y _3431_/Y _3436_/Y VPWR VGND sg13cmos5l_o21ai_1
Xhold589 _3041_/B _4101_/Q VPWR VGND sg13cmos5l_dlygate4sd3_1
XFILLER_44_1023 VPWR VGND sg13cmos5l_decap_4
X_3368_ _3368_/Y hold874/X _3357_/Y _3367_/Y _3378_/B VPWR VGND sg13cmos5l_a22oi_1
X_2319_ _3925_/D _3873_/A0 hold697/X _2321_/S VPWR VGND sg13cmos5l_mux2_1
XFILLER_39_972 VPWR VGND sg13cmos5l_decap_8
Xheichips26_dna_sequencer_150 uo_out[7] VPWR VGND sg13cmos5l_tielo
X_3299_ _3299_/X _4202_/Q _3309_/B VPWR VGND sg13cmos5l_and2_1
XFILLER_25_121 VPWR VGND sg13cmos5l_decap_4
XFILLER_21_360 VPWR VGND sg13cmos5l_fill_1
XFILLER_21_371 VPWR VGND sg13cmos5l_fill_2
XFILLER_5_548 VPWR VGND sg13cmos5l_decap_4
XFILLER_1_743 VPWR VGND sg13cmos5l_decap_8
XFILLER_49_758 VPWR VGND sg13cmos5l_decap_8
XFILLER_36_408 VPWR VGND sg13cmos5l_fill_1
XFILLER_45_964 VPWR VGND sg13cmos5l_decap_8
XFILLER_17_633 VPWR VGND sg13cmos5l_decap_4
XFILLER_17_644 VPWR VGND sg13cmos5l_decap_4
XFILLER_17_688 VPWR VGND sg13cmos5l_decap_8
XFILLER_16_176 VPWR VGND sg13cmos5l_decap_4
XFILLER_31_124 VPWR VGND sg13cmos5l_decap_4
XFILLER_31_168 VPWR VGND sg13cmos5l_decap_8
X_2670_ _2676_/B _2666_/Y _2667_/Y _2669_/Y _2670_/B2 _2680_/A1 VPWR VGND sg13cmos5l_a221oi_1
XFILLER_8_397 VPWR VGND sg13cmos5l_decap_8
XFILLER_9_898 VPWR VGND sg13cmos5l_decap_8
XFILLER_4_581 VPWR VGND sg13cmos5l_decap_8
X_4271_ _4271_/Q _4277_/CLK _4271_/D _4271_/RESET_B VPWR VGND sg13cmos5l_dfrbpq_1
XFILLER_28_1018 VPWR VGND sg13cmos5l_decap_8
X_3222_ _3224_/B _3222_/A _3222_/B VPWR VGND sg13cmos5l_nor2_1
XFILLER_39_213 VPWR VGND sg13cmos5l_decap_8
X_3153_ _3165_/S _3160_/B _3160_/C VPWR VGND sg13cmos5l_nand2_1
XFILLER_39_279 VPWR VGND sg13cmos5l_decap_8
X_3084_ _3088_/A _3082_/Y _3083_/Y _3064_/Y VPWR VGND sg13cmos5l_a21o_1
XFILLER_23_603 VPWR VGND sg13cmos5l_decap_8
XFILLER_36_975 VPWR VGND sg13cmos5l_decap_8
X_3986_ _3986_/Q clkload6/A _3986_/D _3986_/RESET_B VPWR VGND sg13cmos5l_dfrbpq_1
X_2937_ _2938_/B _4139_/Q _4140_/Q _4141_/Q VPWR VGND sg13cmos5l_o21ai_1
XFILLER_11_1011 VPWR VGND sg13cmos5l_decap_8
X_2868_ _2868_/X _2859_/B _3013_/B _2868_/S VPWR VGND sg13cmos5l_mux2_1
X_2799_ _2977_/B _4111_/Q _2799_/B VPWR VGND sg13cmos5l_xnor2_1
XFILLER_26_32 VPWR VGND sg13cmos5l_fill_2
XFILLER_27_964 VPWR VGND sg13cmos5l_decap_4
XFILLER_42_912 VPWR VGND sg13cmos5l_decap_8
XFILLER_42_989 VPWR VGND sg13cmos5l_decap_8
XFILLER_13_146 VPWR VGND sg13cmos5l_decap_4
XFILLER_14_658 VPWR VGND sg13cmos5l_fill_1
XFILLER_22_680 VPWR VGND sg13cmos5l_decap_8
XFILLER_10_842 VPWR VGND sg13cmos5l_decap_4
XFILLER_3_25 VPWR VGND sg13cmos5l_decap_8
XFILLER_49_511 VPWR VGND sg13cmos5l_decap_8
XFILLER_3_58 VPWR VGND sg13cmos5l_decap_8
XFILLER_36_205 VPWR VGND sg13cmos5l_fill_2
XFILLER_18_931 VPWR VGND sg13cmos5l_decap_8
XFILLER_45_772 VPWR VGND sg13cmos5l_fill_1
XFILLER_18_997 VPWR VGND sg13cmos5l_decap_8
XFILLER_33_934 VPWR VGND sg13cmos5l_decap_8
X_3840_ _3840_/X _2247_/B _4269_/Q _3843_/B VPWR VGND sg13cmos5l_a21o_1
X_3771_ _3771_/Y _4212_/Q _3768_/B _3776_/S VPWR VGND sg13cmos5l_o21ai_1
XFILLER_20_628 VPWR VGND sg13cmos5l_decap_4
XFILLER_32_477 VPWR VGND sg13cmos5l_decap_4
XFILLER_32_488 VPWR VGND sg13cmos5l_decap_4
XFILLER_34_1011 VPWR VGND sg13cmos5l_decap_8
X_2722_ _2775_/C _2721_/A _2720_/Y _2721_/Y VPWR VGND sg13cmos5l_a21oi_1
XFILLER_8_172 VPWR VGND sg13cmos5l_decap_8
X_2653_ _2653_/Y _2639_/A _3912_/Q _2654_/A1 VPWR VGND sg13cmos5l_a21oi_1
X_2584_ _2584_/Y _2654_/A1 _2582_/Y _2583_/Y _2580_/Y _2662_/A VPWR VGND sg13cmos5l_a221oi_1
Xfanout107 _3867_/A input8/X VPWR VGND sg13cmos5l_buf_1
Xfanout118 _2417_/A0 input10/X VPWR VGND sg13cmos5l_buf_1
Xfanout129 _3041_/A _3212_/A VPWR VGND sg13cmos5l_buf_1
X_4254_ _4254_/Q _4277_/CLK _4254_/D _4254_/RESET_B VPWR VGND sg13cmos5l_dfrbpq_1
X_4185_ _4185_/Q _4259_/CLK _4185_/D _4185_/RESET_B VPWR VGND sg13cmos5l_dfrbpq_1
X_3205_ _4159_/D _2181_/Y _3706_/A2 _3204_/Y VPWR VGND sg13cmos5l_a21oi_1
XFILLER_28_706 VPWR VGND sg13cmos5l_fill_2
X_3136_ _3137_/C _4117_/Q _4118_/Q _4119_/Q VPWR VGND sg13cmos5l_o21ai_1
XFILLER_27_249 VPWR VGND sg13cmos5l_decap_4
X_3067_ _3078_/A _3062_/A _3073_/B _3066_/Y VPWR VGND sg13cmos5l_a21oi_1
XFILLER_11_639 VPWR VGND sg13cmos5l_fill_1
XFILLER_23_477 VPWR VGND sg13cmos5l_decap_4
X_3969_ _3969_/Q clkload6/A _3969_/D _3969_/RESET_B VPWR VGND sg13cmos5l_dfrbpq_1
XFILLER_12_34 VPWR VGND sg13cmos5l_decap_4
XFILLER_12_78 VPWR VGND sg13cmos5l_decap_8
XFILLER_37_64 VPWR VGND sg13cmos5l_fill_2
XFILLER_14_411 VPWR VGND sg13cmos5l_decap_4
XFILLER_15_923 VPWR VGND sg13cmos5l_decap_8
XFILLER_33_219 VPWR VGND sg13cmos5l_decap_4
XFILLER_14_444 VPWR VGND sg13cmos5l_decap_8
XFILLER_15_967 VPWR VGND sg13cmos5l_decap_8
XFILLER_30_915 VPWR VGND sg13cmos5l_decap_8
XFILLER_14_499 VPWR VGND sg13cmos5l_decap_8
XFILLER_10_683 VPWR VGND sg13cmos5l_decap_8
XFILLER_5_164 VPWR VGND sg13cmos5l_decap_8
XFILLER_49_341 VPWR VGND sg13cmos5l_decap_8
X_4050__212 _4050_/RESET_B VPWR VGND sg13cmos5l_tiehi
X_3823_ _3823_/Y _3829_/A _3821_/Y _3822_/Y VPWR VGND sg13cmos5l_a21oi_1
X_3754_ _3768_/B _4216_/Q _3754_/B VPWR VGND sg13cmos5l_or2_1
X_2705_ _2705_/Y _4059_/Q _4060_/Q _4061_/Q VPWR VGND sg13cmos5l_o21ai_1
X_3685_ _3685_/X _4247_/Q _3685_/B VPWR VGND sg13cmos5l_or2_1
X_2636_ _2642_/B _2632_/Y _2633_/Y _2635_/Y _2678_/S1 _2680_/A1 VPWR VGND sg13cmos5l_a221oi_1
X_2567_ _2567_/Y _2568_/A _3923_/Q _2643_/S1 VPWR VGND sg13cmos5l_a21oi_1
X_2498_ _2498_/Y _2497_/Y _2498_/B VPWR VGND sg13cmos5l_nand2b_1
X_4237_ _4237_/Q _4237_/CLK _4237_/D _4237_/RESET_B VPWR VGND sg13cmos5l_dfrbpq_1
XFILLER_28_525 VPWR VGND sg13cmos5l_fill_1
X_4168_ _4168_/Q _4168_/CLK _4168_/D _4168_/RESET_B VPWR VGND sg13cmos5l_dfrbpq_1
XFILLER_16_709 VPWR VGND sg13cmos5l_decap_8
X_3119_ _3119_/X _3104_/A _3118_/Y _3122_/S VPWR VGND sg13cmos5l_mux2_1
X_4099_ _4099_/Q _4129_/CLK _4099_/D _4099_/RESET_B VPWR VGND sg13cmos5l_dfrbpq_1
XFILLER_24_720 VPWR VGND sg13cmos5l_decap_8
XFILLER_36_591 VPWR VGND sg13cmos5l_fill_1
XFILLER_12_926 VPWR VGND sg13cmos5l_fill_2
XFILLER_20_992 VPWR VGND sg13cmos5l_decap_8
XFILLER_24_1010 VPWR VGND sg13cmos5l_decap_8
XFILLER_47_812 VPWR VGND sg13cmos5l_decap_8
XFILLER_47_889 VPWR VGND sg13cmos5l_decap_8
XFILLER_19_569 VPWR VGND sg13cmos5l_decap_4
X_4090__570 _4090_/RESET_B VPWR VGND sg13cmos5l_tiehi
XFILLER_46_377 VPWR VGND sg13cmos5l_fill_1
XFILLER_7_930 VPWR VGND sg13cmos5l_decap_8
Xhold919 _2174_/A _4218_/Q VPWR VGND sg13cmos5l_dlygate4sd3_1
Xhold908 _3557_/A _4202_/Q VPWR VGND sg13cmos5l_dlygate4sd3_1
X_3470_ _3470_/Y _4208_/Q _4207_/Q _3769_/A VPWR VGND sg13cmos5l_nand3b_1
XFILLER_43_4 VPWR VGND sg13cmos5l_decap_4
XFILLER_9_1004 VPWR VGND sg13cmos5l_decap_8
X_2421_ _4012_/D input5/X hold666/X _2421_/S VPWR VGND sg13cmos5l_mux2_1
X_2352_ _2358_/S _2474_/B _3855_/D _2352_/C VPWR VGND sg13cmos5l_nand3_1
X_2283_ _2290_/C _4025_/Q _2283_/B VPWR VGND sg13cmos5l_nand2_1
XFILLER_38_812 VPWR VGND sg13cmos5l_decap_8
X_4022_ _4022_/Q _4027_/CLK _4022_/D _4022_/RESET_B VPWR VGND sg13cmos5l_dfrbpq_1
XFILLER_49_182 VPWR VGND sg13cmos5l_fill_1
XFILLER_37_322 VPWR VGND sg13cmos5l_decap_8
XFILLER_38_878 VPWR VGND sg13cmos5l_decap_8
XFILLER_25_506 VPWR VGND sg13cmos5l_decap_8
XFILLER_33_594 VPWR VGND sg13cmos5l_fill_1
X_3806_ _3806_/Y _3799_/A _3802_/Y _3805_/Y VPWR VGND sg13cmos5l_o21ai_1
XFILLER_21_789 VPWR VGND sg13cmos5l_fill_1
X_3737_ _3738_/B _4255_/Q _3719_/Y _3716_/Y VPWR VGND sg13cmos5l_a21oi_1
X_3668_ _3668_/Y _4221_/Q _4264_/Q VPWR VGND sg13cmos5l_nand2_1
X_3599_ _3599_/X _3600_/A _3600_/B VPWR VGND sg13cmos5l_and2_1
X_2619_ _2619_/Y _2616_/A _3920_/Q _2641_/B2 VPWR VGND sg13cmos5l_a21oi_1
XFILLER_0_605 VPWR VGND sg13cmos5l_fill_2
XFILLER_18_33 VPWR VGND sg13cmos5l_decap_8
XFILLER_28_344 VPWR VGND sg13cmos5l_decap_8
XFILLER_28_355 VPWR VGND sg13cmos5l_fill_2
XFILLER_44_848 VPWR VGND sg13cmos5l_decap_8
XFILLER_18_88 VPWR VGND sg13cmos5l_decap_4
X_4074__587 _4074_/RESET_B VPWR VGND sg13cmos5l_tiehi
XFILLER_43_336 VPWR VGND sg13cmos5l_fill_2
X_4248__248 _4248_/RESET_B VPWR VGND sg13cmos5l_tiehi
XFILLER_11_222 VPWR VGND sg13cmos5l_fill_1
XFILLER_12_723 VPWR VGND sg13cmos5l_decap_8
XFILLER_15_1009 VPWR VGND sg13cmos5l_decap_8
XFILLER_8_738 VPWR VGND sg13cmos5l_fill_1
XFILLER_7_215 VPWR VGND sg13cmos5l_decap_8
XFILLER_3_421 VPWR VGND sg13cmos5l_decap_8
XFILLER_4_966 VPWR VGND sg13cmos5l_decap_8
XFILLER_3_432 VPWR VGND sg13cmos5l_fill_1
X_4122__522 _4122_/RESET_B VPWR VGND sg13cmos5l_tiehi
XFILLER_1_0 VPWR VGND sg13cmos5l_decap_8
XFILLER_15_8 VPWR VGND sg13cmos5l_decap_8
XFILLER_35_815 VPWR VGND sg13cmos5l_decap_8
XFILLER_46_174 VPWR VGND sg13cmos5l_fill_1
XFILLER_19_388 VPWR VGND sg13cmos5l_fill_2
XFILLER_34_347 VPWR VGND sg13cmos5l_fill_1
X_2970_ _2975_/B _4091_/Q _4089_/Q _4090_/Q VPWR VGND sg13cmos5l_nor3_1
XFILLER_43_870 VPWR VGND sg13cmos5l_decap_8
XFILLER_30_520 VPWR VGND sg13cmos5l_fill_1
Xhold716 hold716/X _3935_/Q VPWR VGND sg13cmos5l_dlygate4sd3_1
Xhold705 hold705/X _3928_/Q VPWR VGND sg13cmos5l_dlygate4sd3_1
X_3522_ _3522_/Y _4189_/Q _3522_/B _3528_/S VPWR VGND sg13cmos5l_nor3_1
Xhold727 _4039_/D _2515_/Y VPWR VGND sg13cmos5l_dlygate4sd3_1
X_3453_ _3485_/B _4235_/Q _4236_/Q _3453_/B1 VPWR VGND sg13cmos5l_o21ai_1
Xhold738 hold738/X _3921_/Q VPWR VGND sg13cmos5l_dlygate4sd3_1
Xhold749 hold749/X _3886_/Q VPWR VGND sg13cmos5l_dlygate4sd3_1
X_2404_ _3996_/D _2413_/A0 hold810/X _2411_/S VPWR VGND sg13cmos5l_mux2_1
X_3384_ _3384_/Y _2177_/Y _3708_/A2 _3383_/Y VPWR VGND sg13cmos5l_a21oi_1
XFILLER_34_0 VPWR VGND sg13cmos5l_decap_4
X_2335_ _3938_/D _3867_/A hold764/X _2341_/S VPWR VGND sg13cmos5l_mux2_1
X_2266_ _2266_/Y _2273_/B _3833_/B _2451_/A VPWR VGND sg13cmos5l_nor3_1
X_4005_ _4005_/Q _4011_/CLK _4005_/D _4005_/RESET_B VPWR VGND sg13cmos5l_dfrbpq_1
X_2197_ _2342_/B _3846_/B VPWR VGND sg13cmos5l_inv_1
XFILLER_37_185 VPWR VGND sg13cmos5l_decap_8
XFILLER_34_870 VPWR VGND sg13cmos5l_fill_2
XFILLER_33_380 VPWR VGND sg13cmos5l_fill_2
XFILLER_21_586 VPWR VGND sg13cmos5l_decap_4
X_4221__410 _4221_/RESET_B VPWR VGND sg13cmos5l_tiehi
XFILLER_1_925 VPWR VGND sg13cmos5l_decap_8
X_4080__580 _4080_/RESET_B VPWR VGND sg13cmos5l_tiehi
XFILLER_29_21 VPWR VGND sg13cmos5l_fill_1
XFILLER_29_664 VPWR VGND sg13cmos5l_fill_1
XFILLER_16_314 VPWR VGND sg13cmos5l_decap_8
XFILLER_29_697 VPWR VGND sg13cmos5l_decap_8
XFILLER_45_53 VPWR VGND sg13cmos5l_decap_8
XFILLER_16_358 VPWR VGND sg13cmos5l_decap_8
XFILLER_17_859 VPWR VGND sg13cmos5l_decap_8
XFILLER_32_807 VPWR VGND sg13cmos5l_decap_8
XFILLER_12_586 VPWR VGND sg13cmos5l_decap_4
XFILLER_8_579 VPWR VGND sg13cmos5l_fill_2
XFILLER_4_785 VPWR VGND sg13cmos5l_decap_8
XFILLER_39_428 VPWR VGND sg13cmos5l_decap_4
XFILLER_0_991 VPWR VGND sg13cmos5l_decap_8
XFILLER_48_951 VPWR VGND sg13cmos5l_decap_8
X_2953_ _2960_/A _2953_/A _2953_/B _2953_/C VPWR VGND sg13cmos5l_nor3_1
XFILLER_15_380 VPWR VGND sg13cmos5l_decap_8
X_4047__217 _4047_/RESET_B VPWR VGND sg13cmos5l_tiehi
X_2884_ _4106_/D _2884_/A _2884_/B VPWR VGND sg13cmos5l_and2_1
X_3505_ _4212_/D _3560_/B _3505_/B VPWR VGND sg13cmos5l_and2_1
XFILLER_44_1002 VPWR VGND sg13cmos5l_decap_8
X_4023__261 _4023_/RESET_B VPWR VGND sg13cmos5l_tiehi
X_3436_ _3436_/Y _3427_/Y _3429_/Y _3432_/X _3435_/Y VPWR VGND sg13cmos5l_a22oi_1
X_3367_ _3367_/Y _3560_/A _3561_/A _3201_/A _3201_/B VPWR VGND sg13cmos5l_a22oi_1
X_2318_ _2318_/X _3872_/A0 hold667/X _2318_/S VPWR VGND sg13cmos5l_mux2_1
XFILLER_45_409 VPWR VGND sg13cmos5l_fill_2
XFILLER_39_951 VPWR VGND sg13cmos5l_decap_8
X_3298_ _3310_/S _3298_/A _3312_/B VPWR VGND sg13cmos5l_nor2_1
Xheichips26_dna_sequencer_140 uio_oe[7] VPWR VGND sg13cmos5l_tielo
X_2249_ _2502_/B _2510_/A _2504_/A VPWR VGND sg13cmos5l_nor2_1
XFILLER_26_645 VPWR VGND sg13cmos5l_decap_8
XFILLER_26_656 VPWR VGND sg13cmos5l_fill_2
X_4112__532 _4112_/RESET_B VPWR VGND sg13cmos5l_tiehi
XFILLER_25_155 VPWR VGND sg13cmos5l_decap_8
XFILLER_26_667 VPWR VGND sg13cmos5l_fill_2
XFILLER_13_328 VPWR VGND sg13cmos5l_fill_2
XFILLER_15_67 VPWR VGND sg13cmos5l_fill_2
XFILLER_22_862 VPWR VGND sg13cmos5l_decap_8
XFILLER_22_895 VPWR VGND sg13cmos5l_decap_8
XFILLER_5_527 VPWR VGND sg13cmos5l_fill_1
XFILLER_31_77 VPWR VGND sg13cmos5l_decap_8
XFILLER_0_221 VPWR VGND sg13cmos5l_fill_2
XFILLER_0_210 VPWR VGND sg13cmos5l_decap_8
XFILLER_1_722 VPWR VGND sg13cmos5l_decap_8
XFILLER_49_737 VPWR VGND sg13cmos5l_decap_8
XFILLER_0_276 VPWR VGND sg13cmos5l_decap_8
XFILLER_1_799 VPWR VGND sg13cmos5l_decap_8
XFILLER_45_943 VPWR VGND sg13cmos5l_decap_8
XFILLER_44_464 VPWR VGND sg13cmos5l_fill_2
XFILLER_32_637 VPWR VGND sg13cmos5l_decap_8
XFILLER_9_800 VPWR VGND sg13cmos5l_decap_8
XFILLER_13_840 VPWR VGND sg13cmos5l_decap_8
XFILLER_31_158 VPWR VGND sg13cmos5l_decap_4
XFILLER_12_361 VPWR VGND sg13cmos5l_decap_4
XFILLER_9_855 VPWR VGND sg13cmos5l_decap_8
X_4270_ _4270_/Q _4277_/CLK _4270_/D _4270_/RESET_B VPWR VGND sg13cmos5l_dfrbpq_1
X_3221_ _3224_/A _3222_/A _3222_/B _3218_/Y _3219_/Y _3220_/Y VPWR VGND sg13cmos5l_a221oi_1
XFILLER_39_203 VPWR VGND sg13cmos5l_fill_1
X_3152_ _3160_/C _3152_/A _3167_/B VPWR VGND sg13cmos5l_or2_1
X_3083_ _3083_/Y _3064_/A _3064_/B _3080_/A _3080_/B VPWR VGND sg13cmos5l_a22oi_1
XFILLER_35_420 VPWR VGND sg13cmos5l_decap_8
XFILLER_35_431 VPWR VGND sg13cmos5l_decap_8
XFILLER_36_954 VPWR VGND sg13cmos5l_decap_8
X_3985_ _3985_/Q clkload6/A _3985_/D _3985_/RESET_B VPWR VGND sg13cmos5l_dfrbpq_1
XFILLER_22_158 VPWR VGND sg13cmos5l_fill_2
X_2936_ _2959_/A _4116_/Q _2936_/B VPWR VGND sg13cmos5l_xnor2_1
X_2867_ _4093_/D _2885_/B _2867_/B VPWR VGND sg13cmos5l_nor2_1
X_4244__262 _4244_/RESET_B VPWR VGND sg13cmos5l_tiehi
X_2798_ _2976_/A _3047_/A _2799_/B VPWR VGND sg13cmos5l_xnor2_1
XFILLER_7_90 VPWR VGND sg13cmos5l_fill_1
X_3419_ _3419_/Y _3419_/A _3419_/B VPWR VGND sg13cmos5l_xnor2_1
Xhold1010 _2900_/A _4107_/Q VPWR VGND sg13cmos5l_dlygate4sd3_1
XFILLER_45_206 VPWR VGND sg13cmos5l_fill_1
XFILLER_18_409 VPWR VGND sg13cmos5l_decap_8
XFILLER_39_792 VPWR VGND sg13cmos5l_decap_8
XFILLER_26_11 VPWR VGND sg13cmos5l_decap_8
XFILLER_26_431 VPWR VGND sg13cmos5l_decap_8
XFILLER_26_44 VPWR VGND sg13cmos5l_decap_8
XFILLER_27_987 VPWR VGND sg13cmos5l_decap_8
XFILLER_14_637 VPWR VGND sg13cmos5l_decap_8
XFILLER_42_968 VPWR VGND sg13cmos5l_decap_8
XFILLER_41_467 VPWR VGND sg13cmos5l_decap_8
XFILLER_41_456 VPWR VGND sg13cmos5l_decap_8
X_4186__452 _4186_/RESET_B VPWR VGND sg13cmos5l_tiehi
XFILLER_42_76 VPWR VGND sg13cmos5l_decap_8
XFILLER_42_54 VPWR VGND sg13cmos5l_decap_4
XFILLER_6_803 VPWR VGND sg13cmos5l_decap_8
XFILLER_6_858 VPWR VGND sg13cmos5l_fill_2
XFILLER_5_335 VPWR VGND sg13cmos5l_decap_4
XFILLER_49_556 VPWR VGND sg13cmos5l_fill_1
XFILLER_18_954 VPWR VGND sg13cmos5l_decap_8
XFILLER_45_751 VPWR VGND sg13cmos5l_decap_8
X_4152__164 _4152_/D VPWR VGND sg13cmos5l_tielo
XFILLER_17_464 VPWR VGND sg13cmos5l_fill_1
XFILLER_18_976 VPWR VGND sg13cmos5l_decap_8
XFILLER_33_913 VPWR VGND sg13cmos5l_decap_8
XFILLER_44_294 VPWR VGND sg13cmos5l_decap_8
X_3770_ _3770_/X _3776_/S _3770_/B VPWR VGND sg13cmos5l_or2_1
X_2721_ _2721_/Y _2721_/A _2711_/B VPWR VGND sg13cmos5l_nor2b_1
XFILLER_8_151 VPWR VGND sg13cmos5l_decap_8
XFILLER_9_663 VPWR VGND sg13cmos5l_fill_2
XFILLER_9_674 VPWR VGND sg13cmos5l_decap_4
XFILLER_8_195 VPWR VGND sg13cmos5l_decap_8
X_2652_ _2652_/Y _2639_/A _3929_/Q VPWR VGND sg13cmos5l_nand2b_1
X_2583_ _2583_/Y _2639_/A _3911_/Q _2654_/A1 VPWR VGND sg13cmos5l_a21oi_1
Xfanout119 _3871_/A0 input10/X VPWR VGND sg13cmos5l_buf_1
Xfanout108 _2414_/A0 input7/X VPWR VGND sg13cmos5l_buf_1
X_4253_ _4253_/Q _4259_/CLK _4253_/D _4253_/RESET_B VPWR VGND sg13cmos5l_dfrbpq_1
X_4102__542 _4102_/RESET_B VPWR VGND sg13cmos5l_tiehi
X_3204_ _3204_/Y _2178_/A _3706_/A2 _3273_/B VPWR VGND sg13cmos5l_o21ai_1
XFILLER_41_1027 VPWR VGND sg13cmos5l_fill_2
X_4184_ _4184_/Q _4237_/CLK _4184_/D _4184_/RESET_B VPWR VGND sg13cmos5l_dfrbpq_1
X_3135_ _3135_/X _3147_/A _3167_/A VPWR VGND sg13cmos5l_or2_1
X_3066_ _3066_/Y _3079_/A _3065_/Y VPWR VGND sg13cmos5l_nor2b_1
XFILLER_24_957 VPWR VGND sg13cmos5l_fill_2
X_3968_ _3968_/Q clkload6/A _3968_/D _3968_/RESET_B VPWR VGND sg13cmos5l_dfrbpq_1
X_2919_ _2920_/C _2918_/A _2918_/B _2917_/X _2893_/Y VPWR VGND sg13cmos5l_a22oi_1
X_3899_ _3899_/Q clkload8/A _3899_/D _3899_/RESET_B VPWR VGND sg13cmos5l_dfrbpq_1
XFILLER_3_839 VPWR VGND sg13cmos5l_decap_8
XFILLER_2_338 VPWR VGND sg13cmos5l_decap_8
X_3895__224 _3895_/RESET_B VPWR VGND sg13cmos5l_tiehi
XFILLER_46_537 VPWR VGND sg13cmos5l_fill_2
XFILLER_2_1010 VPWR VGND sg13cmos5l_decap_8
XFILLER_33_209 VPWR VGND sg13cmos5l_fill_1
XFILLER_27_795 VPWR VGND sg13cmos5l_decap_8
XFILLER_15_957 VPWR VGND sg13cmos5l_decap_4
XFILLER_18_1018 VPWR VGND sg13cmos5l_decap_8
XFILLER_42_776 VPWR VGND sg13cmos5l_fill_2
XFILLER_41_264 VPWR VGND sg13cmos5l_fill_2
XFILLER_1_371 VPWR VGND sg13cmos5l_fill_1
XFILLER_49_331 VPWR VGND sg13cmos5l_fill_1
XFILLER_49_386 VPWR VGND sg13cmos5l_decap_8
XFILLER_37_548 VPWR VGND sg13cmos5l_fill_2
XFILLER_33_743 VPWR VGND sg13cmos5l_fill_2
XFILLER_33_765 VPWR VGND sg13cmos5l_decap_4
X_3822_ _3822_/Y _2271_/C _3829_/A _3827_/B1 VPWR VGND sg13cmos5l_o21ai_1
XFILLER_33_798 VPWR VGND sg13cmos5l_decap_8
X_3753_ _3755_/A _4216_/Q _3754_/B VPWR VGND sg13cmos5l_nand2_1
X_3885__404 _3885_/RESET_B VPWR VGND sg13cmos5l_tiehi
X_2704_ _2704_/Y _2883_/A _4083_/Q VPWR VGND sg13cmos5l_xnor2_1
X_3684_ _3684_/Y _4246_/Q _3676_/B _3685_/B _4247_/Q _3680_/Y VPWR VGND sg13cmos5l_a221oi_1
XFILLER_9_493 VPWR VGND sg13cmos5l_decap_8
X_2635_ _2635_/Y _2634_/A _3958_/Q _2634_/Y VPWR VGND sg13cmos5l_a21oi_1
XFILLER_0_809 VPWR VGND sg13cmos5l_decap_8
X_2566_ _2566_/Y _2568_/A _3940_/Q VPWR VGND sg13cmos5l_nand2b_1
X_2497_ _2497_/Y _4275_/Q _2497_/B _2497_/C VPWR VGND sg13cmos5l_nor3_1
X_4236_ _4236_/Q _4259_/CLK _4236_/D _4236_/RESET_B VPWR VGND sg13cmos5l_dfrbpq_1
X_4176__462 _4176_/RESET_B VPWR VGND sg13cmos5l_tiehi
X_4167_ _4167_/Q _4173_/CLK _4167_/D _4167_/RESET_B VPWR VGND sg13cmos5l_dfrbpq_1
X_3118_ _3118_/Y _4170_/Q _3124_/B VPWR VGND sg13cmos5l_nand2_1
X_4098_ _4098_/Q _4129_/CLK _4098_/D _4098_/RESET_B VPWR VGND sg13cmos5l_dfrbpq_1
X_3049_ _3049_/Y _3049_/A _3049_/B _3049_/C VPWR VGND sg13cmos5l_nand3_1
XFILLER_15_209 VPWR VGND sg13cmos5l_decap_8
XFILLER_24_754 VPWR VGND sg13cmos5l_decap_4
X_4183__455 _4183_/RESET_B VPWR VGND sg13cmos5l_tiehi
XFILLER_3_647 VPWR VGND sg13cmos5l_fill_2
XFILLER_3_4 VPWR VGND sg13cmos5l_decap_8
XFILLER_2_168 VPWR VGND sg13cmos5l_decap_4
XFILLER_48_42 VPWR VGND sg13cmos5l_decap_8
XFILLER_48_53 VPWR VGND sg13cmos5l_fill_1
XFILLER_46_323 VPWR VGND sg13cmos5l_fill_2
XFILLER_19_537 VPWR VGND sg13cmos5l_decap_4
X_4190__448 _4190_/RESET_B VPWR VGND sg13cmos5l_tiehi
XFILLER_47_868 VPWR VGND sg13cmos5l_decap_8
XFILLER_34_507 VPWR VGND sg13cmos5l_fill_1
XFILLER_15_743 VPWR VGND sg13cmos5l_fill_1
XFILLER_15_776 VPWR VGND sg13cmos5l_decap_8
XFILLER_42_584 VPWR VGND sg13cmos5l_fill_1
Xfanout90 _2552_/A _2624_/A VPWR VGND sg13cmos5l_buf_1
XFILLER_7_986 VPWR VGND sg13cmos5l_decap_8
XFILLER_6_452 VPWR VGND sg13cmos5l_decap_8
XFILLER_10_492 VPWR VGND sg13cmos5l_decap_8
Xhold909 _2211_/A _4236_/Q VPWR VGND sg13cmos5l_dlygate4sd3_1
X_2420_ _4011_/D _3863_/A0 hold708/X _2421_/S VPWR VGND sg13cmos5l_mux2_1
X_2351_ _3952_/D hold768/X _3854_/A1 _2351_/S VPWR VGND sg13cmos5l_mux2_1
XFILLER_36_4 VPWR VGND sg13cmos5l_fill_2
X_2282_ _4278_/D _4276_/D _2282_/B _2282_/C VPWR VGND sg13cmos5l_nand3b_1
X_4021_ _4021_/Q clkload4/A _4021_/D _4021_/RESET_B VPWR VGND sg13cmos5l_dfrbpq_1
XFILLER_49_172 VPWR VGND sg13cmos5l_fill_2
XFILLER_37_301 VPWR VGND sg13cmos5l_decap_8
XFILLER_37_389 VPWR VGND sg13cmos5l_decap_8
XFILLER_33_540 VPWR VGND sg13cmos5l_decap_8
X_3805_ _3805_/Y _3805_/A _3805_/B _3805_/C VPWR VGND sg13cmos5l_nand3_1
X_3736_ _3736_/Y _3805_/A _3736_/B VPWR VGND sg13cmos5l_nand2b_1
X_3667_ _3667_/Y _4219_/Q _3682_/A _3666_/Y VPWR VGND sg13cmos5l_o21ai_1
XFILLER_47_1022 VPWR VGND sg13cmos5l_decap_8
X_3598_ _3598_/Y _3588_/Y _3590_/Y _3597_/X VPWR VGND sg13cmos5l_o21ai_1
X_2618_ _2618_/Y _2616_/A _3937_/Q VPWR VGND sg13cmos5l_nand2b_1
X_2549_ _2549_/Y _2643_/S1 _2547_/Y _2548_/Y _2545_/Y _2646_/A VPWR VGND sg13cmos5l_a221oi_1
X_4219_ _4219_/Q _4265_/CLK _4219_/D _4219_/RESET_B VPWR VGND sg13cmos5l_dfrbpq_1
XFILLER_28_323 VPWR VGND sg13cmos5l_decap_8
XFILLER_29_879 VPWR VGND sg13cmos5l_decap_8
XFILLER_43_315 VPWR VGND sg13cmos5l_decap_8
XFILLER_16_529 VPWR VGND sg13cmos5l_decap_8
X_3892__238 _3892_/RESET_B VPWR VGND sg13cmos5l_tiehi
XFILLER_43_348 VPWR VGND sg13cmos5l_fill_2
X_4033__241 _4033_/RESET_B VPWR VGND sg13cmos5l_tiehi
XFILLER_4_945 VPWR VGND sg13cmos5l_decap_8
XFILLER_3_466 VPWR VGND sg13cmos5l_fill_1
XFILLER_19_356 VPWR VGND sg13cmos5l_decap_8
XFILLER_19_378 VPWR VGND sg13cmos5l_fill_1
XFILLER_34_315 VPWR VGND sg13cmos5l_decap_8
X_4166__472 _4166_/RESET_B VPWR VGND sg13cmos5l_tiehi
XFILLER_30_598 VPWR VGND sg13cmos5l_fill_2
X_3521_ _3528_/S _3531_/A _3378_/A _3520_/Y VPWR VGND sg13cmos5l_o21ai_1
Xhold717 hold717/X _3916_/Q VPWR VGND sg13cmos5l_dlygate4sd3_1
Xhold706 hold706/X _3943_/Q VPWR VGND sg13cmos5l_dlygate4sd3_1
Xhold728 hold728/X _3939_/Q VPWR VGND sg13cmos5l_dlygate4sd3_1
X_3452_ _3764_/C _4235_/Q _4236_/Q _4237_/Q VPWR VGND sg13cmos5l_nor3_1
XFILLER_6_293 VPWR VGND sg13cmos5l_fill_2
Xhold739 hold739/X _3937_/Q VPWR VGND sg13cmos5l_dlygate4sd3_1
X_3383_ _3383_/Y _4192_/Q _3708_/A2 _3389_/A VPWR VGND sg13cmos5l_o21ai_1
X_2403_ _2411_/S _3846_/D _2412_/B VPWR VGND sg13cmos5l_nand2_1
X_2334_ _3937_/D _3866_/A0 hold739/X _2341_/S VPWR VGND sg13cmos5l_mux2_1
XFILLER_27_0 VPWR VGND sg13cmos5l_decap_4
XFILLER_38_632 VPWR VGND sg13cmos5l_decap_8
X_2265_ _2267_/B _2273_/B _2451_/A VPWR VGND sg13cmos5l_nor2_1
X_4004_ _4004_/Q _4027_/CLK _4004_/D _4004_/RESET_B VPWR VGND sg13cmos5l_dfrbpq_1
X_4173__465 _4173_/RESET_B VPWR VGND sg13cmos5l_tiehi
X_2196_ _2322_/A _2196_/A VPWR VGND sg13cmos5l_inv_1
XFILLER_25_304 VPWR VGND sg13cmos5l_decap_8
XFILLER_25_326 VPWR VGND sg13cmos5l_fill_1
XFILLER_25_337 VPWR VGND sg13cmos5l_decap_4
XFILLER_26_849 VPWR VGND sg13cmos5l_decap_8
XFILLER_40_307 VPWR VGND sg13cmos5l_decap_8
XFILLER_21_510 VPWR VGND sg13cmos5l_decap_4
XFILLER_21_554 VPWR VGND sg13cmos5l_decap_8
XFILLER_4_219 VPWR VGND sg13cmos5l_decap_4
X_4180__458 _4180_/RESET_B VPWR VGND sg13cmos5l_tiehi
X_3719_ _3719_/Y _3717_/Y _3718_/Y _3716_/Y VPWR VGND sg13cmos5l_a21oi_1
XFILLER_1_904 VPWR VGND sg13cmos5l_decap_8
XFILLER_49_919 VPWR VGND sg13cmos5l_decap_8
XFILLER_17_827 VPWR VGND sg13cmos5l_decap_4
XFILLER_17_838 VPWR VGND sg13cmos5l_decap_8
XFILLER_28_153 VPWR VGND sg13cmos5l_decap_8
XFILLER_28_164 VPWR VGND sg13cmos5l_decap_4
XFILLER_45_32 VPWR VGND sg13cmos5l_fill_1
XFILLER_43_123 VPWR VGND sg13cmos5l_fill_2
XFILLER_44_679 VPWR VGND sg13cmos5l_decap_8
XFILLER_25_871 VPWR VGND sg13cmos5l_fill_1
XFILLER_12_565 VPWR VGND sg13cmos5l_decap_8
XFILLER_8_558 VPWR VGND sg13cmos5l_decap_4
XFILLER_4_764 VPWR VGND sg13cmos5l_decap_8
XFILLER_48_930 VPWR VGND sg13cmos5l_decap_8
XFILLER_0_970 VPWR VGND sg13cmos5l_decap_8
XFILLER_19_120 VPWR VGND sg13cmos5l_fill_1
XFILLER_35_602 VPWR VGND sg13cmos5l_decap_8
XFILLER_31_830 VPWR VGND sg13cmos5l_fill_1
X_2952_ _2953_/C _3147_/A _2952_/B VPWR VGND sg13cmos5l_nor2_1
XFILLER_31_896 VPWR VGND sg13cmos5l_decap_4
X_2883_ _4105_/D _2883_/A _2884_/B VPWR VGND sg13cmos5l_and2_1
X_3504_ _3505_/B _2222_/Y _3299_/X _3509_/S VPWR VGND sg13cmos5l_mux2_1
X_3435_ _3435_/Y _3435_/A _3435_/B VPWR VGND sg13cmos5l_nor2_1
X_3366_ _3366_/Y hold899/X _3361_/Y _3358_/Y VPWR VGND sg13cmos5l_o21ai_1
XFILLER_39_930 VPWR VGND sg13cmos5l_decap_8
X_3297_ _3301_/C _3297_/A _3297_/B VPWR VGND sg13cmos5l_xnor2_1
X_2317_ _3923_/D _3871_/A0 hold695/X _2321_/S VPWR VGND sg13cmos5l_mux2_1
Xheichips26_dna_sequencer_141 uio_out[0] VPWR VGND sg13cmos5l_tielo
X_2248_ _2504_/A _2268_/B VPWR VGND sg13cmos5l_inv_1
XFILLER_25_101 VPWR VGND sg13cmos5l_decap_4
X_2179_ _2179_/Y _2179_/A VPWR VGND sg13cmos5l_inv_1
XFILLER_41_605 VPWR VGND sg13cmos5l_fill_1
XFILLER_15_46 VPWR VGND sg13cmos5l_decap_8
XFILLER_25_189 VPWR VGND sg13cmos5l_decap_4
XFILLER_15_79 VPWR VGND sg13cmos5l_decap_8
XFILLER_21_373 VPWR VGND sg13cmos5l_fill_1
XFILLER_0_200 VPWR VGND sg13cmos5l_decap_4
XFILLER_49_716 VPWR VGND sg13cmos5l_decap_8
XFILLER_1_778 VPWR VGND sg13cmos5l_decap_8
XFILLER_0_266 VPWR VGND sg13cmos5l_fill_2
XFILLER_0_299 VPWR VGND sg13cmos5l_decap_8
XFILLER_45_922 VPWR VGND sg13cmos5l_decap_8
XFILLER_45_999 VPWR VGND sg13cmos5l_decap_8
XFILLER_44_443 VPWR VGND sg13cmos5l_decap_8
XFILLER_13_852 VPWR VGND sg13cmos5l_fill_2
XFILLER_31_148 VPWR VGND sg13cmos5l_decap_4
XFILLER_8_322 VPWR VGND sg13cmos5l_decap_8
XFILLER_12_395 VPWR VGND sg13cmos5l_decap_8
X_4163__475 _4163_/RESET_B VPWR VGND sg13cmos5l_tiehi
X_3220_ _3220_/Y _3218_/B _3218_/C _3218_/A VPWR VGND sg13cmos5l_a21oi_1
X_3151_ _3151_/Y _3152_/A _3167_/B VPWR VGND sg13cmos5l_nor2_1
XFILLER_39_248 VPWR VGND sg13cmos5l_decap_8
X_3082_ _3082_/Y _3082_/A _3082_/B VPWR VGND sg13cmos5l_nand2_1
XFILLER_36_933 VPWR VGND sg13cmos5l_decap_8
X_4170__468 _4170_/RESET_B VPWR VGND sg13cmos5l_tiehi
X_3984_ _3984_/Q clkload7/A _3984_/D _3984_/RESET_B VPWR VGND sg13cmos5l_dfrbpq_1
X_2935_ _2955_/B _4116_/Q _2936_/B VPWR VGND sg13cmos5l_xor2_1
X_2866_ _2866_/X _2860_/B _3016_/B _2868_/S VPWR VGND sg13cmos5l_mux2_1
X_2797_ _2974_/A _4111_/Q _2799_/B VPWR VGND sg13cmos5l_nor2_1
X_3418_ _3419_/B _4197_/Q _3438_/B _3404_/Y VPWR VGND sg13cmos5l_a21oi_1
X_3349_ _3349_/Y _3559_/A _4155_/Q _4154_/Q _3304_/A _3348_/Y VPWR VGND sg13cmos5l_a221oi_1
Xhold1000 _3104_/B _4144_/Q VPWR VGND sg13cmos5l_dlygate4sd3_1
XFILLER_46_708 VPWR VGND sg13cmos5l_decap_8
Xhold1011 _2927_/A2 _2910_/B VPWR VGND sg13cmos5l_dlygate4sd3_1
XFILLER_46_719 VPWR VGND sg13cmos5l_fill_1
XFILLER_45_218 VPWR VGND sg13cmos5l_decap_8
XFILLER_26_34 VPWR VGND sg13cmos5l_fill_1
XFILLER_26_443 VPWR VGND sg13cmos5l_decap_8
XFILLER_42_947 VPWR VGND sg13cmos5l_decap_8
XFILLER_41_402 VPWR VGND sg13cmos5l_fill_2
XFILLER_14_627 VPWR VGND sg13cmos5l_fill_1
XFILLER_26_476 VPWR VGND sg13cmos5l_decap_4
XFILLER_42_11 VPWR VGND sg13cmos5l_fill_2
XFILLER_41_446 VPWR VGND sg13cmos5l_fill_1
XFILLER_13_159 VPWR VGND sg13cmos5l_decap_8
XFILLER_5_325 VPWR VGND sg13cmos5l_decap_4
XFILLER_5_314 VPWR VGND sg13cmos5l_decap_4
XFILLER_1_564 VPWR VGND sg13cmos5l_fill_2
XFILLER_49_535 VPWR VGND sg13cmos5l_decap_8
XFILLER_1_597 VPWR VGND sg13cmos5l_fill_2
XFILLER_49_568 VPWR VGND sg13cmos5l_decap_8
XFILLER_36_207 VPWR VGND sg13cmos5l_fill_1
XFILLER_45_730 VPWR VGND sg13cmos5l_decap_8
XFILLER_44_273 VPWR VGND sg13cmos5l_decap_8
XFILLER_33_969 VPWR VGND sg13cmos5l_decap_8
XFILLER_13_671 VPWR VGND sg13cmos5l_decap_4
X_2720_ _2720_/Y _2883_/A _2837_/A VPWR VGND sg13cmos5l_nor2b_1
XFILLER_40_490 VPWR VGND sg13cmos5l_fill_1
XFILLER_13_693 VPWR VGND sg13cmos5l_decap_8
XFILLER_12_192 VPWR VGND sg13cmos5l_decap_4
X_2651_ _2651_/Y _2673_/A _3878_/Q _2650_/Y VPWR VGND sg13cmos5l_a21oi_1
XFILLER_8_185 VPWR VGND sg13cmos5l_decap_4
X_2582_ _2582_/Y _2639_/A _3877_/Q _2581_/Y VPWR VGND sg13cmos5l_a21oi_1
XFILLER_5_892 VPWR VGND sg13cmos5l_decap_8
X_4252_ _4252_/Q _4277_/CLK _4252_/D _4252_/RESET_B VPWR VGND sg13cmos5l_dfrbpq_1
Xfanout109 _3866_/A0 input7/X VPWR VGND sg13cmos5l_buf_1
X_3203_ _4158_/D _3273_/B _3203_/B VPWR VGND sg13cmos5l_and2_1
XFILLER_41_1006 VPWR VGND sg13cmos5l_decap_8
X_4183_ _4183_/Q _4231_/CLK _4183_/D _4183_/RESET_B VPWR VGND sg13cmos5l_dfrbpq_1
X_3134_ _3134_/Y _3147_/A _3167_/A VPWR VGND sg13cmos5l_nor2_1
X_3065_ _3065_/Y _4136_/Q _3073_/B _3063_/B VPWR VGND sg13cmos5l_a21oi_1
XFILLER_36_763 VPWR VGND sg13cmos5l_decap_8
XFILLER_23_402 VPWR VGND sg13cmos5l_fill_2
XFILLER_24_914 VPWR VGND sg13cmos5l_decap_8
XFILLER_24_925 VPWR VGND sg13cmos5l_fill_1
XFILLER_36_785 VPWR VGND sg13cmos5l_decap_4
XFILLER_23_424 VPWR VGND sg13cmos5l_decap_8
XFILLER_23_435 VPWR VGND sg13cmos5l_fill_2
X_3967_ _3967_/Q _4031_/CLK _3967_/D _3967_/RESET_B VPWR VGND sg13cmos5l_dfrbpq_1
X_2918_ _2920_/B _2918_/A _2918_/B VPWR VGND sg13cmos5l_nor2_1
XFILLER_32_980 VPWR VGND sg13cmos5l_decap_8
X_3898_ _3898_/Q clkload8/A _3898_/D _3898_/RESET_B VPWR VGND sg13cmos5l_dfrbpq_1
X_3888__254 _3888_/RESET_B VPWR VGND sg13cmos5l_tiehi
X_2849_ _2849_/Y _2817_/A _2857_/B _2855_/B _4108_/Q VPWR VGND sg13cmos5l_a22oi_1
XFILLER_3_818 VPWR VGND sg13cmos5l_decap_8
X_4218__416 _4218_/RESET_B VPWR VGND sg13cmos5l_tiehi
XFILLER_46_505 VPWR VGND sg13cmos5l_fill_1
XFILLER_37_33 VPWR VGND sg13cmos5l_decap_8
XFILLER_37_66 VPWR VGND sg13cmos5l_fill_1
XFILLER_27_763 VPWR VGND sg13cmos5l_fill_1
XFILLER_10_652 VPWR VGND sg13cmos5l_fill_1
Xclkbuf_leaf_21_clk _4259_/CLK clkbuf_leaf_3_clk/A VPWR VGND sg13cmos5l_buf_8
XFILLER_5_122 VPWR VGND sg13cmos5l_fill_1
XFILLER_6_667 VPWR VGND sg13cmos5l_fill_1
XFILLER_2_884 VPWR VGND sg13cmos5l_decap_8
XFILLER_17_295 VPWR VGND sg13cmos5l_decap_8
XFILLER_33_755 VPWR VGND sg13cmos5l_decap_8
X_3821_ _3821_/Y _2160_/Y _4274_/Q _3818_/A VPWR VGND sg13cmos5l_a21oi_1
XFILLER_20_438 VPWR VGND sg13cmos5l_decap_4
Xclkbuf_leaf_12_clk _4136_/CLK clkload1/A VPWR VGND sg13cmos5l_buf_8
X_3752_ _3752_/Y _3775_/B _3747_/Y _3756_/B _3756_/A VPWR VGND sg13cmos5l_a22oi_1
XFILLER_9_461 VPWR VGND sg13cmos5l_decap_8
X_2703_ _2714_/B _2883_/A _4083_/Q VPWR VGND sg13cmos5l_nor2_1
X_3683_ _3685_/B _3686_/B _3682_/Y _3681_/Y VPWR VGND sg13cmos5l_a21oi_1
XFILLER_9_472 VPWR VGND sg13cmos5l_fill_2
X_2634_ _2634_/Y _2634_/A _3975_/Q VPWR VGND sg13cmos5l_nor2b_1
X_2565_ _2572_/A _2561_/Y _2562_/Y _2564_/Y _2645_/S1 _2644_/A VPWR VGND sg13cmos5l_a221oi_1
XFILLER_4_70 VPWR VGND sg13cmos5l_fill_1
X_2496_ _2688_/B _2496_/A _2496_/B _2496_/C _2496_/D VPWR VGND sg13cmos5l_nand4_1
X_4235_ _4235_/Q _4259_/CLK _4235_/D _4235_/RESET_B VPWR VGND sg13cmos5l_dfrbpq_1
X_3998__293 _3998_/RESET_B VPWR VGND sg13cmos5l_tiehi
X_4166_ _4166_/Q _4173_/CLK _4166_/D _4166_/RESET_B VPWR VGND sg13cmos5l_dfrbpq_1
X_3117_ _3122_/S _3113_/Y _3116_/Y _3099_/A VPWR VGND sg13cmos5l_o21ai_1
XFILLER_28_516 VPWR VGND sg13cmos5l_decap_8
X_4097_ _4097_/Q _4277_/CLK _4097_/D _4097_/RESET_B VPWR VGND sg13cmos5l_dfrbpq_1
XFILLER_43_519 VPWR VGND sg13cmos5l_decap_8
X_3048_ _3049_/C _3048_/A _3048_/B _3048_/C _3048_/D VPWR VGND sg13cmos5l_nand4_1
XFILLER_24_700 VPWR VGND sg13cmos5l_decap_4
XFILLER_23_210 VPWR VGND sg13cmos5l_decap_4
XFILLER_12_906 VPWR VGND sg13cmos5l_decap_8
XFILLER_12_928 VPWR VGND sg13cmos5l_fill_1
XFILLER_11_438 VPWR VGND sg13cmos5l_decap_8
XFILLER_20_950 VPWR VGND sg13cmos5l_decap_8
XFILLER_23_68 VPWR VGND sg13cmos5l_fill_2
XFILLER_48_21 VPWR VGND sg13cmos5l_decap_8
XFILLER_47_847 VPWR VGND sg13cmos5l_decap_8
XFILLER_0_28 VPWR VGND sg13cmos5l_decap_8
XFILLER_0_39 VPWR VGND sg13cmos5l_fill_1
XFILLER_14_210 VPWR VGND sg13cmos5l_decap_8
XFILLER_14_221 VPWR VGND sg13cmos5l_fill_2
XFILLER_15_722 VPWR VGND sg13cmos5l_fill_1
XFILLER_27_593 VPWR VGND sg13cmos5l_decap_8
XFILLER_9_26 VPWR VGND sg13cmos5l_decap_8
XFILLER_30_725 VPWR VGND sg13cmos5l_fill_1
Xfanout91 _2568_/A _2624_/A VPWR VGND sg13cmos5l_buf_1
Xfanout80 _2641_/B2 fanout84/X VPWR VGND sg13cmos5l_buf_1
XFILLER_6_420 VPWR VGND sg13cmos5l_fill_2
XFILLER_11_983 VPWR VGND sg13cmos5l_decap_8
XFILLER_31_1027 VPWR VGND sg13cmos5l_fill_2
XFILLER_7_965 VPWR VGND sg13cmos5l_decap_8
X_2350_ _3951_/D hold676/X _2419_/A0 _2351_/S VPWR VGND sg13cmos5l_mux2_1
XFILLER_2_692 VPWR VGND sg13cmos5l_decap_4
X_2281_ _4275_/D _2282_/C VPWR VGND sg13cmos5l_inv_1
XFILLER_49_140 VPWR VGND sg13cmos5l_decap_4
X_4020_ _4020_/Q clkload4/A _4020_/D _4020_/RESET_B VPWR VGND sg13cmos5l_dfrbpq_1
Xclkbuf_leaf_1_clk _4011_/CLK clkbuf_leaf_4_clk/A VPWR VGND sg13cmos5l_buf_8
XFILLER_29_4 VPWR VGND sg13cmos5l_decap_4
XFILLER_46_891 VPWR VGND sg13cmos5l_decap_8
XFILLER_21_703 VPWR VGND sg13cmos5l_fill_2
XFILLER_33_585 VPWR VGND sg13cmos5l_decap_8
X_3804_ _3804_/Y _3792_/X _3796_/Y _3799_/A _3802_/Y _3803_/Y VPWR VGND sg13cmos5l_a221oi_1
X_3735_ _3736_/B _3805_/B _3805_/C VPWR VGND sg13cmos5l_nand2_1
XFILLER_9_280 VPWR VGND sg13cmos5l_decap_8
X_3666_ _3666_/Y _4220_/Q _4263_/Q VPWR VGND sg13cmos5l_nand2b_1
XFILLER_47_1001 VPWR VGND sg13cmos5l_decap_8
X_3597_ _3597_/X _3597_/A _3597_/B VPWR VGND sg13cmos5l_or2_1
X_2617_ _2617_/Y _2616_/A _3886_/Q _2616_/Y VPWR VGND sg13cmos5l_a21oi_1
XFILLER_0_607 VPWR VGND sg13cmos5l_fill_1
X_2548_ _2548_/Y _2568_/A _3919_/Q _2643_/S1 VPWR VGND sg13cmos5l_a21oi_1
X_2479_ _2479_/Y _2194_/A _2435_/A _2487_/B1 VPWR VGND sg13cmos5l_o21ai_1
X_4218_ _4218_/Q clkload3/A _4218_/D _4218_/RESET_B VPWR VGND sg13cmos5l_dfrbpq_1
XFILLER_29_803 VPWR VGND sg13cmos5l_fill_1
X_4149_ _4149_/Q _4205_/CLK _4149_/D _4149_/RESET_B VPWR VGND sg13cmos5l_dfrbpq_1
XFILLER_29_869 VPWR VGND sg13cmos5l_decap_4
XFILLER_8_729 VPWR VGND sg13cmos5l_decap_8
XFILLER_11_257 VPWR VGND sg13cmos5l_decap_8
XFILLER_7_206 VPWR VGND sg13cmos5l_fill_1
X_4265__564 _4265_/RESET_B VPWR VGND sg13cmos5l_tiehi
Xclkload0 clkload0/X clkload0/A VPWR VGND sg13cmos5l_buf_8
XFILLER_4_924 VPWR VGND sg13cmos5l_decap_8
XFILLER_47_611 VPWR VGND sg13cmos5l_decap_4
X_4272__557 _4272_/RESET_B VPWR VGND sg13cmos5l_tiehi
XFILLER_35_806 VPWR VGND sg13cmos5l_decap_4
XFILLER_47_677 VPWR VGND sg13cmos5l_decap_8
X_3520_ _3520_/Y _3520_/A _3520_/B VPWR VGND sg13cmos5l_nand2_1
XFILLER_11_780 VPWR VGND sg13cmos5l_decap_8
Xhold718 hold718/X _3898_/Q VPWR VGND sg13cmos5l_dlygate4sd3_1
XFILLER_7_784 VPWR VGND sg13cmos5l_decap_4
Xhold707 hold707/X _3910_/Q VPWR VGND sg13cmos5l_dlygate4sd3_1
Xhold729 hold729/X _4000_/Q VPWR VGND sg13cmos5l_dlygate4sd3_1
XFILLER_6_283 VPWR VGND sg13cmos5l_decap_4
X_3451_ _3451_/Y _4222_/Q _3704_/A VPWR VGND sg13cmos5l_nand2b_1
X_3382_ _3382_/Y _2178_/Y _3706_/A2 _3381_/Y VPWR VGND sg13cmos5l_a21oi_1
X_2402_ _2412_/B _4031_/Q _3846_/B _2474_/B VPWR VGND sg13cmos5l_nor3_1
X_2333_ _3936_/D _3865_/A0 hold758/X _2341_/S VPWR VGND sg13cmos5l_mux2_1
X_2264_ _2264_/Y _4025_/Q _2278_/C VPWR VGND sg13cmos5l_nor2_1
X_4003_ _4003_/Q clkload6/A _4003_/D _4003_/RESET_B VPWR VGND sg13cmos5l_dfrbpq_1
X_2195_ _2195_/Y _2195_/A VPWR VGND sg13cmos5l_inv_1
XFILLER_38_699 VPWR VGND sg13cmos5l_decap_8
X_3995__296 _3995_/RESET_B VPWR VGND sg13cmos5l_tiehi
XFILLER_26_828 VPWR VGND sg13cmos5l_decap_8
XFILLER_19_880 VPWR VGND sg13cmos5l_decap_4
XFILLER_41_809 VPWR VGND sg13cmos5l_decap_8
XFILLER_34_850 VPWR VGND sg13cmos5l_fill_2
XFILLER_33_382 VPWR VGND sg13cmos5l_fill_1
XFILLER_21_599 VPWR VGND sg13cmos5l_fill_2
X_3718_ _3718_/Y _4252_/Q _4226_/Q VPWR VGND sg13cmos5l_xnor2_1
X_3649_ _3649_/Y _3678_/C _3658_/B VPWR VGND sg13cmos5l_nand2_1
XFILLER_20_36 VPWR VGND sg13cmos5l_fill_2
XFILLER_0_404 VPWR VGND sg13cmos5l_decap_8
XFILLER_48_408 VPWR VGND sg13cmos5l_fill_2
XFILLER_0_459 VPWR VGND sg13cmos5l_decap_8
XFILLER_21_1015 VPWR VGND sg13cmos5l_decap_8
XFILLER_28_132 VPWR VGND sg13cmos5l_decap_8
XFILLER_17_806 VPWR VGND sg13cmos5l_decap_8
XFILLER_43_168 VPWR VGND sg13cmos5l_fill_1
XFILLER_40_820 VPWR VGND sg13cmos5l_decap_4
XFILLER_12_500 VPWR VGND sg13cmos5l_decap_8
XFILLER_12_511 VPWR VGND sg13cmos5l_decap_8
XFILLER_40_897 VPWR VGND sg13cmos5l_fill_1
XFILLER_8_537 VPWR VGND sg13cmos5l_decap_8
XFILLER_6_49 VPWR VGND sg13cmos5l_fill_1
XFILLER_6_38 VPWR VGND sg13cmos5l_decap_4
XFILLER_4_743 VPWR VGND sg13cmos5l_decap_8
XFILLER_3_242 VPWR VGND sg13cmos5l_decap_8
XFILLER_39_408 VPWR VGND sg13cmos5l_decap_8
XFILLER_48_986 VPWR VGND sg13cmos5l_decap_8
XFILLER_47_463 VPWR VGND sg13cmos5l_decap_8
XFILLER_47_496 VPWR VGND sg13cmos5l_fill_1
XFILLER_16_861 VPWR VGND sg13cmos5l_decap_4
XFILLER_34_146 VPWR VGND sg13cmos5l_decap_8
XFILLER_37_1022 VPWR VGND sg13cmos5l_decap_8
X_2951_ _2953_/B _2964_/A _2955_/B VPWR VGND sg13cmos5l_nor2_1
XFILLER_42_190 VPWR VGND sg13cmos5l_decap_4
XFILLER_31_842 VPWR VGND sg13cmos5l_decap_8
X_2882_ _4104_/D _2882_/A _2884_/B VPWR VGND sg13cmos5l_and2_1
XFILLER_30_385 VPWR VGND sg13cmos5l_fill_2
X_3503_ _3509_/S _3501_/Y _3502_/Y _3490_/Y VPWR VGND sg13cmos5l_o21ai_1
X_3434_ _3435_/B _3434_/A _3434_/B VPWR VGND sg13cmos5l_xnor2_1
X_3365_ _3365_/Y hold899/X _3361_/Y _3364_/Y _4185_/Q VPWR VGND sg13cmos5l_a22oi_1
X_3296_ _3312_/B _4179_/Q _3297_/B VPWR VGND sg13cmos5l_xor2_1
X_2316_ _3922_/D _3859_/A0 hold710/X _2321_/S VPWR VGND sg13cmos5l_mux2_1
X_3901__555 _3901_/RESET_B VPWR VGND sg13cmos5l_tiehi
Xheichips26_dna_sequencer_142 uio_out[1] VPWR VGND sg13cmos5l_tielo
X_2247_ _2268_/B _2247_/A _2247_/B _3835_/A VPWR VGND sg13cmos5l_nor3_1
XFILLER_39_986 VPWR VGND sg13cmos5l_decap_8
XFILLER_38_474 VPWR VGND sg13cmos5l_fill_1
X_2178_ _2178_/Y _2178_/A VPWR VGND sg13cmos5l_inv_1
XFILLER_41_617 VPWR VGND sg13cmos5l_decap_8
XFILLER_40_138 VPWR VGND sg13cmos5l_decap_8
XFILLER_22_842 VPWR VGND sg13cmos5l_fill_1
XFILLER_21_385 VPWR VGND sg13cmos5l_decap_4
XFILLER_31_35 VPWR VGND sg13cmos5l_fill_2
XFILLER_5_518 VPWR VGND sg13cmos5l_decap_8
XFILLER_0_223 VPWR VGND sg13cmos5l_fill_1
XFILLER_1_757 VPWR VGND sg13cmos5l_decap_8
XFILLER_45_901 VPWR VGND sg13cmos5l_decap_8
XFILLER_16_102 VPWR VGND sg13cmos5l_decap_4
XFILLER_45_978 VPWR VGND sg13cmos5l_decap_8
XFILLER_44_466 VPWR VGND sg13cmos5l_fill_1
XFILLER_44_488 VPWR VGND sg13cmos5l_fill_1
XFILLER_40_661 VPWR VGND sg13cmos5l_fill_2
XFILLER_40_683 VPWR VGND sg13cmos5l_decap_4
XFILLER_12_385 VPWR VGND sg13cmos5l_decap_4
XFILLER_4_562 VPWR VGND sg13cmos5l_decap_4
X_4278__563 _4278_/RESET_B VPWR VGND sg13cmos5l_tiehi
X_3150_ _3160_/B _3134_/Y _3143_/Y _3148_/Y VPWR VGND sg13cmos5l_o21ai_1
XFILLER_39_227 VPWR VGND sg13cmos5l_fill_1
X_3081_ _3082_/B _3070_/Y _3089_/A _3080_/Y VPWR VGND sg13cmos5l_a21oi_1
XFILLER_11_4 VPWR VGND sg13cmos5l_decap_8
XFILLER_48_783 VPWR VGND sg13cmos5l_decap_8
X_3992__299 _3992_/RESET_B VPWR VGND sg13cmos5l_tiehi
XFILLER_36_989 VPWR VGND sg13cmos5l_decap_8
XFILLER_23_617 VPWR VGND sg13cmos5l_decap_8
X_3983_ _3983_/Q clkload7/A _3983_/D _3983_/RESET_B VPWR VGND sg13cmos5l_dfrbpq_1
XFILLER_22_127 VPWR VGND sg13cmos5l_fill_2
X_2934_ _2936_/B _4114_/Q _4115_/Q _4112_/Q _4113_/Q VPWR VGND sg13cmos5l_nor4_1
X_2865_ _2868_/S _4096_/Q _2865_/B VPWR VGND sg13cmos5l_nor2_1
X_2796_ _2995_/B _4111_/Q _3046_/A VPWR VGND sg13cmos5l_nor2_1
XFILLER_11_1025 VPWR VGND sg13cmos5l_decap_4
X_3417_ _3435_/A _3417_/A _3417_/B VPWR VGND sg13cmos5l_nor2_1
X_3348_ _3348_/Y _3558_/A _3359_/B _3362_/B _4202_/Q VPWR VGND sg13cmos5l_a22oi_1
Xhold1001 _3576_/A _4233_/Q VPWR VGND sg13cmos5l_dlygate4sd3_1
Xhold1012 _3601_/A _4232_/Q VPWR VGND sg13cmos5l_dlygate4sd3_1
XFILLER_39_761 VPWR VGND sg13cmos5l_decap_4
X_3279_ _3305_/A _4176_/Q _4175_/Q VPWR VGND sg13cmos5l_xnor2_1
XFILLER_42_926 VPWR VGND sg13cmos5l_decap_8
XFILLER_14_606 VPWR VGND sg13cmos5l_decap_4
XFILLER_14_617 VPWR VGND sg13cmos5l_fill_1
XFILLER_9_109 VPWR VGND sg13cmos5l_decap_8
XFILLER_42_45 VPWR VGND sg13cmos5l_decap_4
XFILLER_22_672 VPWR VGND sg13cmos5l_fill_2
XFILLER_10_856 VPWR VGND sg13cmos5l_fill_1
XFILLER_10_878 VPWR VGND sg13cmos5l_fill_2
Xhold890 hold890/X _2748_/Y VPWR VGND sg13cmos5l_dlygate4sd3_1
XFILLER_3_39 VPWR VGND sg13cmos5l_decap_8
XFILLER_49_525 VPWR VGND sg13cmos5l_fill_2
XFILLER_18_912 VPWR VGND sg13cmos5l_fill_2
XFILLER_17_411 VPWR VGND sg13cmos5l_decap_8
XFILLER_17_422 VPWR VGND sg13cmos5l_fill_2
XFILLER_36_219 VPWR VGND sg13cmos5l_decap_8
XFILLER_17_444 VPWR VGND sg13cmos5l_decap_8
XFILLER_33_948 VPWR VGND sg13cmos5l_decap_8
XFILLER_41_992 VPWR VGND sg13cmos5l_decap_8
XFILLER_9_621 VPWR VGND sg13cmos5l_fill_1
XFILLER_12_160 VPWR VGND sg13cmos5l_decap_4
XFILLER_34_1025 VPWR VGND sg13cmos5l_decap_4
XFILLER_9_665 VPWR VGND sg13cmos5l_fill_1
X_2650_ _2650_/Y _2673_/A _3895_/Q VPWR VGND sg13cmos5l_nor2b_1
X_2581_ _2581_/Y _2603_/A _3894_/Q VPWR VGND sg13cmos5l_nor2b_1
X_4251_ _4251_/Q _4265_/CLK _4251_/D _4251_/RESET_B VPWR VGND sg13cmos5l_dfrbpq_1
X_3202_ _3202_/Y _3190_/Y hold859/X _3215_/B VPWR VGND sg13cmos5l_a21oi_1
X_4182_ _4182_/Q _4231_/CLK _4182_/D _4182_/RESET_B VPWR VGND sg13cmos5l_dfrbpq_1
X_3133_ _3167_/A _4120_/Q _3137_/B VPWR VGND sg13cmos5l_xor2_1
X_3064_ _3064_/Y _3064_/A _3064_/B VPWR VGND sg13cmos5l_nor2_1
XFILLER_36_731 VPWR VGND sg13cmos5l_decap_8
X_3966_ _3966_/Q _4031_/CLK _3966_/D _3966_/RESET_B VPWR VGND sg13cmos5l_dfrbpq_1
XFILLER_11_609 VPWR VGND sg13cmos5l_decap_8
X_2917_ _2917_/X _2917_/A _2917_/B VPWR VGND sg13cmos5l_or2_1
X_3897_ _3897_/Q clkload7/A _3897_/D _3897_/RESET_B VPWR VGND sg13cmos5l_dfrbpq_1
XFILLER_12_15 VPWR VGND sg13cmos5l_fill_1
X_2848_ _2848_/Y _3046_/A _4069_/Q VPWR VGND sg13cmos5l_nand2_1
X_2779_ _2779_/Y _2779_/A _2779_/B VPWR VGND sg13cmos5l_nor2_1
XFILLER_19_709 VPWR VGND sg13cmos5l_decap_8
XFILLER_42_734 VPWR VGND sg13cmos5l_decap_8
XFILLER_41_233 VPWR VGND sg13cmos5l_decap_4
XFILLER_42_778 VPWR VGND sg13cmos5l_fill_1
XFILLER_14_469 VPWR VGND sg13cmos5l_decap_8
XFILLER_30_929 VPWR VGND sg13cmos5l_fill_2
XFILLER_23_992 VPWR VGND sg13cmos5l_decap_8
XFILLER_5_145 VPWR VGND sg13cmos5l_fill_2
XFILLER_10_697 VPWR VGND sg13cmos5l_decap_8
X_4043__222 _4043_/RESET_B VPWR VGND sg13cmos5l_tiehi
XFILLER_2_863 VPWR VGND sg13cmos5l_decap_8
XFILLER_49_322 VPWR VGND sg13cmos5l_decap_4
XFILLER_49_366 VPWR VGND sg13cmos5l_decap_8
XFILLER_49_377 VPWR VGND sg13cmos5l_fill_1
XFILLER_45_594 VPWR VGND sg13cmos5l_decap_8
XFILLER_17_285 VPWR VGND sg13cmos5l_decap_4
X_3820_ _3829_/A _4274_/Q _2272_/A _3819_/Y VPWR VGND sg13cmos5l_a21oi_1
X_3751_ _3756_/B _4215_/Q _3781_/C VPWR VGND sg13cmos5l_xnor2_1
XFILLER_14_981 VPWR VGND sg13cmos5l_decap_8
XFILLER_20_417 VPWR VGND sg13cmos5l_decap_8
X_2702_ _2702_/Y _2702_/A _2706_/A VPWR VGND sg13cmos5l_xnor2_1
X_3682_ _3682_/Y _3682_/A _4265_/Q VPWR VGND sg13cmos5l_nor2_1
X_2633_ _2633_/Y _2634_/A _3992_/Q _2678_/S1 VPWR VGND sg13cmos5l_a21oi_1
X_2564_ _2564_/Y _2563_/A _3957_/Q _2563_/Y VPWR VGND sg13cmos5l_a21oi_1
X_2495_ _2496_/D _2502_/A _2495_/B VPWR VGND sg13cmos5l_nor2_1
X_4234_ _4234_/Q _4259_/CLK _4234_/D _4234_/RESET_B VPWR VGND sg13cmos5l_dfrbpq_1
X_4165_ _4165_/Q _4173_/CLK _4165_/D _4165_/RESET_B VPWR VGND sg13cmos5l_dfrbpq_1
X_3116_ _3116_/Y _3115_/A _3112_/X _3124_/B VPWR VGND sg13cmos5l_o21ai_1
X_4096_ _4096_/Q _4193_/CLK _4096_/D _4096_/RESET_B VPWR VGND sg13cmos5l_dfrbpq_1
X_3047_ _4137_/D _3047_/A _3047_/B VPWR VGND sg13cmos5l_nor2_1
XFILLER_24_734 VPWR VGND sg13cmos5l_decap_8
XFILLER_24_767 VPWR VGND sg13cmos5l_decap_8
X_3949_ _3949_/Q _4031_/CLK _3949_/D _3949_/RESET_B VPWR VGND sg13cmos5l_dfrbpq_1
XFILLER_3_616 VPWR VGND sg13cmos5l_decap_8
XFILLER_2_104 VPWR VGND sg13cmos5l_decap_4
XFILLER_24_1024 VPWR VGND sg13cmos5l_decap_4
XFILLER_47_826 VPWR VGND sg13cmos5l_decap_8
XFILLER_46_325 VPWR VGND sg13cmos5l_fill_1
XFILLER_42_520 VPWR VGND sg13cmos5l_fill_2
XFILLER_42_542 VPWR VGND sg13cmos5l_fill_2
XFILLER_15_756 VPWR VGND sg13cmos5l_fill_2
XFILLER_7_900 VPWR VGND sg13cmos5l_decap_4
Xfanout92 _2616_/A _2624_/A VPWR VGND sg13cmos5l_buf_1
Xfanout81 _2654_/A1 _2677_/S1 VPWR VGND sg13cmos5l_buf_1
XFILLER_31_1006 VPWR VGND sg13cmos5l_decap_8
Xfanout70 _3846_/B hold945/X VPWR VGND sg13cmos5l_buf_1
XFILLER_7_944 VPWR VGND sg13cmos5l_decap_8
X_4229__398 _4229_/RESET_B VPWR VGND sg13cmos5l_tiehi
XFILLER_6_487 VPWR VGND sg13cmos5l_decap_8
XFILLER_2_660 VPWR VGND sg13cmos5l_decap_4
XFILLER_9_1018 VPWR VGND sg13cmos5l_decap_8
X_2280_ _2282_/C _2278_/Y hold923/X _3704_/A VPWR VGND sg13cmos5l_o21ai_1
XFILLER_38_804 VPWR VGND sg13cmos5l_fill_2
XFILLER_38_848 VPWR VGND sg13cmos5l_decap_8
XFILLER_38_837 VPWR VGND sg13cmos5l_fill_1
XFILLER_38_826 VPWR VGND sg13cmos5l_decap_8
XFILLER_37_358 VPWR VGND sg13cmos5l_decap_8
XFILLER_37_336 VPWR VGND sg13cmos5l_decap_8
XFILLER_46_870 VPWR VGND sg13cmos5l_decap_8
XFILLER_45_380 VPWR VGND sg13cmos5l_fill_2
XFILLER_33_520 VPWR VGND sg13cmos5l_decap_8
X_3803_ _3803_/Y _3803_/A _3803_/B VPWR VGND sg13cmos5l_nor2_1
XFILLER_21_748 VPWR VGND sg13cmos5l_decap_8
X_3734_ _3734_/Y _3802_/A _3734_/B VPWR VGND sg13cmos5l_nand2_1
X_4208__427 _4208_/RESET_B VPWR VGND sg13cmos5l_tiehi
X_3665_ _3665_/Y _4219_/Q _3682_/A _3674_/A _4218_/Q _3664_/Y VPWR VGND sg13cmos5l_a221oi_1
X_2616_ _2616_/Y _2616_/A _3903_/Q VPWR VGND sg13cmos5l_nor2b_1
X_3596_ _3597_/B _3511_/B _3563_/A _3596_/S VPWR VGND sg13cmos5l_mux2_1
XFILLER_0_619 VPWR VGND sg13cmos5l_decap_8
X_2547_ _2547_/Y _2568_/A _3885_/Q _2546_/Y VPWR VGND sg13cmos5l_a21oi_1
X_2478_ _2478_/Y _2322_/A _2475_/B _2477_/Y VPWR VGND sg13cmos5l_a21oi_1
X_4217_ _4217_/Q clkload3/A _4217_/D _4217_/RESET_B VPWR VGND sg13cmos5l_dfrbpq_1
XFILLER_29_837 VPWR VGND sg13cmos5l_decap_8
XFILLER_44_807 VPWR VGND sg13cmos5l_fill_1
XFILLER_18_58 VPWR VGND sg13cmos5l_decap_4
X_4148_ _4148_/Q _4205_/CLK _4148_/D _4148_/RESET_B VPWR VGND sg13cmos5l_dfrbpq_1
XFILLER_29_859 VPWR VGND sg13cmos5l_decap_8
XFILLER_16_509 VPWR VGND sg13cmos5l_decap_4
X_4079_ _4079_/Q _4129_/CLK _4079_/D _4079_/RESET_B VPWR VGND sg13cmos5l_dfrbpq_1
XFILLER_24_520 VPWR VGND sg13cmos5l_decap_8
XFILLER_24_531 VPWR VGND sg13cmos5l_fill_1
XFILLER_12_737 VPWR VGND sg13cmos5l_fill_1
XFILLER_7_229 VPWR VGND sg13cmos5l_decap_8
Xclkload1 clkload1/X clkload1/A VPWR VGND sg13cmos5l_buf_8
XFILLER_4_903 VPWR VGND sg13cmos5l_decap_8
XFILLER_47_634 VPWR VGND sg13cmos5l_decap_4
XFILLER_19_325 VPWR VGND sg13cmos5l_decap_4
XFILLER_35_829 VPWR VGND sg13cmos5l_fill_2
XFILLER_15_531 VPWR VGND sg13cmos5l_decap_8
XFILLER_15_553 VPWR VGND sg13cmos5l_decap_8
XFILLER_43_884 VPWR VGND sg13cmos5l_decap_8
XFILLER_15_564 VPWR VGND sg13cmos5l_fill_2
XFILLER_7_741 VPWR VGND sg13cmos5l_fill_2
XFILLER_7_730 VPWR VGND sg13cmos5l_decap_8
XFILLER_7_763 VPWR VGND sg13cmos5l_decap_8
XFILLER_10_291 VPWR VGND sg13cmos5l_fill_2
Xhold719 hold719/X _3978_/Q VPWR VGND sg13cmos5l_dlygate4sd3_1
Xhold708 hold708/X _4011_/Q VPWR VGND sg13cmos5l_dlygate4sd3_1
X_3450_ _3450_/Y _3617_/B _3704_/B VPWR VGND sg13cmos5l_nor2_1
XFILLER_41_4 VPWR VGND sg13cmos5l_fill_2
X_2401_ _3995_/D input5/X hold774/X _2401_/S VPWR VGND sg13cmos5l_mux2_1
X_3381_ _3381_/Y _4191_/Q _3706_/A2 _3273_/B VPWR VGND sg13cmos5l_o21ai_1
X_2332_ _2338_/S _3855_/D _2332_/B VPWR VGND sg13cmos5l_nand2_1
X_4002_ _4002_/Q clkload6/A _4002_/D _4002_/RESET_B VPWR VGND sg13cmos5l_dfrbpq_1
X_2263_ _2278_/C _2283_/B VPWR VGND sg13cmos5l_inv_1
X_2194_ _2194_/Y _2194_/A VPWR VGND sg13cmos5l_inv_1
XFILLER_37_155 VPWR VGND sg13cmos5l_decap_8
XFILLER_34_840 VPWR VGND sg13cmos5l_fill_2
XFILLER_34_895 VPWR VGND sg13cmos5l_decap_4
XFILLER_21_534 VPWR VGND sg13cmos5l_decap_8
XFILLER_14_1023 VPWR VGND sg13cmos5l_decap_4
X_3717_ _3717_/Y _4253_/Q _4227_/Q VPWR VGND sg13cmos5l_xnor2_1
X_3648_ _3659_/A _3642_/Y _3646_/Y _3647_/Y VPWR VGND sg13cmos5l_o21ai_1
X_3579_ _3594_/C _4231_/Q _3591_/B VPWR VGND sg13cmos5l_xnor2_1
XFILLER_1_939 VPWR VGND sg13cmos5l_decap_8
XFILLER_0_438 VPWR VGND sg13cmos5l_decap_8
XFILLER_28_100 VPWR VGND sg13cmos5l_fill_2
XFILLER_28_111 VPWR VGND sg13cmos5l_decap_4
XFILLER_43_125 VPWR VGND sg13cmos5l_fill_1
XFILLER_16_328 VPWR VGND sg13cmos5l_decap_4
XFILLER_28_199 VPWR VGND sg13cmos5l_decap_8
XFILLER_45_67 VPWR VGND sg13cmos5l_decap_8
XFILLER_43_147 VPWR VGND sg13cmos5l_decap_8
XFILLER_40_865 VPWR VGND sg13cmos5l_fill_1
XFILLER_4_722 VPWR VGND sg13cmos5l_decap_8
XFILLER_3_276 VPWR VGND sg13cmos5l_decap_4
XFILLER_48_965 VPWR VGND sg13cmos5l_decap_8
XFILLER_19_155 VPWR VGND sg13cmos5l_fill_2
XFILLER_35_626 VPWR VGND sg13cmos5l_decap_8
XFILLER_35_637 VPWR VGND sg13cmos5l_fill_2
XFILLER_37_1001 VPWR VGND sg13cmos5l_decap_8
XFILLER_35_659 VPWR VGND sg13cmos5l_decap_8
X_2950_ _2953_/A _3147_/A _2952_/B _2944_/X _2949_/Y _2945_/X VPWR VGND sg13cmos5l_a221oi_1
XFILLER_16_895 VPWR VGND sg13cmos5l_decap_8
XFILLER_31_810 VPWR VGND sg13cmos5l_decap_4
XFILLER_31_821 VPWR VGND sg13cmos5l_decap_8
X_2881_ _4103_/D _3041_/A _2896_/B VPWR VGND sg13cmos5l_and2_1
X_3502_ _3502_/Y _3292_/A _3492_/A _3309_/B VPWR VGND sg13cmos5l_o21ai_1
X_3433_ _3434_/B _3433_/A _3433_/B VPWR VGND sg13cmos5l_xor2_1
XFILLER_44_1027 VPWR VGND sg13cmos5l_fill_2
XFILLER_44_1016 VPWR VGND sg13cmos5l_decap_8
X_3364_ _3364_/Y _3353_/B _3362_/Y _3363_/Y _3355_/C VPWR VGND sg13cmos5l_a22oi_1
X_3295_ _3305_/B _3288_/Y _3290_/Y _3293_/Y VPWR VGND sg13cmos5l_a21o_1
X_2315_ _3921_/D _3867_/A hold738/X _2321_/S VPWR VGND sg13cmos5l_mux2_1
Xheichips26_dna_sequencer_143 uio_out[2] VPWR VGND sg13cmos5l_tielo
X_2246_ _4276_/D _2502_/A _2688_/A VPWR VGND sg13cmos5l_and2_1
XFILLER_39_965 VPWR VGND sg13cmos5l_decap_8
XFILLER_38_486 VPWR VGND sg13cmos5l_fill_2
X_2177_ _2177_/Y _2177_/A VPWR VGND sg13cmos5l_inv_1
XFILLER_25_125 VPWR VGND sg13cmos5l_fill_2
XFILLER_25_169 VPWR VGND sg13cmos5l_fill_2
XFILLER_21_364 VPWR VGND sg13cmos5l_fill_2
XFILLER_22_876 VPWR VGND sg13cmos5l_fill_1
Xoutput14 uo_out[0] _4016_/Q VPWR VGND sg13cmos5l_buf_1
XFILLER_1_736 VPWR VGND sg13cmos5l_decap_8
XFILLER_0_246 VPWR VGND sg13cmos5l_decap_4
XFILLER_48_239 VPWR VGND sg13cmos5l_decap_8
XFILLER_17_637 VPWR VGND sg13cmos5l_fill_2
XFILLER_45_957 VPWR VGND sg13cmos5l_decap_8
XFILLER_17_648 VPWR VGND sg13cmos5l_fill_1
XFILLER_17_659 VPWR VGND sg13cmos5l_decap_4
XFILLER_16_169 VPWR VGND sg13cmos5l_decap_8
XFILLER_25_670 VPWR VGND sg13cmos5l_fill_1
XFILLER_25_692 VPWR VGND sg13cmos5l_decap_8
XFILLER_31_117 VPWR VGND sg13cmos5l_decap_8
XFILLER_31_128 VPWR VGND sg13cmos5l_fill_1
XFILLER_13_887 VPWR VGND sg13cmos5l_fill_2
XFILLER_40_695 VPWR VGND sg13cmos5l_decap_4
XFILLER_9_869 VPWR VGND sg13cmos5l_fill_1
XFILLER_4_574 VPWR VGND sg13cmos5l_decap_8
X_3080_ _3080_/Y _3080_/A _3080_/B VPWR VGND sg13cmos5l_nor2_1
XFILLER_48_762 VPWR VGND sg13cmos5l_decap_8
XFILLER_47_272 VPWR VGND sg13cmos5l_fill_2
XFILLER_35_445 VPWR VGND sg13cmos5l_decap_8
XFILLER_36_968 VPWR VGND sg13cmos5l_decap_8
X_3982_ _3982_/Q clkload6/A _3982_/D _3982_/RESET_B VPWR VGND sg13cmos5l_dfrbpq_1
XFILLER_35_478 VPWR VGND sg13cmos5l_decap_4
X_2933_ _2945_/A _4114_/Q _4112_/Q _4113_/Q VPWR VGND sg13cmos5l_or3_1
XFILLER_16_681 VPWR VGND sg13cmos5l_decap_4
XFILLER_31_673 VPWR VGND sg13cmos5l_fill_2
X_2864_ _2865_/B _2870_/B _2861_/Y _2863_/Y VPWR VGND sg13cmos5l_o21ai_1
X_2795_ _2820_/B _4111_/Q _2817_/A VPWR VGND sg13cmos5l_nor2b_1
XFILLER_11_1004 VPWR VGND sg13cmos5l_decap_8
X_3416_ _3417_/B _4201_/Q _3433_/B _3438_/C _3415_/Y VPWR VGND sg13cmos5l_a22oi_1
X_3899__511 _3899_/RESET_B VPWR VGND sg13cmos5l_tiehi
X_3347_ _4183_/D _3347_/A _3432_/B VPWR VGND sg13cmos5l_nor2_1
Xhold1002 _3738_/A _4256_/Q VPWR VGND sg13cmos5l_dlygate4sd3_1
Xhold1013 _3069_/A _4135_/Q VPWR VGND sg13cmos5l_dlygate4sd3_1
X_3278_ _3278_/X _3289_/A _3289_/B _3500_/A VPWR VGND sg13cmos5l_a21o_1
XFILLER_27_902 VPWR VGND sg13cmos5l_decap_8
X_2229_ _2748_/A _4070_/Q VPWR VGND sg13cmos5l_inv_1
X_4251__236 _4251_/RESET_B VPWR VGND sg13cmos5l_tiehi
XFILLER_26_25 VPWR VGND sg13cmos5l_decap_8
XFILLER_27_957 VPWR VGND sg13cmos5l_decap_8
XFILLER_27_968 VPWR VGND sg13cmos5l_fill_1
XFILLER_26_58 VPWR VGND sg13cmos5l_fill_2
XFILLER_42_13 VPWR VGND sg13cmos5l_fill_1
XFILLER_10_835 VPWR VGND sg13cmos5l_decap_8
XFILLER_10_846 VPWR VGND sg13cmos5l_fill_1
Xhold891 _2456_/A _4023_/Q VPWR VGND sg13cmos5l_dlygate4sd3_1
XFILLER_3_18 VPWR VGND sg13cmos5l_decap_8
Xhold880 _4267_/D _3828_/Y VPWR VGND sg13cmos5l_dlygate4sd3_1
XFILLER_49_504 VPWR VGND sg13cmos5l_decap_8
XFILLER_27_1022 VPWR VGND sg13cmos5l_decap_8
XFILLER_45_721 VPWR VGND sg13cmos5l_fill_1
XFILLER_18_924 VPWR VGND sg13cmos5l_decap_8
XFILLER_45_765 VPWR VGND sg13cmos5l_decap_8
XFILLER_33_927 VPWR VGND sg13cmos5l_decap_8
XFILLER_41_971 VPWR VGND sg13cmos5l_decap_8
XFILLER_34_1004 VPWR VGND sg13cmos5l_decap_8
XFILLER_8_165 VPWR VGND sg13cmos5l_decap_8
XFILLER_9_699 VPWR VGND sg13cmos5l_decap_8
X_2580_ _2580_/Y _2639_/A _3928_/Q VPWR VGND sg13cmos5l_nand2b_1
XFILLER_5_872 VPWR VGND sg13cmos5l_decap_4
XFILLER_4_371 VPWR VGND sg13cmos5l_fill_2
X_4250_ _4250_/Q clkload4/A _4250_/D _4250_/RESET_B VPWR VGND sg13cmos5l_dfrbpq_1
X_4181_ _4181_/Q _4231_/CLK _4181_/D _4181_/RESET_B VPWR VGND sg13cmos5l_dfrbpq_1
X_3201_ _3201_/Y _3201_/A _3201_/B VPWR VGND sg13cmos5l_nand2_1
X_3132_ _3145_/B _4119_/Q _4120_/Q _4117_/Q _4118_/Q VPWR VGND sg13cmos5l_nor4_1
X_4020__267 _4020_/RESET_B VPWR VGND sg13cmos5l_tiehi
X_3063_ _3064_/B _3079_/A _3063_/B VPWR VGND sg13cmos5l_and2_1
XFILLER_23_404 VPWR VGND sg13cmos5l_fill_1
X_3965_ _3965_/Q clkload6/A _3965_/D _3965_/RESET_B VPWR VGND sg13cmos5l_dfrbpq_1
X_3896_ _3896_/Q clkload7/A _3896_/D _3896_/RESET_B VPWR VGND sg13cmos5l_dfrbpq_1
X_2916_ _2917_/B _2916_/A _2916_/B VPWR VGND sg13cmos5l_xnor2_1
X_2847_ _4091_/D _2885_/B _2894_/B VPWR VGND sg13cmos5l_nor2_1
XFILLER_12_27 VPWR VGND sg13cmos5l_decap_8
XFILLER_12_38 VPWR VGND sg13cmos5l_fill_1
XFILLER_12_49 VPWR VGND sg13cmos5l_decap_4
X_2778_ _2779_/B _2778_/A _2778_/B VPWR VGND sg13cmos5l_xnor2_1
XFILLER_2_1024 VPWR VGND sg13cmos5l_decap_4
XFILLER_42_702 VPWR VGND sg13cmos5l_fill_1
XFILLER_14_404 VPWR VGND sg13cmos5l_decap_8
XFILLER_15_916 VPWR VGND sg13cmos5l_decap_8
XFILLER_14_415 VPWR VGND sg13cmos5l_fill_2
XFILLER_10_676 VPWR VGND sg13cmos5l_decap_8
X_4262__184 _4262_/RESET_B VPWR VGND sg13cmos5l_tiehi
XFILLER_5_157 VPWR VGND sg13cmos5l_decap_8
XFILLER_2_842 VPWR VGND sg13cmos5l_decap_8
XFILLER_18_743 VPWR VGND sg13cmos5l_decap_4
XFILLER_45_562 VPWR VGND sg13cmos5l_fill_2
XFILLER_33_713 VPWR VGND sg13cmos5l_decap_4
XFILLER_45_584 VPWR VGND sg13cmos5l_decap_4
XFILLER_14_960 VPWR VGND sg13cmos5l_decap_8
XFILLER_21_908 VPWR VGND sg13cmos5l_fill_1
XFILLER_33_779 VPWR VGND sg13cmos5l_fill_1
X_3750_ _3754_/B _4215_/Q _4214_/Q _4212_/Q _4213_/Q VPWR VGND sg13cmos5l_nor4_1
X_2701_ _2706_/A _4059_/Q _4060_/Q _4061_/Q VPWR VGND sg13cmos5l_nor3_1
XFILLER_13_492 VPWR VGND sg13cmos5l_decap_8
X_3681_ _3681_/Y _4221_/Q _3681_/B _3686_/B VPWR VGND sg13cmos5l_nor3_1
X_2632_ _2632_/Y _2634_/A _4009_/Q VPWR VGND sg13cmos5l_nand2b_1
X_4241__268 _4241_/RESET_B VPWR VGND sg13cmos5l_tiehi
X_2563_ _2563_/Y _2563_/A _3974_/Q VPWR VGND sg13cmos5l_nor2b_1
X_4233_ _4233_/Q _4237_/CLK _4233_/D _4233_/RESET_B VPWR VGND sg13cmos5l_dfrbpq_1
X_2494_ _2496_/C _4274_/Q _2497_/B _4278_/Q VPWR VGND sg13cmos5l_o21ai_1
X_4164_ _4164_/Q _4193_/CLK _4164_/D _4164_/RESET_B VPWR VGND sg13cmos5l_dfrbpq_1
X_3115_ _3115_/Y _3115_/A _3124_/B VPWR VGND sg13cmos5l_nand2_1
X_4095_ _4095_/Q _4193_/CLK _4095_/D _4095_/RESET_B VPWR VGND sg13cmos5l_dfrbpq_1
X_3046_ _4136_/D _3046_/A _3047_/B VPWR VGND sg13cmos5l_nor2_1
XFILLER_24_713 VPWR VGND sg13cmos5l_decap_8
XFILLER_23_256 VPWR VGND sg13cmos5l_fill_1
X_3948_ _3948_/Q clkload6/A _3948_/D _3948_/RESET_B VPWR VGND sg13cmos5l_dfrbpq_1
XFILLER_20_985 VPWR VGND sg13cmos5l_decap_8
X_3879_ _3879_/Q clkload2/A _3879_/D _3879_/RESET_B VPWR VGND sg13cmos5l_dfrbpq_1
X_4142__166 _4142_/D VPWR VGND sg13cmos5l_tielo
XFILLER_24_1003 VPWR VGND sg13cmos5l_decap_8
XFILLER_47_805 VPWR VGND sg13cmos5l_decap_8
XFILLER_15_713 VPWR VGND sg13cmos5l_fill_1
XFILLER_27_573 VPWR VGND sg13cmos5l_fill_2
XFILLER_14_289 VPWR VGND sg13cmos5l_fill_2
Xfanout82 _2675_/B2 _2677_/S1 VPWR VGND sg13cmos5l_buf_1
Xfanout60 _2194_/A _3617_/A VPWR VGND sg13cmos5l_buf_1
Xfanout71 _2474_/B _3855_/C VPWR VGND sg13cmos5l_buf_1
XFILLER_7_923 VPWR VGND sg13cmos5l_decap_8
Xfanout93 _2624_/A _2677_/S0 VPWR VGND sg13cmos5l_buf_1
XFILLER_43_8 VPWR VGND sg13cmos5l_fill_1
XFILLER_37_315 VPWR VGND sg13cmos5l_decap_8
XFILLER_37_348 VPWR VGND sg13cmos5l_fill_1
X_3802_ _3802_/Y _3802_/A _3802_/B VPWR VGND sg13cmos5l_nand2_1
X_3733_ _3734_/B _3733_/A _3733_/B VPWR VGND sg13cmos5l_xor2_1
XFILLER_9_260 VPWR VGND sg13cmos5l_fill_1
X_3664_ _3664_/Y _3677_/B _4260_/Q _4261_/Q _3673_/B VPWR VGND sg13cmos5l_a22oi_1
X_2615_ _4050_/D _2756_/A2 _2692_/B _2614_/Y VPWR VGND sg13cmos5l_a21oi_1
X_3595_ _3597_/A _3595_/A _3595_/B _3595_/C VPWR VGND sg13cmos5l_nor3_1
X_2546_ _2546_/Y _2568_/A _3902_/Q VPWR VGND sg13cmos5l_nor2b_1
X_2477_ _2477_/Y _2322_/A _2475_/B _2519_/A VPWR VGND sg13cmos5l_o21ai_1
X_4216_ _4216_/Q _4237_/CLK _4216_/D _4216_/RESET_B VPWR VGND sg13cmos5l_dfrbpq_1
XFILLER_18_26 VPWR VGND sg13cmos5l_decap_8
X_4147_ _4147_/Q _4173_/CLK _4147_/D _4147_/RESET_B VPWR VGND sg13cmos5l_dfrbpq_1
XFILLER_28_337 VPWR VGND sg13cmos5l_decap_8
XFILLER_29_849 VPWR VGND sg13cmos5l_decap_4
X_4078_ _4078_/Q clkload9/A _4078_/D _4078_/RESET_B VPWR VGND sg13cmos5l_dfrbpq_1
XFILLER_43_329 VPWR VGND sg13cmos5l_decap_8
XFILLER_37_882 VPWR VGND sg13cmos5l_decap_4
X_3029_ _3029_/Y _3015_/Y _3025_/Y _3028_/Y VPWR VGND sg13cmos5l_a21oi_1
XFILLER_12_716 VPWR VGND sg13cmos5l_decap_8
XFILLER_8_709 VPWR VGND sg13cmos5l_decap_4
XFILLER_11_215 VPWR VGND sg13cmos5l_decap_8
Xclkload2 clkload2/X clkload2/A VPWR VGND sg13cmos5l_buf_8
XFILLER_4_959 VPWR VGND sg13cmos5l_decap_8
XFILLER_3_414 VPWR VGND sg13cmos5l_decap_8
X_4159__482 _4159_/RESET_B VPWR VGND sg13cmos5l_tiehi
XFILLER_46_167 VPWR VGND sg13cmos5l_decap_8
X_4235__392 _4235_/RESET_B VPWR VGND sg13cmos5l_tiehi
XFILLER_28_893 VPWR VGND sg13cmos5l_decap_8
XFILLER_34_329 VPWR VGND sg13cmos5l_fill_1
XFILLER_27_381 VPWR VGND sg13cmos5l_fill_1
XFILLER_24_80 VPWR VGND sg13cmos5l_decap_4
X_4084__175 _4084_/D VPWR VGND sg13cmos5l_tielo
Xhold709 hold709/X _3964_/Q VPWR VGND sg13cmos5l_dlygate4sd3_1
X_2400_ _2400_/X _3863_/A0 hold699/X _2400_/S VPWR VGND sg13cmos5l_mux2_1
X_3380_ _4190_/D _3547_/A _3380_/B VPWR VGND sg13cmos5l_and2_1
X_2331_ _3935_/D _3854_/A1 hold716/X _2331_/S VPWR VGND sg13cmos5l_mux2_1
XFILLER_34_4 VPWR VGND sg13cmos5l_fill_2
X_2262_ _2283_/B _4024_/Q _4023_/Q _4022_/Q VPWR VGND sg13cmos5l_nor3_1
X_4001_ _4001_/Q clkload6/A _4001_/D _4001_/RESET_B VPWR VGND sg13cmos5l_dfrbpq_1
X_2193_ _2193_/Y _4047_/Q VPWR VGND sg13cmos5l_inv_1
XFILLER_38_646 VPWR VGND sg13cmos5l_decap_8
XFILLER_38_668 VPWR VGND sg13cmos5l_decap_4
X_4214__421 _4214_/RESET_B VPWR VGND sg13cmos5l_tiehi
XFILLER_37_178 VPWR VGND sg13cmos5l_decap_8
XFILLER_34_863 VPWR VGND sg13cmos5l_decap_8
X_4247__252 _4247_/RESET_B VPWR VGND sg13cmos5l_tiehi
XFILLER_14_1002 VPWR VGND sg13cmos5l_decap_8
XFILLER_21_579 VPWR VGND sg13cmos5l_decap_8
X_3716_ _3716_/Y _4254_/Q _4228_/Q VPWR VGND sg13cmos5l_nand2_1
X_3647_ _3647_/Y _4244_/Q _3647_/B VPWR VGND sg13cmos5l_xnor2_1
XFILLER_1_918 VPWR VGND sg13cmos5l_decap_8
X_3578_ _3594_/B _4225_/Q _4196_/Q _4230_/Q VPWR VGND sg13cmos5l_nand3_1
X_2529_ _2529_/Y _2535_/A _2528_/Y _2726_/A VPWR VGND sg13cmos5l_o21ai_1
XFILLER_45_46 VPWR VGND sg13cmos5l_decap_8
XFILLER_44_627 VPWR VGND sg13cmos5l_fill_1
XFILLER_43_137 VPWR VGND sg13cmos5l_decap_4
XFILLER_24_384 VPWR VGND sg13cmos5l_decap_8
XFILLER_12_579 VPWR VGND sg13cmos5l_decap_8
XFILLER_4_778 VPWR VGND sg13cmos5l_decap_8
XFILLER_0_984 VPWR VGND sg13cmos5l_decap_8
XFILLER_48_944 VPWR VGND sg13cmos5l_decap_8
XFILLER_19_101 VPWR VGND sg13cmos5l_fill_1
XFILLER_35_616 VPWR VGND sg13cmos5l_fill_2
XFILLER_16_885 VPWR VGND sg13cmos5l_decap_4
XFILLER_43_682 VPWR VGND sg13cmos5l_decap_8
XFILLER_30_321 VPWR VGND sg13cmos5l_fill_1
X_2880_ _4102_/D _3041_/A _2880_/B VPWR VGND sg13cmos5l_and2_1
XFILLER_30_398 VPWR VGND sg13cmos5l_decap_8
X_3501_ _3501_/Y _3292_/A _3492_/A _3495_/X _3499_/Y _3500_/X VPWR VGND sg13cmos5l_a221oi_1
X_3432_ _3432_/X _3432_/A _3432_/B VPWR VGND sg13cmos5l_and2_1
X_3363_ _3363_/Y _4206_/Q _4202_/Q VPWR VGND sg13cmos5l_nor2b_1
X_3294_ _3298_/A _3288_/Y _3290_/Y _3293_/Y VPWR VGND sg13cmos5l_a21oi_1
X_2314_ _3920_/D _3866_/A0 hold711/X _2321_/S VPWR VGND sg13cmos5l_mux2_1
XFILLER_39_944 VPWR VGND sg13cmos5l_decap_8
Xheichips26_dna_sequencer_144 uio_out[3] VPWR VGND sg13cmos5l_tielo
X_2245_ _3176_/B _2245_/A VPWR VGND sg13cmos5l_inv_1
X_2176_ _2176_/Y _2176_/A VPWR VGND sg13cmos5l_inv_1
XFILLER_19_690 VPWR VGND sg13cmos5l_decap_8
XFILLER_25_148 VPWR VGND sg13cmos5l_decap_8
XFILLER_15_38 VPWR VGND sg13cmos5l_decap_4
XFILLER_22_811 VPWR VGND sg13cmos5l_fill_1
X_4030__247 _4030_/RESET_B VPWR VGND sg13cmos5l_tiehi
XFILLER_33_181 VPWR VGND sg13cmos5l_fill_1
XFILLER_21_343 VPWR VGND sg13cmos5l_decap_4
XFILLER_22_855 VPWR VGND sg13cmos5l_decap_8
XFILLER_22_888 VPWR VGND sg13cmos5l_decap_8
X_4149__492 _4149_/RESET_B VPWR VGND sg13cmos5l_tiehi
X_4067__192 _4067_/RESET_B VPWR VGND sg13cmos5l_tiehi
Xoutput15 uo_out[1] _4017_/Q VPWR VGND sg13cmos5l_buf_1
XFILLER_1_715 VPWR VGND sg13cmos5l_decap_8
XFILLER_29_421 VPWR VGND sg13cmos5l_fill_2
XFILLER_45_936 VPWR VGND sg13cmos5l_decap_8
X_4156__485 _4156_/RESET_B VPWR VGND sg13cmos5l_tiehi
XFILLER_44_457 VPWR VGND sg13cmos5l_decap_8
XFILLER_16_137 VPWR VGND sg13cmos5l_decap_4
X_4232__395 _4232_/RESET_B VPWR VGND sg13cmos5l_tiehi
XFILLER_13_800 VPWR VGND sg13cmos5l_decap_8
XFILLER_12_310 VPWR VGND sg13cmos5l_decap_8
XFILLER_9_826 VPWR VGND sg13cmos5l_fill_2
XFILLER_12_343 VPWR VGND sg13cmos5l_decap_8
XFILLER_12_354 VPWR VGND sg13cmos5l_decap_8
XFILLER_9_848 VPWR VGND sg13cmos5l_decap_8
XFILLER_8_369 VPWR VGND sg13cmos5l_fill_1
X_4204__431 _4204_/RESET_B VPWR VGND sg13cmos5l_tiehi
XFILLER_21_81 VPWR VGND sg13cmos5l_decap_4
XFILLER_0_781 VPWR VGND sg13cmos5l_decap_8
XFILLER_48_741 VPWR VGND sg13cmos5l_decap_8
XFILLER_35_413 VPWR VGND sg13cmos5l_decap_8
XFILLER_36_947 VPWR VGND sg13cmos5l_decap_8
XFILLER_47_295 VPWR VGND sg13cmos5l_decap_8
X_3981_ _3981_/Q _4031_/CLK _3981_/D _3981_/RESET_B VPWR VGND sg13cmos5l_dfrbpq_1
X_4211__424 _4211_/RESET_B VPWR VGND sg13cmos5l_tiehi
X_2932_ _3154_/A _3213_/A _2964_/A VPWR VGND sg13cmos5l_nand2_1
XFILLER_31_630 VPWR VGND sg13cmos5l_decap_4
X_2863_ _2863_/Y _2859_/Y _2860_/Y _2862_/Y VPWR VGND sg13cmos5l_o21ai_1
X_2794_ _2990_/C _2799_/B VPWR VGND sg13cmos5l_inv_1
XFILLER_7_61 VPWR VGND sg13cmos5l_decap_8
XFILLER_7_94 VPWR VGND sg13cmos5l_decap_8
X_3415_ _3415_/Y _4200_/Q _3438_/B VPWR VGND sg13cmos5l_nand2_1
X_3346_ _3432_/B _3115_/A _3124_/B _3318_/Y _3338_/C VPWR VGND sg13cmos5l_a22oi_1
Xhold1003 _3811_/B1 _3810_/Y VPWR VGND sg13cmos5l_dlygate4sd3_1
Xhold1014 _3100_/B1 _4145_/Q VPWR VGND sg13cmos5l_dlygate4sd3_1
X_3277_ _3500_/A _3558_/A _4204_/Q VPWR VGND sg13cmos5l_xnor2_1
X_2228_ _3046_/A _2820_/A VPWR VGND sg13cmos5l_inv_1
XFILLER_26_424 VPWR VGND sg13cmos5l_decap_8
XFILLER_26_457 VPWR VGND sg13cmos5l_fill_1
XFILLER_13_129 VPWR VGND sg13cmos5l_decap_8
XFILLER_35_991 VPWR VGND sg13cmos5l_decap_8
XFILLER_42_25 VPWR VGND sg13cmos5l_fill_2
XFILLER_10_803 VPWR VGND sg13cmos5l_decap_8
XFILLER_42_69 VPWR VGND sg13cmos5l_decap_8
XFILLER_42_58 VPWR VGND sg13cmos5l_fill_2
XFILLER_22_663 VPWR VGND sg13cmos5l_decap_4
XFILLER_22_674 VPWR VGND sg13cmos5l_fill_1
XFILLER_5_339 VPWR VGND sg13cmos5l_fill_1
XFILLER_1_523 VPWR VGND sg13cmos5l_fill_1
Xhold881 _3378_/B _4188_/Q VPWR VGND sg13cmos5l_dlygate4sd3_1
XFILLER_27_1001 VPWR VGND sg13cmos5l_decap_8
Xhold870 _3009_/C _4140_/Q VPWR VGND sg13cmos5l_dlygate4sd3_1
Xhold892 _3181_/A _4172_/Q VPWR VGND sg13cmos5l_dlygate4sd3_1
XFILLER_49_549 VPWR VGND sg13cmos5l_decap_8
XFILLER_45_744 VPWR VGND sg13cmos5l_decap_8
XFILLER_44_265 VPWR VGND sg13cmos5l_decap_4
XFILLER_44_243 VPWR VGND sg13cmos5l_fill_1
XFILLER_33_906 VPWR VGND sg13cmos5l_decap_8
XFILLER_44_287 VPWR VGND sg13cmos5l_decap_8
XFILLER_16_70 VPWR VGND sg13cmos5l_fill_1
XFILLER_26_980 VPWR VGND sg13cmos5l_decap_8
XFILLER_32_416 VPWR VGND sg13cmos5l_decap_4
XFILLER_41_950 VPWR VGND sg13cmos5l_decap_8
Xclkbuf_leaf_24_clk _4265_/CLK clkbuf_leaf_4_clk/A VPWR VGND sg13cmos5l_buf_8
X_3987__304 _3987_/RESET_B VPWR VGND sg13cmos5l_tiehi
XFILLER_32_449 VPWR VGND sg13cmos5l_decap_4
XFILLER_40_460 VPWR VGND sg13cmos5l_fill_1
XFILLER_8_111 VPWR VGND sg13cmos5l_fill_2
X_4280__477 _4280_/RESET_B VPWR VGND sg13cmos5l_tiehi
XFILLER_4_383 VPWR VGND sg13cmos5l_decap_4
X_4180_ _4180_/Q _4231_/CLK _4180_/D _4180_/RESET_B VPWR VGND sg13cmos5l_dfrbpq_1
X_3200_ _3200_/Y _3183_/Y _3197_/S _3199_/Y VPWR VGND sg13cmos5l_a21oi_1
X_3131_ _3137_/B _4119_/Q _4117_/Q _4118_/Q VPWR VGND sg13cmos5l_or3_1
X_3062_ _3063_/B _3062_/A _3073_/B VPWR VGND sg13cmos5l_nor2_1
X_3964_ _3964_/Q _4031_/CLK _3964_/D _3964_/RESET_B VPWR VGND sg13cmos5l_dfrbpq_1
XFILLER_23_449 VPWR VGND sg13cmos5l_decap_8
Xclkbuf_leaf_15_clk _4173_/CLK clkload1/A VPWR VGND sg13cmos5l_buf_8
X_2915_ _2918_/B _2889_/B _2914_/B _2914_/Y VPWR VGND sg13cmos5l_a21oi_1
XFILLER_32_994 VPWR VGND sg13cmos5l_decap_8
X_3895_ _3895_/Q clkload9/A _3895_/D _3895_/RESET_B VPWR VGND sg13cmos5l_dfrbpq_1
X_2846_ _2894_/B _2704_/Y _2837_/A _2845_/Y VPWR VGND sg13cmos5l_a21oi_1
XFILLER_31_493 VPWR VGND sg13cmos5l_fill_1
X_4146__495 _4146_/RESET_B VPWR VGND sg13cmos5l_tiehi
X_2777_ _2778_/B _2771_/A _2773_/B _2762_/Y VPWR VGND sg13cmos5l_a21oi_1
X_4064__195 _4064_/RESET_B VPWR VGND sg13cmos5l_tiehi
X_3329_ _3343_/B _3326_/X _3327_/Y _3328_/Y VPWR VGND sg13cmos5l_a21oi_1
XFILLER_2_1003 VPWR VGND sg13cmos5l_decap_8
XFILLER_27_733 VPWR VGND sg13cmos5l_decap_4
X_4153__488 _4153_/RESET_B VPWR VGND sg13cmos5l_tiehi
XFILLER_26_232 VPWR VGND sg13cmos5l_fill_2
X_4071__188 _4071_/RESET_B VPWR VGND sg13cmos5l_tiehi
XFILLER_42_769 VPWR VGND sg13cmos5l_decap_8
XFILLER_10_611 VPWR VGND sg13cmos5l_fill_2
XFILLER_5_147 VPWR VGND sg13cmos5l_fill_1
XFILLER_2_821 VPWR VGND sg13cmos5l_decap_8
X_4201__434 _4201_/RESET_B VPWR VGND sg13cmos5l_tiehi
XFILLER_2_898 VPWR VGND sg13cmos5l_decap_8
XFILLER_45_530 VPWR VGND sg13cmos5l_decap_4
XFILLER_17_210 VPWR VGND sg13cmos5l_decap_4
XFILLER_45_541 VPWR VGND sg13cmos5l_fill_2
XFILLER_27_80 VPWR VGND sg13cmos5l_fill_1
XFILLER_33_736 VPWR VGND sg13cmos5l_decap_8
XFILLER_33_769 VPWR VGND sg13cmos5l_fill_1
X_2700_ _2789_/A _2872_/B _2792_/B VPWR VGND sg13cmos5l_nand2b_1
X_3680_ _3680_/Y _3680_/A _3680_/B _3680_/C VPWR VGND sg13cmos5l_nor3_1
XFILLER_9_486 VPWR VGND sg13cmos5l_decap_8
X_2631_ _2631_/Y _2422_/B _2622_/Y _2630_/Y VPWR VGND sg13cmos5l_o21ai_1
X_2562_ _2562_/Y _2643_/S0 _3991_/Q _2645_/S1 VPWR VGND sg13cmos5l_a21oi_1
X_4232_ _4232_/Q _4237_/CLK _4232_/D _4232_/RESET_B VPWR VGND sg13cmos5l_dfrbpq_1
X_2493_ _2496_/B _4276_/Q _4278_/Q _2278_/Y VPWR VGND sg13cmos5l_o21ai_1
Xclkbuf_leaf_4_clk clkload2/A clkbuf_leaf_4_clk/A VPWR VGND sg13cmos5l_buf_8
X_4163_ _4163_/Q _4193_/CLK _4163_/D _4163_/RESET_B VPWR VGND sg13cmos5l_dfrbpq_1
X_3114_ _3124_/B _4174_/Q _3114_/B VPWR VGND sg13cmos5l_xnor2_1
X_4094_ _4094_/Q _4136_/CLK _4094_/D _4094_/RESET_B VPWR VGND sg13cmos5l_dfrbpq_1
XFILLER_49_891 VPWR VGND sg13cmos5l_decap_8
X_3045_ _4135_/D _3045_/A _3047_/B VPWR VGND sg13cmos5l_nor2_1
XFILLER_24_758 VPWR VGND sg13cmos5l_fill_1
X_3947_ _3947_/Q _4031_/CLK _3947_/D _3947_/RESET_B VPWR VGND sg13cmos5l_dfrbpq_1
XFILLER_23_16 VPWR VGND sg13cmos5l_decap_8
XFILLER_20_931 VPWR VGND sg13cmos5l_fill_2
XFILLER_20_964 VPWR VGND sg13cmos5l_decap_4
X_3878_ _3878_/Q clkload9/A _3878_/D _3878_/RESET_B VPWR VGND sg13cmos5l_dfrbpq_1
X_2829_ _2829_/Y _4082_/Q _4064_/Q VPWR VGND sg13cmos5l_nand2b_1
XFILLER_48_35 VPWR VGND sg13cmos5l_decap_8
X_3977__314 _3977_/RESET_B VPWR VGND sg13cmos5l_tiehi
XFILLER_46_316 VPWR VGND sg13cmos5l_decap_8
XFILLER_46_305 VPWR VGND sg13cmos5l_decap_4
XFILLER_42_500 VPWR VGND sg13cmos5l_decap_8
XFILLER_15_736 VPWR VGND sg13cmos5l_decap_8
XFILLER_9_18 VPWR VGND sg13cmos5l_decap_4
XFILLER_15_769 VPWR VGND sg13cmos5l_decap_8
XFILLER_14_257 VPWR VGND sg13cmos5l_decap_4
Xfanout83 _2677_/S1 fanout84/X VPWR VGND sg13cmos5l_buf_1
Xfanout61 _2488_/A2 _3617_/A VPWR VGND sg13cmos5l_buf_1
Xfanout50 _3373_/A _3273_/Y VPWR VGND sg13cmos5l_buf_1
Xfanout72 _3855_/C _4029_/Q VPWR VGND sg13cmos5l_buf_1
X_3984__307 _3984_/RESET_B VPWR VGND sg13cmos5l_tiehi
Xfanout94 _2657_/S _2677_/S0 VPWR VGND sg13cmos5l_buf_1
XFILLER_6_401 VPWR VGND sg13cmos5l_fill_1
XFILLER_10_430 VPWR VGND sg13cmos5l_decap_8
XFILLER_22_290 VPWR VGND sg13cmos5l_decap_4
XFILLER_11_997 VPWR VGND sg13cmos5l_decap_8
XFILLER_13_93 VPWR VGND sg13cmos5l_fill_2
XFILLER_7_979 VPWR VGND sg13cmos5l_decap_8
XFILLER_6_478 VPWR VGND sg13cmos5l_decap_4
XFILLER_2_673 VPWR VGND sg13cmos5l_fill_1
XFILLER_38_806 VPWR VGND sg13cmos5l_fill_1
XFILLER_18_574 VPWR VGND sg13cmos5l_decap_8
X_3801_ _3802_/B _3801_/A _3801_/B VPWR VGND sg13cmos5l_xnor2_1
XFILLER_33_577 VPWR VGND sg13cmos5l_fill_2
XFILLER_33_599 VPWR VGND sg13cmos5l_decap_8
X_3732_ _3802_/A _3794_/B VPWR VGND sg13cmos5l_inv_1
XFILLER_13_290 VPWR VGND sg13cmos5l_fill_1
X_3663_ _4243_/D _3715_/B _3805_/A VPWR VGND sg13cmos5l_nor2_1
X_2614_ _2614_/Y _2692_/A _2756_/A2 _2688_/A VPWR VGND sg13cmos5l_o21ai_1
X_3594_ _3595_/C _3594_/A _3594_/B _3594_/C VPWR VGND sg13cmos5l_and3_1
XFILLER_47_1015 VPWR VGND sg13cmos5l_decap_8
X_2545_ _2545_/Y _2568_/A _3936_/Q VPWR VGND sg13cmos5l_nand2b_1
X_4143__498 _4143_/RESET_B VPWR VGND sg13cmos5l_tiehi
X_4061__198 _4061_/RESET_B VPWR VGND sg13cmos5l_tiehi
X_2476_ _4030_/D _2476_/A _2476_/B VPWR VGND sg13cmos5l_nor2_1
X_4215_ _4215_/Q _4237_/CLK _4215_/D _4215_/RESET_B VPWR VGND sg13cmos5l_dfrbpq_1
X_4146_ _4146_/Q _4173_/CLK _4146_/D _4146_/RESET_B VPWR VGND sg13cmos5l_dfrbpq_1
XFILLER_28_316 VPWR VGND sg13cmos5l_decap_8
X_4077_ _4077_/Q _4129_/CLK _4077_/D _4077_/RESET_B VPWR VGND sg13cmos5l_dfrbpq_1
X_3028_ _3028_/Y hold897/X _3025_/Y _3000_/A VPWR VGND sg13cmos5l_o21ai_1
XFILLER_24_544 VPWR VGND sg13cmos5l_decap_4
XFILLER_12_706 VPWR VGND sg13cmos5l_decap_4
XFILLER_34_59 VPWR VGND sg13cmos5l_fill_1
Xclkload3 clkload3/Y clkload3/A VPWR VGND sg13cmos5l_inv_2
XFILLER_4_938 VPWR VGND sg13cmos5l_decap_8
X_4040__227 _4040_/RESET_B VPWR VGND sg13cmos5l_tiehi
XFILLER_46_124 VPWR VGND sg13cmos5l_decap_4
XFILLER_46_179 VPWR VGND sg13cmos5l_decap_4
XFILLER_34_308 VPWR VGND sg13cmos5l_decap_8
XFILLER_15_544 VPWR VGND sg13cmos5l_decap_4
XFILLER_27_393 VPWR VGND sg13cmos5l_fill_2
XFILLER_30_525 VPWR VGND sg13cmos5l_decap_8
XFILLER_6_242 VPWR VGND sg13cmos5l_decap_8
XFILLER_41_6 VPWR VGND sg13cmos5l_fill_1
X_2330_ _3934_/D _3873_/A0 hold806/X _2331_/S VPWR VGND sg13cmos5l_mux2_1
XFILLER_3_993 VPWR VGND sg13cmos5l_decap_8
XFILLER_2_470 VPWR VGND sg13cmos5l_decap_4
X_2261_ _3833_/B _4276_/Q _4275_/Q VPWR VGND sg13cmos5l_nor2_1
X_4000_ _4000_/Q _4031_/CLK _4000_/D _4000_/RESET_B VPWR VGND sg13cmos5l_dfrbpq_1
XFILLER_27_4 VPWR VGND sg13cmos5l_fill_2
X_2192_ _2192_/Y _2692_/A VPWR VGND sg13cmos5l_inv_1
XFILLER_46_691 VPWR VGND sg13cmos5l_fill_2
XFILLER_18_382 VPWR VGND sg13cmos5l_decap_4
X_3891__242 _3891_/RESET_B VPWR VGND sg13cmos5l_tiehi
XFILLER_21_503 VPWR VGND sg13cmos5l_decap_8
X_3967__324 _3967_/RESET_B VPWR VGND sg13cmos5l_tiehi
X_3715_ _4259_/D _3715_/A _3715_/B VPWR VGND sg13cmos5l_nor2_1
X_3646_ _3646_/Y _3658_/B _3646_/B VPWR VGND sg13cmos5l_nand2_1
X_3577_ _3594_/A _3591_/A _3591_/B VPWR VGND sg13cmos5l_nand2_1
X_2528_ _2528_/Y _2528_/A _2727_/A VPWR VGND sg13cmos5l_nor2_1
X_2459_ _2459_/Y _2456_/A _2464_/A _2466_/A VPWR VGND sg13cmos5l_o21ai_1
X_3974__317 _3974_/RESET_B VPWR VGND sg13cmos5l_tiehi
XFILLER_28_146 VPWR VGND sg13cmos5l_decap_8
X_4129_ _4129_/Q _4129_/CLK _4129_/D _4129_/RESET_B VPWR VGND sg13cmos5l_dfrbpq_1
XFILLER_43_116 VPWR VGND sg13cmos5l_decap_8
XFILLER_37_680 VPWR VGND sg13cmos5l_fill_1
XFILLER_12_525 VPWR VGND sg13cmos5l_decap_4
XFILLER_24_396 VPWR VGND sg13cmos5l_decap_8
XFILLER_12_558 VPWR VGND sg13cmos5l_decap_4
XFILLER_4_757 VPWR VGND sg13cmos5l_decap_8
XFILLER_3_256 VPWR VGND sg13cmos5l_fill_1
XFILLER_0_963 VPWR VGND sg13cmos5l_decap_8
XFILLER_48_923 VPWR VGND sg13cmos5l_decap_8
XFILLER_47_422 VPWR VGND sg13cmos5l_decap_8
XFILLER_19_168 VPWR VGND sg13cmos5l_fill_2
XFILLER_31_889 VPWR VGND sg13cmos5l_decap_8
X_3500_ _3500_/X _3500_/A _3500_/B _3500_/C VPWR VGND sg13cmos5l_and3_1
XFILLER_11_580 VPWR VGND sg13cmos5l_decap_8
X_3431_ _3431_/Y _3427_/Y _3429_/Y _3430_/Y VPWR VGND sg13cmos5l_o21ai_1
X_3362_ _3362_/Y _4157_/Q _3362_/B VPWR VGND sg13cmos5l_nor2_1
XFILLER_3_790 VPWR VGND sg13cmos5l_decap_8
X_2313_ _3919_/D _3865_/A0 hold746/X _2321_/S VPWR VGND sg13cmos5l_mux2_1
X_3293_ _3293_/Y _3292_/A _3312_/A _3309_/B VPWR VGND sg13cmos5l_o21ai_1
XFILLER_39_923 VPWR VGND sg13cmos5l_decap_8
Xheichips26_dna_sequencer_145 uio_out[4] VPWR VGND sg13cmos5l_tielo
Xheichips26_dna_sequencer_134 uio_oe[1] VPWR VGND sg13cmos5l_tielo
X_2244_ _3185_/B _4123_/Q VPWR VGND sg13cmos5l_inv_1
XFILLER_38_433 VPWR VGND sg13cmos5l_fill_2
X_2175_ _3677_/B _2175_/A VPWR VGND sg13cmos5l_inv_1
XFILLER_25_105 VPWR VGND sg13cmos5l_fill_2
XFILLER_38_499 VPWR VGND sg13cmos5l_decap_8
XFILLER_34_672 VPWR VGND sg13cmos5l_fill_2
XFILLER_21_366 VPWR VGND sg13cmos5l_fill_1
XFILLER_31_16 VPWR VGND sg13cmos5l_decap_4
X_3629_ _3638_/B _4263_/Q _4262_/Q _4261_/Q VPWR VGND sg13cmos5l_nor3_1
Xoutput16 uo_out[2] _4018_/Q VPWR VGND sg13cmos5l_buf_1
XFILLER_0_237 VPWR VGND sg13cmos5l_decap_4
XFILLER_0_204 VPWR VGND sg13cmos5l_fill_2
XFILLER_0_259 VPWR VGND sg13cmos5l_decap_8
XFILLER_5_1023 VPWR VGND sg13cmos5l_decap_4
XFILLER_45_915 VPWR VGND sg13cmos5l_decap_8
XFILLER_44_436 VPWR VGND sg13cmos5l_decap_8
XFILLER_16_116 VPWR VGND sg13cmos5l_decap_8
XFILLER_16_127 VPWR VGND sg13cmos5l_fill_1
XFILLER_40_642 VPWR VGND sg13cmos5l_fill_2
XFILLER_13_878 VPWR VGND sg13cmos5l_decap_4
XFILLER_8_315 VPWR VGND sg13cmos5l_decap_8
XFILLER_4_532 VPWR VGND sg13cmos5l_decap_8
XFILLER_4_521 VPWR VGND sg13cmos5l_fill_1
XFILLER_0_760 VPWR VGND sg13cmos5l_decap_8
X_3957__334 _3957_/RESET_B VPWR VGND sg13cmos5l_tiehi
XFILLER_48_797 VPWR VGND sg13cmos5l_decap_8
XFILLER_47_241 VPWR VGND sg13cmos5l_decap_4
XFILLER_36_926 VPWR VGND sg13cmos5l_decap_8
X_3980_ _3980_/Q _4031_/CLK _3980_/D _3980_/RESET_B VPWR VGND sg13cmos5l_dfrbpq_1
XFILLER_44_981 VPWR VGND sg13cmos5l_decap_8
X_2931_ _3152_/A _4142_/Q _2931_/B VPWR VGND sg13cmos5l_xnor2_1
Xclkbuf_0_clk clkbuf_0_clk/X clk VPWR VGND sg13cmos5l_buf_8
X_2862_ _2862_/Y _4094_/Q _2859_/B _2861_/Y _4095_/Q VPWR VGND sg13cmos5l_a22oi_1
X_2793_ _2799_/B _2817_/A _4110_/Q VPWR VGND sg13cmos5l_nor2_1
XFILLER_30_196 VPWR VGND sg13cmos5l_decap_8
X_3964__327 _3964_/RESET_B VPWR VGND sg13cmos5l_tiehi
XFILLER_8_871 VPWR VGND sg13cmos5l_fill_2
XFILLER_7_40 VPWR VGND sg13cmos5l_decap_4
XFILLER_7_370 VPWR VGND sg13cmos5l_fill_1
X_3414_ _3438_/C _4200_/Q _3438_/B _3434_/A VPWR VGND sg13cmos5l_o21ai_1
X_3345_ _4182_/D _3394_/B _3428_/A VPWR VGND sg13cmos5l_nor2_1
Xhold1015 _3155_/A _4117_/Q VPWR VGND sg13cmos5l_dlygate4sd3_1
X_3276_ _3276_/Y _3289_/A _3289_/B VPWR VGND sg13cmos5l_nand2_1
Xhold1004 hold1004/X _4175_/Q VPWR VGND sg13cmos5l_dlygate4sd3_1
X_2227_ _2227_/Y _2227_/A VPWR VGND sg13cmos5l_inv_1
XFILLER_39_742 VPWR VGND sg13cmos5l_fill_1
XFILLER_27_926 VPWR VGND sg13cmos5l_fill_2
XFILLER_26_469 VPWR VGND sg13cmos5l_decap_8
XFILLER_35_970 VPWR VGND sg13cmos5l_decap_8
XFILLER_22_631 VPWR VGND sg13cmos5l_fill_2
XFILLER_34_480 VPWR VGND sg13cmos5l_decap_8
XFILLER_34_491 VPWR VGND sg13cmos5l_fill_1
XFILLER_21_163 VPWR VGND sg13cmos5l_fill_2
XFILLER_21_196 VPWR VGND sg13cmos5l_decap_4
XFILLER_22_697 VPWR VGND sg13cmos5l_decap_8
XFILLER_5_329 VPWR VGND sg13cmos5l_fill_1
XFILLER_5_318 VPWR VGND sg13cmos5l_fill_2
XFILLER_5_307 VPWR VGND sg13cmos5l_decap_8
Xhold882 hold882/X _3378_/Y VPWR VGND sg13cmos5l_dlygate4sd3_1
Xhold860 _4156_/D _3202_/Y VPWR VGND sg13cmos5l_dlygate4sd3_1
Xhold871 _3032_/B _4125_/Q VPWR VGND sg13cmos5l_dlygate4sd3_1
Xhold893 _2537_/A _4048_/Q VPWR VGND sg13cmos5l_dlygate4sd3_1
XFILLER_44_255 VPWR VGND sg13cmos5l_decap_4
XFILLER_25_480 VPWR VGND sg13cmos5l_fill_2
XFILLER_13_664 VPWR VGND sg13cmos5l_decap_8
XFILLER_13_675 VPWR VGND sg13cmos5l_fill_2
XFILLER_13_686 VPWR VGND sg13cmos5l_decap_8
XFILLER_8_123 VPWR VGND sg13cmos5l_decap_4
XFILLER_12_196 VPWR VGND sg13cmos5l_fill_2
XFILLER_8_189 VPWR VGND sg13cmos5l_fill_2
XFILLER_5_885 VPWR VGND sg13cmos5l_decap_8
X_3130_ _4146_/D _3217_/B _3255_/A VPWR VGND sg13cmos5l_and2_1
X_3061_ _3079_/A _3077_/B _3077_/C _3077_/A VPWR VGND sg13cmos5l_a21oi_1
XFILLER_24_907 VPWR VGND sg13cmos5l_decap_8
XFILLER_36_756 VPWR VGND sg13cmos5l_decap_8
XFILLER_36_789 VPWR VGND sg13cmos5l_fill_1
XFILLER_17_981 VPWR VGND sg13cmos5l_decap_8
XFILLER_23_417 VPWR VGND sg13cmos5l_decap_8
X_3963_ _3963_/Q _4031_/CLK _3963_/D _3963_/RESET_B VPWR VGND sg13cmos5l_dfrbpq_1
X_2914_ _2914_/Y _2914_/A _2914_/B VPWR VGND sg13cmos5l_nor2_1
X_3894_ _3894_/Q clkload9/A _3894_/D _3894_/RESET_B VPWR VGND sg13cmos5l_dfrbpq_1
XFILLER_32_973 VPWR VGND sg13cmos5l_decap_8
X_2845_ _2845_/Y _2845_/A _2845_/B VPWR VGND sg13cmos5l_nor2_1
X_2776_ _2776_/Y _2776_/A _2776_/B VPWR VGND sg13cmos5l_nand2_1
X_3328_ _3328_/Y _3115_/A _3317_/X _3124_/B VPWR VGND sg13cmos5l_o21ai_1
XFILLER_39_550 VPWR VGND sg13cmos5l_decap_4
X_3259_ _3259_/Y _3252_/A _3252_/B _3255_/Y _3258_/Y VPWR VGND sg13cmos5l_a22oi_1
XFILLER_42_715 VPWR VGND sg13cmos5l_decap_4
XFILLER_41_203 VPWR VGND sg13cmos5l_decap_4
XFILLER_23_951 VPWR VGND sg13cmos5l_decap_8
XFILLER_23_962 VPWR VGND sg13cmos5l_fill_2
XFILLER_10_645 VPWR VGND sg13cmos5l_decap_8
XFILLER_6_605 VPWR VGND sg13cmos5l_decap_4
X_3947__344 _3947_/RESET_B VPWR VGND sg13cmos5l_tiehi
XFILLER_5_115 VPWR VGND sg13cmos5l_decap_8
XFILLER_2_800 VPWR VGND sg13cmos5l_decap_8
Xhold690 hold690/X _3962_/Q VPWR VGND sg13cmos5l_dlygate4sd3_1
XFILLER_2_877 VPWR VGND sg13cmos5l_decap_8
XFILLER_40_1010 VPWR VGND sg13cmos5l_decap_8
XFILLER_45_564 VPWR VGND sg13cmos5l_fill_1
X_3954__337 _3954_/RESET_B VPWR VGND sg13cmos5l_tiehi
XFILLER_32_203 VPWR VGND sg13cmos5l_decap_4
XFILLER_32_225 VPWR VGND sg13cmos5l_decap_4
XFILLER_33_748 VPWR VGND sg13cmos5l_decap_8
XFILLER_14_995 VPWR VGND sg13cmos5l_decap_8
XFILLER_9_454 VPWR VGND sg13cmos5l_decap_8
X_2630_ _2630_/Y _2422_/B _2629_/X _4040_/Q VPWR VGND sg13cmos5l_a21oi_1
X_2561_ _2561_/Y _2643_/S0 _4008_/Q VPWR VGND sg13cmos5l_nand2b_1
XFILLER_5_693 VPWR VGND sg13cmos5l_fill_2
X_2492_ _4038_/D _2194_/Y _2491_/Y _3874_/A VPWR VGND sg13cmos5l_a21oi_1
X_4231_ _4231_/Q _4231_/CLK _4231_/D _4231_/RESET_B VPWR VGND sg13cmos5l_dfrbpq_1
X_4162_ _4162_/Q _4193_/CLK _4162_/D _4162_/RESET_B VPWR VGND sg13cmos5l_dfrbpq_1
XFILLER_49_870 VPWR VGND sg13cmos5l_decap_8
X_3113_ _3113_/Y _3102_/X _3107_/Y _3115_/A _3112_/X _3108_/X VPWR VGND sg13cmos5l_a221oi_1
XFILLER_28_509 VPWR VGND sg13cmos5l_fill_2
X_4093_ _4093_/Q _4136_/CLK _4093_/D _4093_/RESET_B VPWR VGND sg13cmos5l_dfrbpq_1
X_3044_ _4134_/D _3044_/A _3047_/B VPWR VGND sg13cmos5l_nor2_1
XFILLER_24_704 VPWR VGND sg13cmos5l_fill_1
XFILLER_36_553 VPWR VGND sg13cmos5l_decap_4
XFILLER_23_203 VPWR VGND sg13cmos5l_decap_8
XFILLER_17_1023 VPWR VGND sg13cmos5l_decap_4
X_3946_ _3946_/Q _4031_/CLK _3946_/D _3946_/RESET_B VPWR VGND sg13cmos5l_dfrbpq_1
XFILLER_20_943 VPWR VGND sg13cmos5l_decap_8
X_3877_ _3877_/Q clkload9/A _3877_/D _3877_/RESET_B VPWR VGND sg13cmos5l_dfrbpq_1
X_2828_ _2828_/Y _4063_/Q _4064_/Q VPWR VGND sg13cmos5l_xnor2_1
X_2759_ _4077_/D _2792_/B _2768_/B VPWR VGND sg13cmos5l_and2_1
XFILLER_2_118 VPWR VGND sg13cmos5l_fill_1
XFILLER_48_14 VPWR VGND sg13cmos5l_decap_8
XFILLER_27_520 VPWR VGND sg13cmos5l_fill_2
XFILLER_27_586 VPWR VGND sg13cmos5l_decap_8
XFILLER_11_910 VPWR VGND sg13cmos5l_fill_1
Xfanout40 _3438_/B _3433_/B VPWR VGND sg13cmos5l_buf_1
Xfanout62 _3617_/A _4251_/Q VPWR VGND sg13cmos5l_buf_1
Xfanout51 _3215_/B _3095_/Y VPWR VGND sg13cmos5l_buf_1
XFILLER_23_792 VPWR VGND sg13cmos5l_decap_4
Xfanout73 _2680_/A1 _2644_/A VPWR VGND sg13cmos5l_buf_1
XFILLER_11_976 VPWR VGND sg13cmos5l_decap_8
Xfanout84 fanout84/X _4014_/Q VPWR VGND sg13cmos5l_buf_1
Xfanout95 _2639_/A _2673_/A VPWR VGND sg13cmos5l_buf_1
XFILLER_7_958 VPWR VGND sg13cmos5l_decap_8
XFILLER_6_413 VPWR VGND sg13cmos5l_decap_8
X_4240__270 _4240_/RESET_B VPWR VGND sg13cmos5l_tiehi
XFILLER_49_100 VPWR VGND sg13cmos5l_fill_1
XFILLER_2_696 VPWR VGND sg13cmos5l_fill_1
XFILLER_49_155 VPWR VGND sg13cmos5l_decap_4
XFILLER_49_144 VPWR VGND sg13cmos5l_fill_1
XFILLER_49_133 VPWR VGND sg13cmos5l_decap_8
XFILLER_46_884 VPWR VGND sg13cmos5l_decap_8
XFILLER_45_350 VPWR VGND sg13cmos5l_decap_4
XFILLER_33_534 VPWR VGND sg13cmos5l_fill_2
X_3800_ _3801_/B _3800_/A _3800_/B VPWR VGND sg13cmos5l_nand2_1
X_3731_ _3794_/B _3805_/B _3731_/B VPWR VGND sg13cmos5l_nor2_1
XFILLER_9_251 VPWR VGND sg13cmos5l_decap_4
X_3662_ _3805_/A _3645_/B _3647_/Y _3644_/Y VPWR VGND sg13cmos5l_a21oi_1
XFILLER_9_273 VPWR VGND sg13cmos5l_decap_8
Xclkload10 clkload10/Y _4280_/CLK VPWR VGND sg13cmos5l_inv_2
X_3593_ _3593_/Y _3588_/Y _3590_/Y _3592_/Y _3594_/A _3570_/Y VPWR VGND sg13cmos5l_a221oi_1
X_2613_ _2692_/B _2560_/Y _2579_/Y _2595_/Y _2612_/Y VPWR VGND sg13cmos5l_a22oi_1
X_2544_ _2544_/Y _2688_/B _2506_/B VPWR VGND sg13cmos5l_nor2b_1
XFILLER_48_0 VPWR VGND sg13cmos5l_decap_8
X_2475_ _2476_/B _2519_/A _2475_/B VPWR VGND sg13cmos5l_nand2_1
X_4214_ _4214_/Q _4237_/CLK _4214_/D _4214_/RESET_B VPWR VGND sg13cmos5l_dfrbpq_1
X_4145_ _4145_/Q _4173_/CLK _4145_/D _4145_/RESET_B VPWR VGND sg13cmos5l_dfrbpq_1
X_4076_ _4076_/Q _4129_/CLK _4076_/D _4076_/RESET_B VPWR VGND sg13cmos5l_dfrbpq_1
XFILLER_43_309 VPWR VGND sg13cmos5l_fill_2
XFILLER_37_895 VPWR VGND sg13cmos5l_fill_1
X_3937__354 _3937_/RESET_B VPWR VGND sg13cmos5l_tiehi
X_3027_ _3027_/Y _3018_/Y _3025_/Y _3026_/Y VPWR VGND sg13cmos5l_a21oi_1
Xclkload4 clkload4/Y clkload4/A VPWR VGND sg13cmos5l_inv_1
X_3929_ _3929_/Q clkload9/A _3929_/D _3929_/RESET_B VPWR VGND sg13cmos5l_dfrbpq_1
XFILLER_4_917 VPWR VGND sg13cmos5l_decap_8
XFILLER_3_405 VPWR VGND sg13cmos5l_fill_1
X_3944__347 _3944_/RESET_B VPWR VGND sg13cmos5l_tiehi
XFILLER_47_604 VPWR VGND sg13cmos5l_decap_8
XFILLER_47_615 VPWR VGND sg13cmos5l_fill_1
X_3990__301 _3990_/RESET_B VPWR VGND sg13cmos5l_tiehi
XFILLER_27_350 VPWR VGND sg13cmos5l_fill_2
XFILLER_43_898 VPWR VGND sg13cmos5l_decap_8
XFILLER_11_773 VPWR VGND sg13cmos5l_decap_8
XFILLER_7_777 VPWR VGND sg13cmos5l_decap_8
XFILLER_7_788 VPWR VGND sg13cmos5l_fill_2
XFILLER_6_287 VPWR VGND sg13cmos5l_fill_2
XFILLER_6_276 VPWR VGND sg13cmos5l_decap_8
XFILLER_3_972 VPWR VGND sg13cmos5l_decap_8
XFILLER_2_482 VPWR VGND sg13cmos5l_decap_4
X_2260_ _2273_/B _2260_/A _2260_/B VPWR VGND sg13cmos5l_nor2_1
XFILLER_38_604 VPWR VGND sg13cmos5l_fill_1
X_2191_ _2191_/Y _2693_/A VPWR VGND sg13cmos5l_inv_1
XFILLER_37_169 VPWR VGND sg13cmos5l_decap_4
XFILLER_19_873 VPWR VGND sg13cmos5l_decap_8
XFILLER_19_884 VPWR VGND sg13cmos5l_fill_2
X_3714_ _4258_/D _3714_/A _3715_/B VPWR VGND sg13cmos5l_nor2_1
X_3645_ _3646_/B _3645_/A _3645_/B VPWR VGND sg13cmos5l_nand2_1
XFILLER_20_18 VPWR VGND sg13cmos5l_fill_2
XFILLER_20_29 VPWR VGND sg13cmos5l_decap_8
X_3576_ _3576_/Y _3576_/A _3591_/B VPWR VGND sg13cmos5l_nand2_1
X_2527_ _2727_/A _2761_/A _2775_/A VPWR VGND sg13cmos5l_nand2b_1
X_2458_ _2458_/Y _2458_/A _2458_/B VPWR VGND sg13cmos5l_xnor2_1
XFILLER_29_16 VPWR VGND sg13cmos5l_fill_1
X_2389_ _3984_/D hold715/X _2418_/A0 _2391_/S VPWR VGND sg13cmos5l_mux2_1
XFILLER_21_1008 VPWR VGND sg13cmos5l_decap_8
X_4128_ _4128_/Q _4227_/CLK _4128_/D _4128_/RESET_B VPWR VGND sg13cmos5l_dfrbpq_1
X_4059_ _4059_/Q clkload8/A _4059_/D _4059_/RESET_B VPWR VGND sg13cmos5l_dfrbpq_1
XFILLER_40_802 VPWR VGND sg13cmos5l_fill_2
XFILLER_24_331 VPWR VGND sg13cmos5l_decap_4
XFILLER_40_824 VPWR VGND sg13cmos5l_fill_1
XFILLER_4_736 VPWR VGND sg13cmos5l_decap_8
XFILLER_48_902 VPWR VGND sg13cmos5l_decap_8
XFILLER_0_942 VPWR VGND sg13cmos5l_decap_8
XFILLER_47_401 VPWR VGND sg13cmos5l_decap_8
XFILLER_48_979 VPWR VGND sg13cmos5l_decap_8
XFILLER_47_456 VPWR VGND sg13cmos5l_decap_8
XFILLER_27_180 VPWR VGND sg13cmos5l_decap_8
XFILLER_28_681 VPWR VGND sg13cmos5l_fill_1
XFILLER_34_139 VPWR VGND sg13cmos5l_decap_8
XFILLER_37_1015 VPWR VGND sg13cmos5l_decap_8
XFILLER_16_854 VPWR VGND sg13cmos5l_decap_8
XFILLER_31_835 VPWR VGND sg13cmos5l_decap_8
XFILLER_42_194 VPWR VGND sg13cmos5l_fill_1
XFILLER_15_397 VPWR VGND sg13cmos5l_decap_8
XFILLER_30_378 VPWR VGND sg13cmos5l_decap_8
X_3430_ _3430_/Y _3420_/Y _3430_/B VPWR VGND sg13cmos5l_nand2b_1
X_3361_ _3361_/Y _3353_/B _3359_/Y _3360_/Y _3355_/C VPWR VGND sg13cmos5l_a22oi_1
X_3927__364 _3927_/RESET_B VPWR VGND sg13cmos5l_tiehi
X_2312_ _2318_/S _3855_/C _3855_/D _2312_/C VPWR VGND sg13cmos5l_nand3_1
X_3292_ _3313_/A _3292_/A _3309_/B VPWR VGND sg13cmos5l_and2_1
Xheichips26_dna_sequencer_135 uio_oe[2] VPWR VGND sg13cmos5l_tielo
X_2243_ _3032_/A _4126_/Q VPWR VGND sg13cmos5l_inv_1
XFILLER_39_979 VPWR VGND sg13cmos5l_decap_8
XFILLER_38_423 VPWR VGND sg13cmos5l_decap_4
X_2174_ _3673_/B _2174_/A VPWR VGND sg13cmos5l_inv_1
Xheichips26_dna_sequencer_146 uio_out[5] VPWR VGND sg13cmos5l_tielo
XFILLER_38_467 VPWR VGND sg13cmos5l_decap_8
X_3934__357 _3934_/RESET_B VPWR VGND sg13cmos5l_tiehi
XFILLER_21_356 VPWR VGND sg13cmos5l_decap_4
XFILLER_21_378 VPWR VGND sg13cmos5l_decap_8
XFILLER_21_389 VPWR VGND sg13cmos5l_fill_1
XFILLER_30_890 VPWR VGND sg13cmos5l_decap_8
X_3628_ _3628_/Y _3619_/X _3623_/A _3627_/Y VPWR VGND sg13cmos5l_o21ai_1
X_3980__311 _3980_/RESET_B VPWR VGND sg13cmos5l_tiehi
Xoutput17 uo_out[3] _4019_/Q VPWR VGND sg13cmos5l_buf_1
X_3559_ _4231_/D _3559_/A _3561_/B VPWR VGND sg13cmos5l_nor2_1
XFILLER_5_1002 VPWR VGND sg13cmos5l_decap_8
XFILLER_29_423 VPWR VGND sg13cmos5l_fill_1
XFILLER_16_106 VPWR VGND sg13cmos5l_fill_2
XFILLER_40_676 VPWR VGND sg13cmos5l_decap_8
X_4265__151 _4265_/D VPWR VGND sg13cmos5l_tielo
XFILLER_9_828 VPWR VGND sg13cmos5l_fill_1
XFILLER_12_378 VPWR VGND sg13cmos5l_decap_8
XFILLER_12_389 VPWR VGND sg13cmos5l_fill_1
XFILLER_21_61 VPWR VGND sg13cmos5l_decap_4
XFILLER_4_588 VPWR VGND sg13cmos5l_fill_1
XFILLER_48_776 VPWR VGND sg13cmos5l_decap_8
XFILLER_46_91 VPWR VGND sg13cmos5l_fill_1
XFILLER_44_960 VPWR VGND sg13cmos5l_decap_8
XFILLER_16_695 VPWR VGND sg13cmos5l_decap_8
XFILLER_31_610 VPWR VGND sg13cmos5l_fill_1
X_2930_ _2931_/B _4139_/Q _4140_/Q _4141_/Q VPWR VGND sg13cmos5l_nor3_1
X_2861_ _2861_/Y _2748_/A _2748_/B _2995_/B VPWR VGND sg13cmos5l_a21oi_1
XFILLER_30_142 VPWR VGND sg13cmos5l_fill_2
X_2792_ _2792_/Y _3034_/B _2792_/B VPWR VGND sg13cmos5l_nand2b_1
XFILLER_11_1018 VPWR VGND sg13cmos5l_decap_8
XFILLER_8_894 VPWR VGND sg13cmos5l_decap_8
XFILLER_7_393 VPWR VGND sg13cmos5l_decap_4
X_3413_ _3434_/A _4199_/Q _3438_/B _3427_/A VPWR VGND sg13cmos5l_a21o_1
X_3344_ _3428_/A _3124_/X _3333_/Y _3343_/Y VPWR VGND sg13cmos5l_a21oi_1
XFILLER_30_0 VPWR VGND sg13cmos5l_fill_2
X_3275_ _3289_/B _4176_/Q _4175_/Q _4177_/Q VPWR VGND sg13cmos5l_o21ai_1
Xhold1005 _3468_/A _4208_/Q VPWR VGND sg13cmos5l_dlygate4sd3_1
XFILLER_39_754 VPWR VGND sg13cmos5l_decap_8
X_2226_ _2226_/Y _2226_/A VPWR VGND sg13cmos5l_inv_1
Xhold1016 hold1016/X _4274_/Q VPWR VGND sg13cmos5l_dlygate4sd3_1
XFILLER_42_919 VPWR VGND sg13cmos5l_decap_8
XFILLER_22_621 VPWR VGND sg13cmos5l_fill_2
XFILLER_42_49 VPWR VGND sg13cmos5l_fill_1
XFILLER_42_38 VPWR VGND sg13cmos5l_decap_8
XFILLER_42_27 VPWR VGND sg13cmos5l_fill_1
X_4227__400 _4227_/RESET_B VPWR VGND sg13cmos5l_tiehi
XFILLER_22_687 VPWR VGND sg13cmos5l_fill_1
X_4184__160 _4184_/D VPWR VGND sg13cmos5l_tielo
Xhold850 _4254_/D _3710_/Y VPWR VGND sg13cmos5l_dlygate4sd3_1
Xhold861 hold861/X _4153_/Q VPWR VGND sg13cmos5l_dlygate4sd3_1
Xhold872 hold872/X _3032_/Y VPWR VGND sg13cmos5l_dlygate4sd3_1
Xhold894 hold894/X _2737_/A VPWR VGND sg13cmos5l_dlygate4sd3_1
Xhold883 _3545_/B _4220_/Q VPWR VGND sg13cmos5l_dlygate4sd3_1
XFILLER_49_518 VPWR VGND sg13cmos5l_decap_8
XFILLER_17_404 VPWR VGND sg13cmos5l_decap_8
XFILLER_18_905 VPWR VGND sg13cmos5l_decap_8
XFILLER_17_437 VPWR VGND sg13cmos5l_decap_8
XFILLER_18_938 VPWR VGND sg13cmos5l_decap_4
X_3917__374 _3917_/RESET_B VPWR VGND sg13cmos5l_tiehi
XFILLER_16_61 VPWR VGND sg13cmos5l_decap_8
XFILLER_13_632 VPWR VGND sg13cmos5l_decap_8
XFILLER_25_492 VPWR VGND sg13cmos5l_fill_2
XFILLER_41_985 VPWR VGND sg13cmos5l_decap_8
XFILLER_9_614 VPWR VGND sg13cmos5l_decap_8
XFILLER_12_153 VPWR VGND sg13cmos5l_fill_2
XFILLER_34_1018 VPWR VGND sg13cmos5l_decap_8
XFILLER_8_113 VPWR VGND sg13cmos5l_fill_1
XFILLER_12_164 VPWR VGND sg13cmos5l_fill_1
XFILLER_8_179 VPWR VGND sg13cmos5l_fill_1
X_3924__367 _3924_/RESET_B VPWR VGND sg13cmos5l_tiehi
X_3060_ _3077_/C _4130_/Q _4103_/Q _4135_/Q VPWR VGND sg13cmos5l_nand3_1
XFILLER_36_702 VPWR VGND sg13cmos5l_fill_2
XFILLER_35_201 VPWR VGND sg13cmos5l_decap_8
XFILLER_35_212 VPWR VGND sg13cmos5l_fill_1
XFILLER_36_724 VPWR VGND sg13cmos5l_decap_8
XFILLER_17_960 VPWR VGND sg13cmos5l_decap_8
XFILLER_35_234 VPWR VGND sg13cmos5l_decap_4
XFILLER_36_779 VPWR VGND sg13cmos5l_fill_2
X_3970__321 _3970_/RESET_B VPWR VGND sg13cmos5l_tiehi
XFILLER_32_952 VPWR VGND sg13cmos5l_decap_8
X_3962_ _3962_/Q _4031_/CLK _3962_/D _3962_/RESET_B VPWR VGND sg13cmos5l_dfrbpq_1
X_2913_ _2918_/A _2917_/A _2913_/B VPWR VGND sg13cmos5l_or2_1
X_3893_ _3893_/Q _4027_/CLK _3893_/D _3893_/RESET_B VPWR VGND sg13cmos5l_dfrbpq_1
X_2844_ _4090_/D _2885_/B _2889_/B VPWR VGND sg13cmos5l_nor2_1
X_2775_ _2776_/B _2775_/A _2775_/B _2775_/C _2775_/D VPWR VGND sg13cmos5l_nand4_1
X_3327_ _3327_/Y _3115_/A _3317_/X _3343_/A _3124_/A VPWR VGND sg13cmos5l_a22oi_1
X_3258_ _3258_/Y _3258_/A _3258_/B VPWR VGND sg13cmos5l_nor2_1
X_4216__156 _4216_/D VPWR VGND sg13cmos5l_tielo
X_2209_ _3561_/A _3360_/A VPWR VGND sg13cmos5l_inv_1
X_3189_ _3189_/Y _4154_/Q _3187_/Y _3184_/Y VPWR VGND sg13cmos5l_o21ai_1
XFILLER_26_212 VPWR VGND sg13cmos5l_decap_4
XFILLER_41_226 VPWR VGND sg13cmos5l_decap_8
X_4268__544 _4268_/RESET_B VPWR VGND sg13cmos5l_tiehi
XFILLER_22_451 VPWR VGND sg13cmos5l_fill_1
XFILLER_23_985 VPWR VGND sg13cmos5l_decap_8
XFILLER_10_613 VPWR VGND sg13cmos5l_fill_1
XFILLER_22_495 VPWR VGND sg13cmos5l_fill_2
Xhold680 hold680/X _3900_/Q VPWR VGND sg13cmos5l_dlygate4sd3_1
XFILLER_2_856 VPWR VGND sg13cmos5l_decap_8
XFILLER_49_315 VPWR VGND sg13cmos5l_decap_8
XFILLER_49_304 VPWR VGND sg13cmos5l_fill_2
Xhold691 hold691/X _3918_/Q VPWR VGND sg13cmos5l_dlygate4sd3_1
XFILLER_49_348 VPWR VGND sg13cmos5l_decap_8
XFILLER_49_326 VPWR VGND sg13cmos5l_fill_1
XFILLER_49_359 VPWR VGND sg13cmos5l_decap_8
XFILLER_45_543 VPWR VGND sg13cmos5l_fill_1
XFILLER_17_278 VPWR VGND sg13cmos5l_decap_8
Xclkbuf_2_0__f_clk clkbuf_leaf_4_clk/A clkbuf_0_clk/X VPWR VGND sg13cmos5l_buf_8
XFILLER_17_289 VPWR VGND sg13cmos5l_fill_1
XFILLER_41_760 VPWR VGND sg13cmos5l_decap_8
XFILLER_14_974 VPWR VGND sg13cmos5l_decap_8
X_2560_ _2560_/Y _2422_/B _2551_/Y _2559_/Y VPWR VGND sg13cmos5l_o21ai_1
X_2491_ _2491_/Y _2441_/B _2491_/B VPWR VGND sg13cmos5l_nand2b_1
X_4230_ _4230_/Q _4259_/CLK _4230_/D _4230_/RESET_B VPWR VGND sg13cmos5l_dfrbpq_1
X_4059__200 _4059_/RESET_B VPWR VGND sg13cmos5l_tiehi
X_4161_ _4161_/Q _4193_/CLK _4161_/D _4161_/RESET_B VPWR VGND sg13cmos5l_dfrbpq_1
X_4092_ _4092_/Q _4137_/CLK _4092_/D _4092_/RESET_B VPWR VGND sg13cmos5l_dfrbpq_1
X_3112_ _3112_/X _4146_/Q _3112_/B VPWR VGND sg13cmos5l_xor2_1
X_3043_ _4133_/D _3555_/A _3043_/B VPWR VGND sg13cmos5l_and2_1
XFILLER_24_727 VPWR VGND sg13cmos5l_decap_8
XFILLER_36_576 VPWR VGND sg13cmos5l_decap_4
XFILLER_36_587 VPWR VGND sg13cmos5l_decap_4
XFILLER_17_1002 VPWR VGND sg13cmos5l_decap_8
XFILLER_32_760 VPWR VGND sg13cmos5l_decap_8
X_3945_ _3945_/Q _4031_/CLK _3945_/D _3945_/RESET_B VPWR VGND sg13cmos5l_dfrbpq_1
XFILLER_20_933 VPWR VGND sg13cmos5l_fill_1
X_3876_ _4028_/D _2198_/Y _2430_/B _2432_/Y VPWR VGND sg13cmos5l_a21oi_1
XFILLER_31_292 VPWR VGND sg13cmos5l_fill_2
X_2827_ _2845_/A _2833_/B _2826_/Y VPWR VGND sg13cmos5l_nor2b_1
XFILLER_20_999 VPWR VGND sg13cmos5l_decap_8
XFILLER_3_609 VPWR VGND sg13cmos5l_decap_8
X_2758_ _4076_/D _2792_/B _2758_/B VPWR VGND sg13cmos5l_and2_1
XFILLER_2_108 VPWR VGND sg13cmos5l_fill_1
X_2689_ _4055_/D _2691_/B VPWR VGND sg13cmos5l_inv_1
X_3907__384 _3907_/RESET_B VPWR VGND sg13cmos5l_tiehi
XFILLER_24_1017 VPWR VGND sg13cmos5l_decap_8
XFILLER_47_819 VPWR VGND sg13cmos5l_decap_8
XFILLER_24_1028 VPWR VGND sg13cmos5l_fill_1
Xfanout30 _2401_/S _2400_/S VPWR VGND sg13cmos5l_buf_1
X_3914__377 _3914_/RESET_B VPWR VGND sg13cmos5l_tiehi
Xfanout63 _3531_/A hold999/X VPWR VGND sg13cmos5l_buf_1
Xfanout74 _2644_/A _4015_/Q VPWR VGND sg13cmos5l_buf_1
Xfanout52 _3169_/A _3095_/Y VPWR VGND sg13cmos5l_buf_1
Xfanout41 _3246_/B _3260_/B VPWR VGND sg13cmos5l_buf_1
Xfanout96 _2603_/A _2673_/A VPWR VGND sg13cmos5l_buf_1
XFILLER_7_904 VPWR VGND sg13cmos5l_fill_1
Xfanout85 _2563_/A fanout99/X VPWR VGND sg13cmos5l_buf_1
XFILLER_7_937 VPWR VGND sg13cmos5l_decap_8
XFILLER_10_465 VPWR VGND sg13cmos5l_decap_8
X_3960__331 _3960_/RESET_B VPWR VGND sg13cmos5l_tiehi
XFILLER_2_653 VPWR VGND sg13cmos5l_decap_8
XFILLER_38_819 VPWR VGND sg13cmos5l_decap_8
XFILLER_1_196 VPWR VGND sg13cmos5l_decap_4
XFILLER_49_178 VPWR VGND sg13cmos5l_decap_4
XFILLER_37_329 VPWR VGND sg13cmos5l_decap_8
XFILLER_38_92 VPWR VGND sg13cmos5l_decap_8
XFILLER_18_521 VPWR VGND sg13cmos5l_fill_2
XFILLER_46_863 VPWR VGND sg13cmos5l_decap_8
XFILLER_33_513 VPWR VGND sg13cmos5l_decap_8
XFILLER_18_598 VPWR VGND sg13cmos5l_decap_4
XFILLER_33_579 VPWR VGND sg13cmos5l_fill_1
X_3730_ _3731_/B _4259_/Q _3733_/B _3728_/Y _3800_/B VPWR VGND sg13cmos5l_a22oi_1
XFILLER_14_782 VPWR VGND sg13cmos5l_decap_8
XFILLER_14_793 VPWR VGND sg13cmos5l_decap_4
X_3661_ _4242_/D _3715_/B _3798_/A VPWR VGND sg13cmos5l_nor2_1
X_2612_ _2612_/Y _4041_/Q _2612_/B _2612_/C VPWR VGND sg13cmos5l_nor3_1
X_3592_ _3592_/Y _3595_/B _3592_/B VPWR VGND sg13cmos5l_nor2_1
Xclkload11 clkload11/Y _4227_/CLK VPWR VGND sg13cmos5l_inv_1
X_2543_ _4049_/D _2688_/A _2543_/B VPWR VGND sg13cmos5l_and2_1
X_2474_ _2475_/B _3846_/B _2474_/B _2474_/C VPWR VGND sg13cmos5l_nand3_1
X_4213_ _4213_/Q _4237_/CLK _4213_/D _4213_/RESET_B VPWR VGND sg13cmos5l_dfrbpq_1
X_4144_ _4144_/Q _4173_/CLK _4144_/D _4144_/RESET_B VPWR VGND sg13cmos5l_dfrbpq_1
XFILLER_37_852 VPWR VGND sg13cmos5l_decap_8
X_4075_ _4075_/Q _4129_/CLK _4075_/D _4075_/RESET_B VPWR VGND sg13cmos5l_dfrbpq_1
X_3026_ _3026_/Y _2245_/A _3025_/Y _3000_/A VPWR VGND sg13cmos5l_o21ai_1
XFILLER_36_351 VPWR VGND sg13cmos5l_decap_8
XFILLER_24_513 VPWR VGND sg13cmos5l_decap_8
XFILLER_36_373 VPWR VGND sg13cmos5l_fill_2
X_3928_ _3928_/Q clkload7/A _3928_/D _3928_/RESET_B VPWR VGND sg13cmos5l_dfrbpq_1
Xclkload5 clkload5/Y clkload5/A VPWR VGND sg13cmos5l_inv_2
X_3859_ _3888_/D _3859_/A0 hold812/X _3864_/S VPWR VGND sg13cmos5l_mux2_1
XFILLER_3_428 VPWR VGND sg13cmos5l_decap_4
XFILLER_1_7 VPWR VGND sg13cmos5l_decap_8
XFILLER_8_1011 VPWR VGND sg13cmos5l_decap_8
XFILLER_19_318 VPWR VGND sg13cmos5l_decap_8
XFILLER_46_148 VPWR VGND sg13cmos5l_fill_2
XFILLER_46_137 VPWR VGND sg13cmos5l_decap_8
XFILLER_28_885 VPWR VGND sg13cmos5l_fill_2
XFILLER_43_822 VPWR VGND sg13cmos5l_decap_8
XFILLER_43_877 VPWR VGND sg13cmos5l_decap_8
XFILLER_30_516 VPWR VGND sg13cmos5l_decap_4
XFILLER_30_549 VPWR VGND sg13cmos5l_decap_4
XFILLER_7_723 VPWR VGND sg13cmos5l_decap_8
XFILLER_7_756 VPWR VGND sg13cmos5l_decap_8
XFILLER_6_233 VPWR VGND sg13cmos5l_fill_1
XFILLER_3_951 VPWR VGND sg13cmos5l_decap_8
X_4138__503 _4138_/RESET_B VPWR VGND sg13cmos5l_tiehi
X_2190_ _2190_/Y _2190_/A VPWR VGND sg13cmos5l_inv_1
X_4056__203 _4056_/RESET_B VPWR VGND sg13cmos5l_tiehi
XFILLER_1_32 VPWR VGND sg13cmos5l_fill_1
XFILLER_18_340 VPWR VGND sg13cmos5l_fill_1
XFILLER_46_693 VPWR VGND sg13cmos5l_fill_1
XFILLER_21_527 VPWR VGND sg13cmos5l_decap_8
XFILLER_34_888 VPWR VGND sg13cmos5l_decap_8
XFILLER_34_899 VPWR VGND sg13cmos5l_fill_1
X_3713_ _4257_/D _3713_/A _3815_/A VPWR VGND sg13cmos5l_nor2_1
XFILLER_14_1016 VPWR VGND sg13cmos5l_decap_8
XFILLER_14_1027 VPWR VGND sg13cmos5l_fill_2
X_3644_ _3644_/Y _3645_/A _3658_/B VPWR VGND sg13cmos5l_nor2b_1
X_3575_ _3575_/Y _4233_/Q _3591_/B VPWR VGND sg13cmos5l_nor2_1
X_2526_ _2528_/A _2526_/A _2526_/B VPWR VGND sg13cmos5l_and2_1
X_2457_ _2463_/B _4022_/Q _2458_/B VPWR VGND sg13cmos5l_and2_1
X_2388_ _3983_/D hold722/X _2417_/A0 _2391_/S VPWR VGND sg13cmos5l_mux2_1
X_3904__387 _3904_/RESET_B VPWR VGND sg13cmos5l_tiehi
X_4254__226 _4254_/RESET_B VPWR VGND sg13cmos5l_tiehi
X_4127_ _4127_/Q _4227_/CLK _4127_/D _4127_/RESET_B VPWR VGND sg13cmos5l_dfrbpq_1
X_4058_ _4058_/Q clkload9/A _4058_/D _4058_/RESET_B VPWR VGND sg13cmos5l_dfrbpq_1
XFILLER_24_310 VPWR VGND sg13cmos5l_decap_8
X_3009_ _3009_/Y _3217_/A _3016_/C _3009_/C VPWR VGND sg13cmos5l_nand3b_1
X_3950__341 _3950_/RESET_B VPWR VGND sg13cmos5l_tiehi
XFILLER_24_376 VPWR VGND sg13cmos5l_fill_1
XFILLER_25_899 VPWR VGND sg13cmos5l_decap_4
XFILLER_40_858 VPWR VGND sg13cmos5l_decap_8
XFILLER_4_715 VPWR VGND sg13cmos5l_decap_8
X_3881__413 _3881_/RESET_B VPWR VGND sg13cmos5l_tiehi
XFILLER_3_214 VPWR VGND sg13cmos5l_decap_4
XFILLER_3_269 VPWR VGND sg13cmos5l_decap_8
X_4009__282 _4009_/RESET_B VPWR VGND sg13cmos5l_tiehi
XFILLER_0_921 VPWR VGND sg13cmos5l_decap_8
XFILLER_0_998 VPWR VGND sg13cmos5l_decap_8
XFILLER_48_958 VPWR VGND sg13cmos5l_decap_8
XFILLER_16_800 VPWR VGND sg13cmos5l_decap_8
XFILLER_19_148 VPWR VGND sg13cmos5l_decap_8
XFILLER_16_822 VPWR VGND sg13cmos5l_decap_8
X_4016__275 _4016_/RESET_B VPWR VGND sg13cmos5l_tiehi
XFILLER_31_803 VPWR VGND sg13cmos5l_decap_8
XFILLER_43_696 VPWR VGND sg13cmos5l_decap_8
XFILLER_15_387 VPWR VGND sg13cmos5l_fill_2
XFILLER_35_93 VPWR VGND sg13cmos5l_decap_8
X_3360_ _3360_/Y _3360_/A _3558_/A VPWR VGND sg13cmos5l_nor2b_1
X_2311_ _3918_/D hold691/X _3854_/A1 _2311_/S VPWR VGND sg13cmos5l_mux2_1
XFILLER_44_1009 VPWR VGND sg13cmos5l_decap_8
X_3291_ _3309_/B _4206_/Q _3291_/B VPWR VGND sg13cmos5l_xnor2_1
XFILLER_38_402 VPWR VGND sg13cmos5l_fill_1
X_2242_ _3362_/B _4153_/Q VPWR VGND sg13cmos5l_inv_1
Xheichips26_dna_sequencer_136 uio_oe[3] VPWR VGND sg13cmos5l_tielo
XFILLER_39_958 VPWR VGND sg13cmos5l_decap_8
XFILLER_38_446 VPWR VGND sg13cmos5l_fill_2
X_2173_ _3681_/B _4219_/Q VPWR VGND sg13cmos5l_inv_1
Xheichips26_dna_sequencer_147 uio_out[6] VPWR VGND sg13cmos5l_tielo
XFILLER_38_479 VPWR VGND sg13cmos5l_decap_8
XFILLER_20_1020 VPWR VGND sg13cmos5l_decap_8
XFILLER_47_980 VPWR VGND sg13cmos5l_decap_8
XFILLER_18_170 VPWR VGND sg13cmos5l_decap_8
XFILLER_15_19 VPWR VGND sg13cmos5l_fill_2
XFILLER_18_192 VPWR VGND sg13cmos5l_decap_8
XFILLER_21_302 VPWR VGND sg13cmos5l_fill_2
XFILLER_22_869 VPWR VGND sg13cmos5l_fill_2
XFILLER_33_195 VPWR VGND sg13cmos5l_decap_8
X_3627_ _3627_/Y _3674_/A _3625_/X _3626_/Y _3624_/X VPWR VGND sg13cmos5l_a22oi_1
Xoutput18 uo_out[4] _4020_/Q VPWR VGND sg13cmos5l_buf_1
X_3558_ _4230_/D _3558_/A _3560_/B VPWR VGND sg13cmos5l_and2_1
XFILLER_0_217 VPWR VGND sg13cmos5l_fill_1
XFILLER_1_729 VPWR VGND sg13cmos5l_decap_8
X_2509_ _2511_/C _2509_/A _2509_/B VPWR VGND sg13cmos5l_nand2_1
X_3489_ _3490_/B _4183_/Q _3500_/B VPWR VGND sg13cmos5l_nor2_1
XFILLER_29_468 VPWR VGND sg13cmos5l_fill_1
XFILLER_38_991 VPWR VGND sg13cmos5l_decap_8
XFILLER_25_663 VPWR VGND sg13cmos5l_decap_8
XFILLER_25_685 VPWR VGND sg13cmos5l_decap_8
XFILLER_9_807 VPWR VGND sg13cmos5l_fill_2
XFILLER_12_324 VPWR VGND sg13cmos5l_fill_2
XFILLER_8_306 VPWR VGND sg13cmos5l_fill_1
XFILLER_40_699 VPWR VGND sg13cmos5l_fill_1
XFILLER_48_755 VPWR VGND sg13cmos5l_decap_8
XFILLER_0_795 VPWR VGND sg13cmos5l_decap_8
X_4135__506 _4135_/RESET_B VPWR VGND sg13cmos5l_tiehi
X_4053__206 _4053_/RESET_B VPWR VGND sg13cmos5l_tiehi
XFILLER_35_438 VPWR VGND sg13cmos5l_decap_8
XFILLER_16_663 VPWR VGND sg13cmos5l_decap_8
XFILLER_16_674 VPWR VGND sg13cmos5l_decap_8
XFILLER_16_685 VPWR VGND sg13cmos5l_fill_2
X_2860_ _2860_/Y _2860_/A _2860_/B VPWR VGND sg13cmos5l_nand2_1
XFILLER_31_666 VPWR VGND sg13cmos5l_decap_8
X_2791_ _2884_/B _4272_/D _3034_/B VPWR VGND sg13cmos5l_nor2_1
XFILLER_8_873 VPWR VGND sg13cmos5l_fill_1
XFILLER_8_851 VPWR VGND sg13cmos5l_fill_1
XFILLER_7_361 VPWR VGND sg13cmos5l_decap_8
XFILLER_7_75 VPWR VGND sg13cmos5l_fill_2
X_3412_ _3427_/A _3426_/A _3426_/B _3426_/C VPWR VGND sg13cmos5l_a21oi_1
X_3343_ _3343_/Y _3343_/A _3343_/B _3343_/C VPWR VGND sg13cmos5l_nor3_1
X_3274_ _3289_/A _4177_/Q _4176_/Q _4175_/Q VPWR VGND sg13cmos5l_or3_1
Xhold1006 _3318_/A _4151_/Q VPWR VGND sg13cmos5l_dlygate4sd3_1
X_3940__351 _3940_/RESET_B VPWR VGND sg13cmos5l_tiehi
XFILLER_39_722 VPWR VGND sg13cmos5l_fill_1
XFILLER_38_221 VPWR VGND sg13cmos5l_fill_2
Xhold1017 _2222_/A _4180_/Q VPWR VGND sg13cmos5l_dlygate4sd3_1
X_2225_ _2225_/Y _2644_/A VPWR VGND sg13cmos5l_inv_1
XFILLER_39_799 VPWR VGND sg13cmos5l_fill_1
XFILLER_26_18 VPWR VGND sg13cmos5l_decap_8
XFILLER_26_438 VPWR VGND sg13cmos5l_fill_1
Xclkbuf_leaf_18_clk _4205_/CLK clkbuf_leaf_3_clk/A VPWR VGND sg13cmos5l_buf_8
XFILLER_41_408 VPWR VGND sg13cmos5l_decap_8
XFILLER_22_611 VPWR VGND sg13cmos5l_fill_1
XFILLER_21_110 VPWR VGND sg13cmos5l_fill_2
XFILLER_22_633 VPWR VGND sg13cmos5l_fill_1
X_2989_ _2991_/A _2989_/A _2989_/B VPWR VGND sg13cmos5l_nor2_1
XFILLER_10_828 VPWR VGND sg13cmos5l_decap_8
XFILLER_21_176 VPWR VGND sg13cmos5l_fill_2
Xhold840 _4067_/D _2745_/Y VPWR VGND sg13cmos5l_dlygate4sd3_1
Xhold851 hold851/X _4034_/Q VPWR VGND sg13cmos5l_dlygate4sd3_1
Xhold862 _4153_/D _3196_/Y VPWR VGND sg13cmos5l_dlygate4sd3_1
Xhold873 _3213_/A _4138_/Q VPWR VGND sg13cmos5l_dlygate4sd3_1
Xhold884 hold884/X _3545_/Y VPWR VGND sg13cmos5l_dlygate4sd3_1
Xhold895 _3360_/A _4206_/Q VPWR VGND sg13cmos5l_dlygate4sd3_1
X_4006__285 _4006_/RESET_B VPWR VGND sg13cmos5l_tiehi
XFILLER_27_1015 VPWR VGND sg13cmos5l_decap_8
XFILLER_45_714 VPWR VGND sg13cmos5l_decap_8
XFILLER_45_758 VPWR VGND sg13cmos5l_decap_8
XFILLER_26_994 VPWR VGND sg13cmos5l_decap_8
XFILLER_41_964 VPWR VGND sg13cmos5l_decap_8
X_4013__278 _4013_/RESET_B VPWR VGND sg13cmos5l_tiehi
XFILLER_12_132 VPWR VGND sg13cmos5l_decap_8
XFILLER_8_158 VPWR VGND sg13cmos5l_decap_8
XFILLER_5_810 VPWR VGND sg13cmos5l_decap_4
XFILLER_5_843 VPWR VGND sg13cmos5l_fill_2
XFILLER_4_342 VPWR VGND sg13cmos5l_decap_8
XFILLER_5_876 VPWR VGND sg13cmos5l_fill_1
XFILLER_4_364 VPWR VGND sg13cmos5l_decap_8
XFILLER_4_353 VPWR VGND sg13cmos5l_fill_1
XFILLER_36_714 VPWR VGND sg13cmos5l_fill_1
X_4250__240 _4250_/RESET_B VPWR VGND sg13cmos5l_tiehi
X_3961_ _3961_/Q _4011_/CLK _3961_/D _3961_/RESET_B VPWR VGND sg13cmos5l_dfrbpq_1
XFILLER_16_493 VPWR VGND sg13cmos5l_decap_8
XFILLER_32_942 VPWR VGND sg13cmos5l_fill_2
X_2912_ _2912_/Y _2912_/A _2912_/B VPWR VGND sg13cmos5l_xnor2_1
X_3892_ _3892_/Q _4278_/CLK _3892_/D _3892_/RESET_B VPWR VGND sg13cmos5l_dfrbpq_1
XFILLER_31_452 VPWR VGND sg13cmos5l_fill_1
X_2843_ _2889_/B _2720_/Y _2835_/Y _2838_/X _2842_/Y VPWR VGND sg13cmos5l_a22oi_1
X_2774_ _2774_/X _2775_/D _2774_/B VPWR VGND sg13cmos5l_or2_1
Xclkbuf_leaf_7_clk clkload6/A clkload0/A VPWR VGND sg13cmos5l_buf_8
X_3326_ _3326_/X _3323_/X _3325_/Y _3321_/Y VPWR VGND sg13cmos5l_a21o_1
XFILLER_39_541 VPWR VGND sg13cmos5l_decap_4
X_3257_ _3258_/B _3257_/A _3257_/B VPWR VGND sg13cmos5l_xnor2_1
XFILLER_39_563 VPWR VGND sg13cmos5l_decap_8
XFILLER_2_1028 VPWR VGND sg13cmos5l_fill_1
XFILLER_2_1017 VPWR VGND sg13cmos5l_decap_8
X_2208_ _3559_/A _2208_/A VPWR VGND sg13cmos5l_inv_1
X_3188_ _3188_/Y hold861/X _3179_/Y _3187_/Y _4154_/Q VPWR VGND sg13cmos5l_a22oi_1
XFILLER_27_725 VPWR VGND sg13cmos5l_fill_2
XFILLER_35_791 VPWR VGND sg13cmos5l_decap_4
XFILLER_23_975 VPWR VGND sg13cmos5l_decap_4
XFILLER_34_290 VPWR VGND sg13cmos5l_fill_2
Xhold670 hold670/X _3894_/Q VPWR VGND sg13cmos5l_dlygate4sd3_1
XFILLER_2_835 VPWR VGND sg13cmos5l_decap_8
Xhold681 _2435_/A _4032_/Q VPWR VGND sg13cmos5l_dlygate4sd3_1
Xhold692 hold692/X _3930_/Q VPWR VGND sg13cmos5l_dlygate4sd3_1
XFILLER_45_555 VPWR VGND sg13cmos5l_decap_8
XFILLER_17_235 VPWR VGND sg13cmos5l_decap_4
XFILLER_18_758 VPWR VGND sg13cmos5l_decap_8
X_4132__509 _4132_/RESET_B VPWR VGND sg13cmos5l_tiehi
XFILLER_45_588 VPWR VGND sg13cmos5l_fill_1
XFILLER_14_953 VPWR VGND sg13cmos5l_decap_8
XFILLER_41_794 VPWR VGND sg13cmos5l_decap_8
XFILLER_9_434 VPWR VGND sg13cmos5l_decap_4
XFILLER_40_293 VPWR VGND sg13cmos5l_fill_2
X_3930__361 _3930_/RESET_B VPWR VGND sg13cmos5l_tiehi
XFILLER_5_684 VPWR VGND sg13cmos5l_fill_2
X_2490_ _4037_/D _3702_/A _2194_/A _2489_/Y VPWR VGND sg13cmos5l_a21oi_1
XFILLER_4_194 VPWR VGND sg13cmos5l_decap_8
XFILLER_4_172 VPWR VGND sg13cmos5l_decap_8
X_4160_ _4160_/Q _4193_/CLK _4160_/D _4160_/RESET_B VPWR VGND sg13cmos5l_dfrbpq_1
XFILLER_1_890 VPWR VGND sg13cmos5l_decap_8
X_3111_ _3115_/A _3114_/B _3111_/B VPWR VGND sg13cmos5l_nand2b_1
X_4091_ _4091_/Q _4137_/CLK _4091_/D _4091_/RESET_B VPWR VGND sg13cmos5l_dfrbpq_1
X_3042_ _4132_/D _3555_/A _3042_/B VPWR VGND sg13cmos5l_and2_1
X_3944_ _3944_/Q _4027_/CLK _3944_/D _3944_/RESET_B VPWR VGND sg13cmos5l_dfrbpq_1
X_3875_ _4027_/D _3875_/A _3875_/B VPWR VGND sg13cmos5l_nor2_1
X_2826_ _2826_/Y _4063_/Q _4064_/Q _4065_/Q VPWR VGND sg13cmos5l_o21ai_1
XFILLER_9_990 VPWR VGND sg13cmos5l_decap_8
XFILLER_20_978 VPWR VGND sg13cmos5l_decap_8
X_2757_ _4075_/D _2792_/B _2757_/B VPWR VGND sg13cmos5l_and2_1
X_2688_ _2691_/B _2688_/A _2688_/B _2688_/C VPWR VGND sg13cmos5l_nand3_1
XFILLER_48_49 VPWR VGND sg13cmos5l_decap_4
X_4003__288 _4003_/RESET_B VPWR VGND sg13cmos5l_tiehi
X_3309_ _3309_/X _3500_/A _3309_/B VPWR VGND sg13cmos5l_and2_1
XFILLER_27_522 VPWR VGND sg13cmos5l_fill_1
XFILLER_11_901 VPWR VGND sg13cmos5l_decap_8
Xfanout31 _2381_/S _2378_/S VPWR VGND sg13cmos5l_buf_1
Xfanout20 _2756_/A2 _2755_/A2 VPWR VGND sg13cmos5l_buf_1
Xfanout64 _3769_/A hold974/X VPWR VGND sg13cmos5l_buf_1
Xfanout53 _3217_/B _3094_/Y VPWR VGND sg13cmos5l_buf_1
Xfanout42 _2964_/A _3152_/A VPWR VGND sg13cmos5l_buf_1
XFILLER_10_444 VPWR VGND sg13cmos5l_decap_4
Xfanout75 _2645_/S1 _2621_/S1 VPWR VGND sg13cmos5l_buf_1
Xfanout86 _2643_/S0 fanout99/X VPWR VGND sg13cmos5l_buf_1
Xfanout97 _2673_/A _2677_/S0 VPWR VGND sg13cmos5l_buf_1
XFILLER_13_63 VPWR VGND sg13cmos5l_fill_2
XFILLER_6_459 VPWR VGND sg13cmos5l_fill_2
XFILLER_10_499 VPWR VGND sg13cmos5l_decap_4
XFILLER_2_621 VPWR VGND sg13cmos5l_fill_2
XFILLER_2_610 VPWR VGND sg13cmos5l_decap_8
X_4199__436 _4199_/RESET_B VPWR VGND sg13cmos5l_tiehi
XFILLER_49_124 VPWR VGND sg13cmos5l_decap_4
XFILLER_49_168 VPWR VGND sg13cmos5l_decap_4
XFILLER_37_308 VPWR VGND sg13cmos5l_decap_8
XFILLER_46_842 VPWR VGND sg13cmos5l_decap_8
XFILLER_33_547 VPWR VGND sg13cmos5l_decap_4
XFILLER_14_772 VPWR VGND sg13cmos5l_fill_1
X_3660_ _3798_/A _3635_/X _3659_/A _3659_/Y VPWR VGND sg13cmos5l_o21ai_1
X_2611_ _2612_/C _2680_/A1 _2607_/X _2610_/Y VPWR VGND sg13cmos5l_a21oi_1
X_3591_ _3592_/B _3591_/A _3591_/B VPWR VGND sg13cmos5l_nor2_1
Xclkload12 clkload12/Y _4205_/CLK VPWR VGND sg13cmos5l_inv_2
X_2542_ _4047_/D _2727_/A hold886/X _2698_/A VPWR VGND sg13cmos5l_a21oi_1
XFILLER_6_982 VPWR VGND sg13cmos5l_decap_8
X_4026__255 _4026_/RESET_B VPWR VGND sg13cmos5l_tiehi
XFILLER_5_481 VPWR VGND sg13cmos5l_decap_8
X_4212_ _4212_/Q _4237_/CLK _4212_/D _4212_/RESET_B VPWR VGND sg13cmos5l_dfrbpq_1
X_2473_ _2476_/A _2474_/B _2474_/C _3846_/B VPWR VGND sg13cmos5l_a21oi_1
X_4143_ _4143_/Q _4173_/CLK _4143_/D _4143_/RESET_B VPWR VGND sg13cmos5l_dfrbpq_1
XFILLER_18_19 VPWR VGND sg13cmos5l_decap_8
X_4074_ _4074_/Q _4129_/CLK _4074_/D _4074_/RESET_B VPWR VGND sg13cmos5l_dfrbpq_1
XFILLER_49_680 VPWR VGND sg13cmos5l_decap_8
XFILLER_37_820 VPWR VGND sg13cmos5l_decap_8
X_3025_ _3025_/Y _3024_/Y _3025_/B VPWR VGND sg13cmos5l_nand2b_1
XFILLER_37_886 VPWR VGND sg13cmos5l_fill_2
XFILLER_37_875 VPWR VGND sg13cmos5l_decap_8
XFILLER_11_208 VPWR VGND sg13cmos5l_decap_8
X_3927_ _3927_/Q _4278_/CLK _3927_/D _3927_/RESET_B VPWR VGND sg13cmos5l_dfrbpq_1
Xclkload6 clkload6/Y clkload6/A VPWR VGND sg13cmos5l_inv_2
X_3858_ _3887_/D _3867_/A hold794/X _3864_/S VPWR VGND sg13cmos5l_mux2_1
X_2809_ _2810_/B _4086_/Q _4085_/Q VPWR VGND sg13cmos5l_xnor2_1
X_3789_ _3789_/Y _3770_/X _3771_/Y _3780_/Y _3783_/Y _3784_/Y VPWR VGND sg13cmos5l_a221oi_1
XFILLER_30_1011 VPWR VGND sg13cmos5l_decap_8
XFILLER_19_308 VPWR VGND sg13cmos5l_fill_1
X_3920__371 _3920_/RESET_B VPWR VGND sg13cmos5l_tiehi
XFILLER_43_801 VPWR VGND sg13cmos5l_fill_2
XFILLER_28_864 VPWR VGND sg13cmos5l_fill_2
XFILLER_42_333 VPWR VGND sg13cmos5l_fill_1
XFILLER_24_73 VPWR VGND sg13cmos5l_decap_8
XFILLER_24_84 VPWR VGND sg13cmos5l_fill_1
XFILLER_7_702 VPWR VGND sg13cmos5l_decap_8
XFILLER_10_230 VPWR VGND sg13cmos5l_decap_8
XFILLER_40_61 VPWR VGND sg13cmos5l_fill_2
XFILLER_6_256 VPWR VGND sg13cmos5l_fill_2
XFILLER_3_930 VPWR VGND sg13cmos5l_decap_8
XFILLER_1_22 VPWR VGND sg13cmos5l_fill_1
XFILLER_38_639 VPWR VGND sg13cmos5l_decap_8
XFILLER_19_842 VPWR VGND sg13cmos5l_decap_8
XFILLER_19_853 VPWR VGND sg13cmos5l_fill_1
XFILLER_18_396 VPWR VGND sg13cmos5l_decap_8
XFILLER_34_856 VPWR VGND sg13cmos5l_decap_8
X_3712_ _4256_/D _3712_/A _3815_/A VPWR VGND sg13cmos5l_nor2_1
X_3643_ _3658_/B _4265_/Q _3643_/B VPWR VGND sg13cmos5l_xnor2_1
X_3574_ _3601_/B _3572_/Y _3573_/Y _3571_/Y VPWR VGND sg13cmos5l_a21oi_1
X_2525_ _2526_/B _4045_/Q _2530_/B VPWR VGND sg13cmos5l_nor2b_1
X_2456_ _2458_/B _2456_/A _2461_/B VPWR VGND sg13cmos5l_xor2_1
X_2387_ _3982_/D hold811/X _3859_/A0 _2391_/S VPWR VGND sg13cmos5l_mux2_1
X_4126_ _4126_/Q _4227_/CLK _4126_/D _4126_/RESET_B VPWR VGND sg13cmos5l_dfrbpq_1
XFILLER_37_650 VPWR VGND sg13cmos5l_fill_1
X_4057_ _4057_/Q clkload9/A _4057_/D _4057_/RESET_B VPWR VGND sg13cmos5l_dfrbpq_1
X_3008_ _3016_/C _4142_/Q _3007_/Y _3006_/Y VPWR VGND sg13cmos5l_o21ai_1
XFILLER_4_705 VPWR VGND sg13cmos5l_decap_4
XFILLER_0_900 VPWR VGND sg13cmos5l_decap_8
XFILLER_10_75 VPWR VGND sg13cmos5l_fill_2
X_4196__439 _4196_/RESET_B VPWR VGND sg13cmos5l_tiehi
XFILLER_48_937 VPWR VGND sg13cmos5l_decap_8
XFILLER_0_977 VPWR VGND sg13cmos5l_decap_8
XFILLER_28_650 VPWR VGND sg13cmos5l_decap_8
XFILLER_35_609 VPWR VGND sg13cmos5l_decap_8
XFILLER_16_878 VPWR VGND sg13cmos5l_decap_8
XFILLER_16_889 VPWR VGND sg13cmos5l_fill_2
XFILLER_30_314 VPWR VGND sg13cmos5l_decap_8
XFILLER_11_550 VPWR VGND sg13cmos5l_fill_2
XFILLER_7_521 VPWR VGND sg13cmos5l_decap_4
X_2310_ _3917_/D hold730/X _3873_/A0 _2311_/S VPWR VGND sg13cmos5l_mux2_1
X_3290_ _3290_/Y _3282_/Y _3289_/X _3278_/X VPWR VGND sg13cmos5l_o21ai_1
X_2241_ _3359_/B _2241_/A VPWR VGND sg13cmos5l_inv_1
XFILLER_39_937 VPWR VGND sg13cmos5l_decap_8
XFILLER_25_4 VPWR VGND sg13cmos5l_decap_8
Xheichips26_dna_sequencer_148 uio_out[7] VPWR VGND sg13cmos5l_tielo
X_2172_ _2172_/Y _2172_/A VPWR VGND sg13cmos5l_inv_1
Xheichips26_dna_sequencer_137 uio_oe[4] VPWR VGND sg13cmos5l_tielo
XFILLER_34_631 VPWR VGND sg13cmos5l_decap_4
XFILLER_22_804 VPWR VGND sg13cmos5l_decap_8
XFILLER_21_325 VPWR VGND sg13cmos5l_fill_2
X_3910__381 _3910_/RESET_B VPWR VGND sg13cmos5l_tiehi
X_3626_ _3626_/Y _4261_/Q _4240_/Q VPWR VGND sg13cmos5l_nand2_1
Xoutput19 uo_out[5] _4021_/Q VPWR VGND sg13cmos5l_buf_1
XFILLER_1_708 VPWR VGND sg13cmos5l_decap_8
X_3557_ _4229_/D _3557_/A _3560_/B VPWR VGND sg13cmos5l_and2_1
X_2508_ _2509_/B _4049_/Q _4097_/Q _4071_/Q _4158_/Q VPWR VGND sg13cmos5l_nor4_1
X_3488_ _3500_/B _4182_/Q _4181_/Q _4180_/Q VPWR VGND sg13cmos5l_or3_1
X_2439_ _2439_/Y input4/X _4017_/Q _2466_/A VPWR VGND sg13cmos5l_o21ai_1
XFILLER_29_414 VPWR VGND sg13cmos5l_decap_8
XFILLER_45_929 VPWR VGND sg13cmos5l_decap_8
X_4109_ _4109_/Q _4136_/CLK _4109_/D _4109_/RESET_B VPWR VGND sg13cmos5l_dfrbpq_1
XFILLER_44_417 VPWR VGND sg13cmos5l_decap_4
XFILLER_38_970 VPWR VGND sg13cmos5l_decap_8
XFILLER_37_480 VPWR VGND sg13cmos5l_fill_2
XFILLER_12_336 VPWR VGND sg13cmos5l_decap_8
XFILLER_8_329 VPWR VGND sg13cmos5l_fill_2
XFILLER_4_502 VPWR VGND sg13cmos5l_decap_4
XFILLER_4_546 VPWR VGND sg13cmos5l_fill_2
XFILLER_21_74 VPWR VGND sg13cmos5l_decap_8
XFILLER_21_85 VPWR VGND sg13cmos5l_fill_2
XFILLER_43_1010 VPWR VGND sg13cmos5l_decap_8
XFILLER_0_774 VPWR VGND sg13cmos5l_decap_8
XFILLER_48_734 VPWR VGND sg13cmos5l_decap_8
XFILLER_47_211 VPWR VGND sg13cmos5l_fill_2
XFILLER_46_60 VPWR VGND sg13cmos5l_decap_8
XFILLER_44_995 VPWR VGND sg13cmos5l_decap_8
XFILLER_15_152 VPWR VGND sg13cmos5l_decap_8
XFILLER_16_653 VPWR VGND sg13cmos5l_fill_1
XFILLER_15_196 VPWR VGND sg13cmos5l_fill_1
XFILLER_30_100 VPWR VGND sg13cmos5l_decap_4
XFILLER_30_111 VPWR VGND sg13cmos5l_decap_8
XFILLER_31_623 VPWR VGND sg13cmos5l_decap_8
XFILLER_31_634 VPWR VGND sg13cmos5l_fill_1
XFILLER_30_122 VPWR VGND sg13cmos5l_fill_2
XFILLER_30_144 VPWR VGND sg13cmos5l_fill_1
X_2790_ _4083_/D _2761_/B hold921/X _4061_/D VPWR VGND sg13cmos5l_a21o_1
XFILLER_8_830 VPWR VGND sg13cmos5l_decap_8
XFILLER_11_380 VPWR VGND sg13cmos5l_fill_2
X_3411_ _3426_/C _4199_/Q _3438_/B VPWR VGND sg13cmos5l_xnor2_1
X_3342_ _4181_/D _3394_/B _3342_/B VPWR VGND sg13cmos5l_nor2_1
X_3273_ _3273_/Y _3547_/B _3273_/B VPWR VGND sg13cmos5l_nand2b_1
Xhold1007 _3453_/B1 _4237_/Q VPWR VGND sg13cmos5l_dlygate4sd3_1
X_2224_ _2510_/A _2224_/A VPWR VGND sg13cmos5l_inv_1
XFILLER_38_255 VPWR VGND sg13cmos5l_decap_4
XFILLER_16_0 VPWR VGND sg13cmos5l_fill_2
XFILLER_35_984 VPWR VGND sg13cmos5l_decap_8
XFILLER_22_623 VPWR VGND sg13cmos5l_fill_1
XFILLER_42_18 VPWR VGND sg13cmos5l_decap_8
XFILLER_22_667 VPWR VGND sg13cmos5l_fill_1
X_2988_ _2989_/B _2994_/A _2994_/C VPWR VGND sg13cmos5l_nand2_1
Xhold830 _3689_/B _4264_/Q VPWR VGND sg13cmos5l_dlygate4sd3_1
X_3609_ _3611_/A _3594_/A hold947/X _3608_/Y VPWR VGND sg13cmos5l_a21oi_1
Xhold852 hold852/X _2442_/Y VPWR VGND sg13cmos5l_dlygate4sd3_1
XFILLER_1_516 VPWR VGND sg13cmos5l_decap_8
Xhold841 _2530_/B _4044_/Q VPWR VGND sg13cmos5l_dlygate4sd3_1
Xhold863 _2526_/A _4043_/Q VPWR VGND sg13cmos5l_dlygate4sd3_1
Xhold885 _2539_/B _4047_/Q VPWR VGND sg13cmos5l_dlygate4sd3_1
Xhold874 hold874/X _4187_/Q VPWR VGND sg13cmos5l_dlygate4sd3_1
Xhold896 _2224_/A _4277_/Q VPWR VGND sg13cmos5l_dlygate4sd3_1
XFILLER_45_737 VPWR VGND sg13cmos5l_decap_8
XFILLER_26_951 VPWR VGND sg13cmos5l_decap_8
XFILLER_32_409 VPWR VGND sg13cmos5l_decap_8
XFILLER_41_943 VPWR VGND sg13cmos5l_decap_8
XFILLER_25_494 VPWR VGND sg13cmos5l_fill_1
XFILLER_9_649 VPWR VGND sg13cmos5l_decap_4
XFILLER_8_137 VPWR VGND sg13cmos5l_fill_1
XFILLER_32_62 VPWR VGND sg13cmos5l_decap_8
X_4141__500 _4141_/RESET_B VPWR VGND sg13cmos5l_tiehi
XFILLER_5_899 VPWR VGND sg13cmos5l_fill_2
XFILLER_4_387 VPWR VGND sg13cmos5l_fill_1
XFILLER_0_593 VPWR VGND sg13cmos5l_decap_4
X_3960_ _3960_/Q _4011_/CLK _3960_/D _3960_/RESET_B VPWR VGND sg13cmos5l_dfrbpq_1
XFILLER_44_781 VPWR VGND sg13cmos5l_fill_1
XFILLER_17_995 VPWR VGND sg13cmos5l_decap_8
XFILLER_31_420 VPWR VGND sg13cmos5l_fill_1
X_2911_ _2912_/B _4104_/Q _2916_/B _2896_/Y VPWR VGND sg13cmos5l_a21oi_1
XFILLER_32_921 VPWR VGND sg13cmos5l_decap_8
X_3891_ _3891_/Q _4278_/CLK _3891_/D _3891_/RESET_B VPWR VGND sg13cmos5l_dfrbpq_1
XFILLER_31_431 VPWR VGND sg13cmos5l_decap_8
X_2842_ _2842_/Y _2845_/B _2828_/Y VPWR VGND sg13cmos5l_nor2b_1
XFILLER_31_486 VPWR VGND sg13cmos5l_decap_8
XFILLER_32_987 VPWR VGND sg13cmos5l_decap_8
X_2773_ _2774_/B _2773_/A _2773_/B _2773_/C VPWR VGND sg13cmos5l_nor3_1
XFILLER_8_671 VPWR VGND sg13cmos5l_decap_4
XFILLER_7_181 VPWR VGND sg13cmos5l_fill_1
X_3325_ _3325_/Y _4170_/Q _4148_/Q _3338_/A VPWR VGND sg13cmos5l_o21ai_1
X_3256_ _3257_/B _3256_/A _3260_/B VPWR VGND sg13cmos5l_xor2_1
X_2207_ _3304_/A _3558_/A VPWR VGND sg13cmos5l_inv_1
X_3187_ _3187_/Y _3180_/B _3185_/Y _3186_/Y _3181_/C VPWR VGND sg13cmos5l_a22oi_1
X_4036__235 _4036_/RESET_B VPWR VGND sg13cmos5l_tiehi
XFILLER_27_737 VPWR VGND sg13cmos5l_fill_1
XFILLER_35_770 VPWR VGND sg13cmos5l_fill_1
XFILLER_10_604 VPWR VGND sg13cmos5l_decap_8
XFILLER_2_814 VPWR VGND sg13cmos5l_decap_8
Xhold671 hold671/X _3899_/Q VPWR VGND sg13cmos5l_dlygate4sd3_1
Xhold660 hold660/X _3967_/Q VPWR VGND sg13cmos5l_dlygate4sd3_1
Xhold682 _4016_/D _2438_/Y VPWR VGND sg13cmos5l_dlygate4sd3_1
Xhold693 hold693/X _3953_/Q VPWR VGND sg13cmos5l_dlygate4sd3_1
XFILLER_40_1024 VPWR VGND sg13cmos5l_decap_4
XFILLER_17_203 VPWR VGND sg13cmos5l_decap_8
XFILLER_45_534 VPWR VGND sg13cmos5l_fill_2
XFILLER_45_523 VPWR VGND sg13cmos5l_decap_8
XFILLER_17_214 VPWR VGND sg13cmos5l_fill_2
XFILLER_33_707 VPWR VGND sg13cmos5l_fill_2
XFILLER_14_932 VPWR VGND sg13cmos5l_decap_8
XFILLER_41_740 VPWR VGND sg13cmos5l_decap_8
XFILLER_13_442 VPWR VGND sg13cmos5l_decap_8
XFILLER_9_468 VPWR VGND sg13cmos5l_decap_4
XFILLER_5_652 VPWR VGND sg13cmos5l_decap_8
X_3110_ _3111_/B _4172_/Q _4171_/Q _4173_/Q VPWR VGND sg13cmos5l_o21ai_1
X_4090_ _4090_/Q _4137_/CLK _4090_/D _4090_/RESET_B VPWR VGND sg13cmos5l_dfrbpq_1
XFILLER_49_884 VPWR VGND sg13cmos5l_decap_8
X_3041_ _4131_/D _3041_/A _3041_/B VPWR VGND sg13cmos5l_and2_1
XFILLER_36_523 VPWR VGND sg13cmos5l_fill_2
XFILLER_16_291 VPWR VGND sg13cmos5l_decap_8
X_3943_ _3943_/Q _4011_/CLK _3943_/D _3943_/RESET_B VPWR VGND sg13cmos5l_dfrbpq_1
X_3874_ _4026_/D _3874_/A _3874_/B VPWR VGND sg13cmos5l_nor2_1
XFILLER_20_902 VPWR VGND sg13cmos5l_decap_8
XFILLER_20_924 VPWR VGND sg13cmos5l_decap_8
X_2825_ _2833_/B _4063_/Q _4064_/Q _4065_/Q VPWR VGND sg13cmos5l_nor3_1
XFILLER_20_957 VPWR VGND sg13cmos5l_decap_8
X_4224__405 _4224_/RESET_B VPWR VGND sg13cmos5l_tiehi
X_2756_ _2756_/Y _2190_/Y _2756_/A2 _2755_/Y VPWR VGND sg13cmos5l_a21oi_1
X_2687_ _4052_/D _2687_/A VPWR VGND sg13cmos5l_inv_1
X_4257__214 _4257_/RESET_B VPWR VGND sg13cmos5l_tiehi
XFILLER_48_28 VPWR VGND sg13cmos5l_decap_8
X_3308_ _4176_/D hold990/X _3396_/B _3347_/A VPWR VGND sg13cmos5l_a21oi_1
XFILLER_46_309 VPWR VGND sg13cmos5l_fill_2
X_3239_ _3240_/B _4169_/Q _3260_/B _3260_/C _3238_/Y VPWR VGND sg13cmos5l_a22oi_1
X_4131__510 _4131_/RESET_B VPWR VGND sg13cmos5l_tiehi
XFILLER_14_217 VPWR VGND sg13cmos5l_decap_4
XFILLER_15_729 VPWR VGND sg13cmos5l_decap_4
XFILLER_23_751 VPWR VGND sg13cmos5l_fill_1
Xfanout21 _3035_/A2 _3710_/A2 VPWR VGND sg13cmos5l_buf_1
Xfanout54 _3047_/B _2929_/Y VPWR VGND sg13cmos5l_buf_1
Xfanout43 _3815_/A _3715_/B VPWR VGND sg13cmos5l_buf_1
Xfanout65 _3558_/A hold997/X VPWR VGND sg13cmos5l_buf_1
Xfanout32 _2361_/S _2358_/S VPWR VGND sg13cmos5l_buf_1
XFILLER_10_423 VPWR VGND sg13cmos5l_fill_2
Xfanout98 _2677_/S0 fanout99/X VPWR VGND sg13cmos5l_buf_1
XFILLER_22_283 VPWR VGND sg13cmos5l_decap_8
XFILLER_22_294 VPWR VGND sg13cmos5l_fill_2
Xfanout76 _2678_/S1 _2621_/S1 VPWR VGND sg13cmos5l_buf_1
Xfanout87 _2634_/A _2667_/A1 VPWR VGND sg13cmos5l_buf_1
XFILLER_2_600 VPWR VGND sg13cmos5l_fill_2
XFILLER_46_821 VPWR VGND sg13cmos5l_decap_8
XFILLER_18_567 VPWR VGND sg13cmos5l_fill_2
XFILLER_33_504 VPWR VGND sg13cmos5l_decap_4
XFILLER_46_898 VPWR VGND sg13cmos5l_decap_8
XFILLER_41_570 VPWR VGND sg13cmos5l_fill_1
XFILLER_13_261 VPWR VGND sg13cmos5l_fill_2
XFILLER_13_272 VPWR VGND sg13cmos5l_decap_8
X_2610_ _2610_/Y _2680_/A1 _2609_/Y _2647_/A VPWR VGND sg13cmos5l_o21ai_1
X_3590_ _3590_/Y _3564_/B _3596_/S _3589_/Y VPWR VGND sg13cmos5l_o21ai_1
XFILLER_9_287 VPWR VGND sg13cmos5l_fill_2
Xclkload13 clkload13/Y _4231_/CLK VPWR VGND sg13cmos5l_inv_2
X_2541_ _4046_/D _2538_/Y _2540_/Y _2698_/A VPWR VGND sg13cmos5l_a21oi_1
XFILLER_6_961 VPWR VGND sg13cmos5l_decap_8
XFILLER_47_1008 VPWR VGND sg13cmos5l_decap_8
X_2472_ _4029_/D _3617_/B _2472_/B VPWR VGND sg13cmos5l_nor2_1
X_4211_ _4211_/Q _4237_/CLK _4211_/D _4211_/RESET_B VPWR VGND sg13cmos5l_dfrbpq_1
X_4142_ _4142_/Q _4193_/CLK _4142_/D _4142_/RESET_B VPWR VGND sg13cmos5l_dfrbpq_1
XFILLER_28_309 VPWR VGND sg13cmos5l_decap_8
X_4073_ _4073_/Q _4129_/CLK _4073_/D _4073_/RESET_B VPWR VGND sg13cmos5l_dfrbpq_1
X_3024_ _3024_/Y _3032_/B _3021_/Y _3032_/A VPWR VGND sg13cmos5l_o21ai_1
XFILLER_24_537 VPWR VGND sg13cmos5l_decap_8
XFILLER_36_375 VPWR VGND sg13cmos5l_fill_1
XFILLER_24_548 VPWR VGND sg13cmos5l_fill_2
X_3926_ _3926_/Q _4011_/CLK _3926_/D _3926_/RESET_B VPWR VGND sg13cmos5l_dfrbpq_1
Xclkload7 clkload7/Y clkload7/A VPWR VGND sg13cmos5l_inv_2
X_3857_ _3886_/D _3866_/A0 hold749/X _3864_/S VPWR VGND sg13cmos5l_mux2_1
X_2808_ _2808_/Y _4086_/Q _2810_/A _2817_/A VPWR VGND sg13cmos5l_o21ai_1
X_3788_ _3792_/A _3802_/A _3739_/Y _3795_/S _3779_/A _3786_/Y VPWR VGND sg13cmos5l_a221oi_1
XFILLER_20_798 VPWR VGND sg13cmos5l_fill_1
X_2739_ _2739_/Y _2855_/B _2739_/B VPWR VGND sg13cmos5l_nor2_1
XFILLER_27_386 VPWR VGND sg13cmos5l_decap_8
XFILLER_28_887 VPWR VGND sg13cmos5l_fill_1
XFILLER_15_548 VPWR VGND sg13cmos5l_fill_1
XFILLER_11_743 VPWR VGND sg13cmos5l_fill_1
XFILLER_11_787 VPWR VGND sg13cmos5l_decap_8
XFILLER_11_798 VPWR VGND sg13cmos5l_decap_8
XFILLER_3_986 VPWR VGND sg13cmos5l_decap_8
XFILLER_2_463 VPWR VGND sg13cmos5l_decap_8
XFILLER_49_60 VPWR VGND sg13cmos5l_decap_8
XFILLER_46_684 VPWR VGND sg13cmos5l_decap_8
XFILLER_18_375 VPWR VGND sg13cmos5l_decap_8
XFILLER_34_846 VPWR VGND sg13cmos5l_decap_4
X_3711_ _3711_/X _3769_/A _3711_/B VPWR VGND sg13cmos5l_and2_1
X_3642_ _3642_/Y _3658_/A _3634_/Y _3636_/Y _3628_/Y _3641_/Y VPWR VGND sg13cmos5l_a221oi_1
X_3573_ _3573_/Y _4224_/Q _4195_/Q VPWR VGND sg13cmos5l_xnor2_1
XFILLER_46_0 VPWR VGND sg13cmos5l_decap_8
X_2524_ _2535_/A _2775_/A _2761_/A VPWR VGND sg13cmos5l_nor2b_1
X_2455_ _2463_/A _4023_/Q _2461_/B VPWR VGND sg13cmos5l_and2_1
X_2386_ _3981_/D hold801/X _2415_/A0 _2391_/S VPWR VGND sg13cmos5l_mux2_1
X_4125_ _4125_/Q _4173_/CLK _4125_/D _4125_/RESET_B VPWR VGND sg13cmos5l_dfrbpq_1
XFILLER_28_139 VPWR VGND sg13cmos5l_decap_8
X_4056_ _4056_/Q clkload9/A _4056_/D _4056_/RESET_B VPWR VGND sg13cmos5l_dfrbpq_1
XFILLER_25_813 VPWR VGND sg13cmos5l_fill_2
X_3007_ _3007_/Y _4096_/Q _4141_/Q VPWR VGND sg13cmos5l_nor2_1
XFILLER_12_518 VPWR VGND sg13cmos5l_decap_8
XFILLER_12_529 VPWR VGND sg13cmos5l_fill_2
X_3909_ _3909_/Q _4278_/CLK _3909_/D _3909_/RESET_B VPWR VGND sg13cmos5l_dfrbpq_1
XFILLER_3_249 VPWR VGND sg13cmos5l_decap_8
XFILLER_0_956 VPWR VGND sg13cmos5l_decap_8
XFILLER_48_916 VPWR VGND sg13cmos5l_decap_8
X_4096__552 _4096_/RESET_B VPWR VGND sg13cmos5l_tiehi
XFILLER_19_52 VPWR VGND sg13cmos5l_fill_2
XFILLER_19_63 VPWR VGND sg13cmos5l_fill_1
XFILLER_19_106 VPWR VGND sg13cmos5l_fill_2
XFILLER_16_835 VPWR VGND sg13cmos5l_fill_2
XFILLER_28_695 VPWR VGND sg13cmos5l_decap_8
XFILLER_35_73 VPWR VGND sg13cmos5l_fill_2
XFILLER_15_389 VPWR VGND sg13cmos5l_fill_1
XFILLER_31_849 VPWR VGND sg13cmos5l_decap_4
XFILLER_11_573 VPWR VGND sg13cmos5l_decap_8
XFILLER_3_783 VPWR VGND sg13cmos5l_decap_8
X_2240_ _3184_/A _4155_/Q VPWR VGND sg13cmos5l_inv_1
XFILLER_39_916 VPWR VGND sg13cmos5l_decap_8
Xheichips26_dna_sequencer_149 uo_out[6] VPWR VGND sg13cmos5l_tielo
X_2171_ _2171_/Y _2171_/A VPWR VGND sg13cmos5l_inv_1
Xheichips26_dna_sequencer_138 uio_oe[5] VPWR VGND sg13cmos5l_tielo
XFILLER_22_816 VPWR VGND sg13cmos5l_fill_1
XFILLER_21_315 VPWR VGND sg13cmos5l_fill_1
XFILLER_30_860 VPWR VGND sg13cmos5l_fill_2
X_3625_ _3625_/X _4239_/Q _4240_/Q VPWR VGND sg13cmos5l_xor2_1
X_3556_ _4228_/D _3556_/A _3556_/B VPWR VGND sg13cmos5l_and2_1
X_2507_ _2509_/A _4127_/Q _4222_/Q _4190_/Q VPWR VGND sg13cmos5l_nor3_1
X_3487_ _4210_/D _3561_/B _3600_/A VPWR VGND sg13cmos5l_nor2_1
X_2438_ _2438_/Y _2435_/Y _2437_/Y _3874_/A VPWR VGND sg13cmos5l_a21oi_1
X_4195__440 _4195_/RESET_B VPWR VGND sg13cmos5l_tiehi
X_2369_ _3967_/D _2418_/A0 hold660/X _2371_/S VPWR VGND sg13cmos5l_mux2_1
XFILLER_5_1027 VPWR VGND sg13cmos5l_fill_2
XFILLER_5_1016 VPWR VGND sg13cmos5l_decap_8
XFILLER_45_908 VPWR VGND sg13cmos5l_decap_8
X_4108_ _4108_/Q _4137_/CLK _4108_/D _4108_/RESET_B VPWR VGND sg13cmos5l_dfrbpq_1
XFILLER_44_429 VPWR VGND sg13cmos5l_decap_8
X_4039_ _4039_/Q clkload2/A _4039_/D _4039_/RESET_B VPWR VGND sg13cmos5l_dfrbpq_1
XFILLER_24_120 VPWR VGND sg13cmos5l_fill_2
XFILLER_40_635 VPWR VGND sg13cmos5l_decap_4
XFILLER_9_809 VPWR VGND sg13cmos5l_fill_1
XFILLER_12_326 VPWR VGND sg13cmos5l_fill_1
XFILLER_21_871 VPWR VGND sg13cmos5l_fill_1
XFILLER_21_31 VPWR VGND sg13cmos5l_decap_8
XFILLER_4_514 VPWR VGND sg13cmos5l_decap_8
XFILLER_21_42 VPWR VGND sg13cmos5l_fill_1
XFILLER_0_753 VPWR VGND sg13cmos5l_decap_8
XFILLER_36_919 VPWR VGND sg13cmos5l_decap_8
XFILLER_29_993 VPWR VGND sg13cmos5l_decap_8
XFILLER_46_83 VPWR VGND sg13cmos5l_decap_4
XFILLER_16_632 VPWR VGND sg13cmos5l_decap_8
XFILLER_44_974 VPWR VGND sg13cmos5l_decap_8
XFILLER_8_864 VPWR VGND sg13cmos5l_decap_8
XFILLER_7_341 VPWR VGND sg13cmos5l_fill_2
XFILLER_7_330 VPWR VGND sg13cmos5l_decap_8
XFILLER_7_44 VPWR VGND sg13cmos5l_fill_1
XFILLER_7_33 VPWR VGND sg13cmos5l_decap_8
XFILLER_11_392 VPWR VGND sg13cmos5l_fill_1
XFILLER_12_893 VPWR VGND sg13cmos5l_fill_2
XFILLER_7_77 VPWR VGND sg13cmos5l_fill_1
X_3410_ _3426_/B _4193_/Q _4164_/Q _4198_/Q VPWR VGND sg13cmos5l_nand3_1
X_3341_ _3341_/Y _3342_/B VPWR VGND sg13cmos5l_inv_1
XFILLER_3_580 VPWR VGND sg13cmos5l_decap_8
X_3272_ _3390_/B _3272_/A _3547_/B VPWR VGND sg13cmos5l_nor2_1
X_2223_ _2223_/Y _3547_/A VPWR VGND sg13cmos5l_inv_1
Xhold1008 _3242_/A _4166_/Q VPWR VGND sg13cmos5l_dlygate4sd3_1
XFILLER_38_223 VPWR VGND sg13cmos5l_fill_1
XFILLER_27_919 VPWR VGND sg13cmos5l_decap_8
XFILLER_34_451 VPWR VGND sg13cmos5l_fill_1
XFILLER_35_963 VPWR VGND sg13cmos5l_decap_8
XFILLER_21_112 VPWR VGND sg13cmos5l_fill_1
XFILLER_34_473 VPWR VGND sg13cmos5l_decap_8
X_2987_ _2995_/D _2976_/Y _2985_/Y _2986_/B VPWR VGND sg13cmos5l_o21ai_1
XFILLER_21_178 VPWR VGND sg13cmos5l_fill_1
XFILLER_21_189 VPWR VGND sg13cmos5l_decap_8
X_3608_ _3608_/Y _3608_/A _3608_/B VPWR VGND sg13cmos5l_nand2_1
Xhold820 _2220_/A _4173_/Q VPWR VGND sg13cmos5l_dlygate4sd3_1
Xhold831 hold831/X _3689_/Y VPWR VGND sg13cmos5l_dlygate4sd3_1
Xhold853 _2245_/A _4122_/Q VPWR VGND sg13cmos5l_dlygate4sd3_1
Xhold842 _2535_/C _2530_/Y VPWR VGND sg13cmos5l_dlygate4sd3_1
Xhold864 _2535_/B _2528_/A VPWR VGND sg13cmos5l_dlygate4sd3_1
Xhold886 hold886/X _2539_/Y VPWR VGND sg13cmos5l_dlygate4sd3_1
X_3539_ _3540_/B _3677_/B _3532_/Y _3539_/S VPWR VGND sg13cmos5l_mux2_1
Xhold875 _4187_/D _3377_/Y VPWR VGND sg13cmos5l_dlygate4sd3_1
Xhold897 hold897/X _4123_/Q VPWR VGND sg13cmos5l_dlygate4sd3_1
XFILLER_17_418 VPWR VGND sg13cmos5l_decap_4
XFILLER_38_790 VPWR VGND sg13cmos5l_decap_8
XFILLER_17_429 VPWR VGND sg13cmos5l_decap_4
XFILLER_44_259 VPWR VGND sg13cmos5l_fill_2
XFILLER_44_248 VPWR VGND sg13cmos5l_decap_8
XFILLER_13_613 VPWR VGND sg13cmos5l_decap_4
XFILLER_40_432 VPWR VGND sg13cmos5l_fill_1
XFILLER_13_646 VPWR VGND sg13cmos5l_decap_8
XFILLER_13_657 VPWR VGND sg13cmos5l_decap_8
XFILLER_41_999 VPWR VGND sg13cmos5l_decap_8
XFILLER_8_127 VPWR VGND sg13cmos5l_fill_1
XFILLER_0_572 VPWR VGND sg13cmos5l_fill_2
XFILLER_48_521 VPWR VGND sg13cmos5l_decap_4
XFILLER_44_760 VPWR VGND sg13cmos5l_decap_8
XFILLER_17_974 VPWR VGND sg13cmos5l_decap_8
XFILLER_44_793 VPWR VGND sg13cmos5l_decap_8
X_2910_ _2920_/A _2910_/A _2910_/B VPWR VGND sg13cmos5l_nor2_1
X_3890_ _3890_/Q clkload2/A _3890_/D _3890_/RESET_B VPWR VGND sg13cmos5l_dfrbpq_1
XFILLER_32_966 VPWR VGND sg13cmos5l_decap_8
X_2841_ _4089_/D _2884_/B _2892_/A VPWR VGND sg13cmos5l_and2_1
XFILLER_31_498 VPWR VGND sg13cmos5l_decap_8
X_2772_ _2772_/Y _2779_/A _2772_/B VPWR VGND sg13cmos5l_nor2_1
XFILLER_7_193 VPWR VGND sg13cmos5l_decap_4
X_3324_ _3338_/A _4149_/Q _4148_/Q VPWR VGND sg13cmos5l_xor2_1
X_3255_ _3255_/Y _3255_/A _3223_/B VPWR VGND sg13cmos5l_nor2b_1
X_2206_ _3674_/A _4261_/Q VPWR VGND sg13cmos5l_inv_1
X_3186_ _3186_/Y _3391_/A _4174_/Q VPWR VGND sg13cmos5l_nor2_1
XFILLER_42_719 VPWR VGND sg13cmos5l_fill_1
XFILLER_42_708 VPWR VGND sg13cmos5l_decap_8
XFILLER_41_207 VPWR VGND sg13cmos5l_fill_2
XFILLER_23_922 VPWR VGND sg13cmos5l_fill_1
XFILLER_23_944 VPWR VGND sg13cmos5l_decap_8
XFILLER_34_292 VPWR VGND sg13cmos5l_fill_1
XFILLER_23_999 VPWR VGND sg13cmos5l_decap_8
Xhold672 hold672/X _3966_/Q VPWR VGND sg13cmos5l_dlygate4sd3_1
XFILLER_1_325 VPWR VGND sg13cmos5l_decap_8
Xhold650 _2693_/A _4051_/Q VPWR VGND sg13cmos5l_dlygate4sd3_1
Xhold661 hold661/X _3975_/Q VPWR VGND sg13cmos5l_dlygate4sd3_1
Xhold694 hold694/X _3972_/Q VPWR VGND sg13cmos5l_dlygate4sd3_1
Xhold683 hold683/X _3990_/Q VPWR VGND sg13cmos5l_dlygate4sd3_1
XFILLER_40_1003 VPWR VGND sg13cmos5l_decap_8
XFILLER_45_502 VPWR VGND sg13cmos5l_fill_2
XFILLER_32_207 VPWR VGND sg13cmos5l_fill_1
XFILLER_32_218 VPWR VGND sg13cmos5l_decap_8
XFILLER_13_421 VPWR VGND sg13cmos5l_decap_8
XFILLER_43_62 VPWR VGND sg13cmos5l_fill_1
XFILLER_41_774 VPWR VGND sg13cmos5l_fill_1
XFILLER_40_262 VPWR VGND sg13cmos5l_decap_4
XFILLER_40_251 VPWR VGND sg13cmos5l_fill_2
XFILLER_14_988 VPWR VGND sg13cmos5l_decap_8
XFILLER_5_686 VPWR VGND sg13cmos5l_fill_1
XFILLER_0_380 VPWR VGND sg13cmos5l_decap_8
XFILLER_49_863 VPWR VGND sg13cmos5l_decap_8
X_4174__162 _4174_/D VPWR VGND sg13cmos5l_tielo
X_3040_ _3040_/Y _2182_/Y _3040_/A2 _3039_/Y VPWR VGND sg13cmos5l_a21oi_1
XFILLER_36_557 VPWR VGND sg13cmos5l_fill_2
X_3942_ _3942_/Q _4278_/CLK _3942_/D _3942_/RESET_B VPWR VGND sg13cmos5l_dfrbpq_1
X_3873_ _3900_/D _3873_/A0 hold680/X _3873_/S VPWR VGND sg13cmos5l_mux2_1
XFILLER_17_1016 VPWR VGND sg13cmos5l_decap_8
XFILLER_17_1027 VPWR VGND sg13cmos5l_fill_2
X_2824_ _4087_/D _2885_/B _2824_/B VPWR VGND sg13cmos5l_nor2_1
X_2755_ _2755_/Y _4074_/Q _2755_/A2 _2688_/A VPWR VGND sg13cmos5l_o21ai_1
X_2686_ _2687_/A _2190_/A _2756_/A2 _2688_/A VPWR VGND sg13cmos5l_o21ai_1
X_3307_ _3307_/Y _3396_/A _3396_/B VPWR VGND sg13cmos5l_nand2_1
X_3238_ _3238_/Y _4168_/Q _3246_/B VPWR VGND sg13cmos5l_nand2_1
X_3169_ _4151_/D _3169_/A _3223_/B VPWR VGND sg13cmos5l_nor2_1
XFILLER_42_527 VPWR VGND sg13cmos5l_fill_1
XFILLER_27_579 VPWR VGND sg13cmos5l_decap_8
Xfanout22 _3710_/A2 _2755_/A2 VPWR VGND sg13cmos5l_buf_1
Xfanout44 _3715_/B _3618_/Y VPWR VGND sg13cmos5l_buf_1
Xfanout55 _3090_/A _2929_/Y VPWR VGND sg13cmos5l_buf_1
Xfanout33 _2341_/S _2338_/S VPWR VGND sg13cmos5l_buf_1
Xfanout88 _2668_/A _2667_/A1 VPWR VGND sg13cmos5l_buf_1
Xfanout66 _2817_/A hold992/X VPWR VGND sg13cmos5l_buf_1
Xfanout77 _2670_/B2 _2621_/S1 VPWR VGND sg13cmos5l_buf_1
Xfanout99 fanout99/X _4013_/Q VPWR VGND sg13cmos5l_buf_1
XFILLER_6_406 VPWR VGND sg13cmos5l_decap_8
XFILLER_11_969 VPWR VGND sg13cmos5l_decap_8
XFILLER_13_65 VPWR VGND sg13cmos5l_fill_1
XFILLER_46_800 VPWR VGND sg13cmos5l_decap_8
XFILLER_46_877 VPWR VGND sg13cmos5l_decap_8
XFILLER_45_354 VPWR VGND sg13cmos5l_fill_1
XFILLER_45_343 VPWR VGND sg13cmos5l_decap_8
XFILLER_45_376 VPWR VGND sg13cmos5l_decap_4
XFILLER_33_527 VPWR VGND sg13cmos5l_decap_8
XFILLER_9_244 VPWR VGND sg13cmos5l_decap_8
XFILLER_9_255 VPWR VGND sg13cmos5l_fill_1
XFILLER_9_266 VPWR VGND sg13cmos5l_decap_8
XFILLER_6_940 VPWR VGND sg13cmos5l_decap_8
Xclkload14 clkload14/Y _4237_/CLK VPWR VGND sg13cmos5l_inv_2
XFILLER_10_980 VPWR VGND sg13cmos5l_decap_8
X_2540_ _2540_/Y _2775_/A hold886/X _2775_/B VPWR VGND sg13cmos5l_o21ai_1
X_4206__158 _4206_/D VPWR VGND sg13cmos5l_tielo
XFILLER_5_461 VPWR VGND sg13cmos5l_decap_4
X_2471_ _2472_/B _2474_/B _2474_/C VPWR VGND sg13cmos5l_xnor2_1
X_4210_ _4210_/Q _4237_/CLK _4210_/D _4210_/RESET_B VPWR VGND sg13cmos5l_dfrbpq_1
X_4141_ _4141_/Q _4168_/CLK _4141_/D _4141_/RESET_B VPWR VGND sg13cmos5l_dfrbpq_1
XFILLER_23_1020 VPWR VGND sg13cmos5l_decap_8
X_4072_ _4072_/Q _4280_/CLK _4072_/D _4072_/RESET_B VPWR VGND sg13cmos5l_dfrbpq_1
XFILLER_49_671 VPWR VGND sg13cmos5l_fill_1
X_3023_ _3025_/B _3019_/Y _3020_/Y _3022_/Y VPWR VGND sg13cmos5l_o21ai_1
XFILLER_24_527 VPWR VGND sg13cmos5l_decap_4
XFILLER_36_365 VPWR VGND sg13cmos5l_decap_4
X_3925_ _3925_/Q _4278_/CLK _3925_/D _3925_/RESET_B VPWR VGND sg13cmos5l_dfrbpq_1
Xclkload8 clkload8/Y clkload8/A VPWR VGND sg13cmos5l_inv_1
X_3856_ _3885_/D _3865_/A0 hold741/X _3864_/S VPWR VGND sg13cmos5l_mux2_1
X_2807_ _2810_/A _4085_/Q _4108_/Q VPWR VGND sg13cmos5l_nand2_1
X_3787_ _3787_/X _3779_/A _3795_/S _3786_/Y VPWR VGND sg13cmos5l_a21o_1
X_2738_ _2739_/B _2737_/B _2736_/Y _2737_/Y VPWR VGND sg13cmos5l_a21oi_1
X_2669_ _2669_/Y _2668_/A _3950_/Q _2668_/Y VPWR VGND sg13cmos5l_a21oi_1
XFILLER_8_1025 VPWR VGND sg13cmos5l_decap_4
XFILLER_46_118 VPWR VGND sg13cmos5l_fill_2
XFILLER_28_844 VPWR VGND sg13cmos5l_decap_4
XFILLER_43_836 VPWR VGND sg13cmos5l_fill_2
XFILLER_43_814 VPWR VGND sg13cmos5l_decap_4
XFILLER_15_538 VPWR VGND sg13cmos5l_fill_1
XFILLER_11_722 VPWR VGND sg13cmos5l_decap_8
X_4049__213 _4049_/RESET_B VPWR VGND sg13cmos5l_tiehi
XFILLER_11_755 VPWR VGND sg13cmos5l_decap_4
XFILLER_7_737 VPWR VGND sg13cmos5l_decap_4
XFILLER_6_269 VPWR VGND sg13cmos5l_fill_2
XFILLER_6_258 VPWR VGND sg13cmos5l_fill_1
XFILLER_3_965 VPWR VGND sg13cmos5l_decap_8
XFILLER_2_420 VPWR VGND sg13cmos5l_decap_8
XFILLER_2_486 VPWR VGND sg13cmos5l_fill_2
XFILLER_49_83 VPWR VGND sg13cmos5l_decap_8
XFILLER_19_866 VPWR VGND sg13cmos5l_decap_8
XFILLER_34_836 VPWR VGND sg13cmos5l_decap_4
XFILLER_21_519 VPWR VGND sg13cmos5l_decap_4
X_3710_ _3710_/Y _2161_/Y _3710_/A2 _3709_/Y VPWR VGND sg13cmos5l_a21oi_1
X_3641_ _3641_/Y _3645_/A _3645_/B VPWR VGND sg13cmos5l_nor2_1
X_3572_ _3572_/Y _4223_/Q _4194_/Q VPWR VGND sg13cmos5l_xnor2_1
X_2523_ _2698_/A _2750_/B _3547_/A VPWR VGND sg13cmos5l_nand2b_1
X_2454_ _4022_/D _2458_/A _2464_/A _2453_/Y VPWR VGND sg13cmos5l_a21oi_1
XFILLER_39_0 VPWR VGND sg13cmos5l_fill_2
X_2385_ _3980_/D hold798/X _2414_/A0 _2391_/S VPWR VGND sg13cmos5l_mux2_1
X_4124_ _4124_/Q _4173_/CLK _4124_/D _4124_/RESET_B VPWR VGND sg13cmos5l_dfrbpq_1
Xinput1 input1/X rst_n VPWR VGND sg13cmos5l_buf_1
XFILLER_49_490 VPWR VGND sg13cmos5l_decap_8
X_4055_ _4055_/Q _4129_/CLK _4055_/D _4055_/RESET_B VPWR VGND sg13cmos5l_dfrbpq_1
X_3006_ _3006_/Y _3001_/Y _3003_/Y _3005_/Y VPWR VGND sg13cmos5l_o21ai_1
XFILLER_24_324 VPWR VGND sg13cmos5l_decap_8
XFILLER_24_335 VPWR VGND sg13cmos5l_fill_1
XFILLER_25_869 VPWR VGND sg13cmos5l_fill_2
XFILLER_24_346 VPWR VGND sg13cmos5l_fill_2
XFILLER_33_880 VPWR VGND sg13cmos5l_fill_1
X_4089__571 _4089_/RESET_B VPWR VGND sg13cmos5l_tiehi
X_3908_ _3908_/Q _4278_/CLK _3908_/D _3908_/RESET_B VPWR VGND sg13cmos5l_dfrbpq_1
X_3839_ _3843_/B _2247_/B _4269_/Q _4277_/Q VPWR VGND sg13cmos5l_o21ai_1
XFILLER_20_552 VPWR VGND sg13cmos5l_fill_2
XFILLER_4_729 VPWR VGND sg13cmos5l_decap_8
XFILLER_0_935 VPWR VGND sg13cmos5l_decap_8
XFILLER_19_118 VPWR VGND sg13cmos5l_fill_2
XFILLER_43_600 VPWR VGND sg13cmos5l_decap_4
XFILLER_43_633 VPWR VGND sg13cmos5l_fill_2
XFILLER_42_110 VPWR VGND sg13cmos5l_decap_8
XFILLER_27_173 VPWR VGND sg13cmos5l_decap_8
XFILLER_35_41 VPWR VGND sg13cmos5l_decap_8
XFILLER_37_1008 VPWR VGND sg13cmos5l_decap_8
XFILLER_31_828 VPWR VGND sg13cmos5l_fill_2
XFILLER_30_349 VPWR VGND sg13cmos5l_fill_2
XFILLER_11_552 VPWR VGND sg13cmos5l_fill_1
XFILLER_3_762 VPWR VGND sg13cmos5l_decap_8
X_2170_ _2170_/Y _2170_/A VPWR VGND sg13cmos5l_inv_1
Xheichips26_dna_sequencer_139 uio_oe[6] VPWR VGND sg13cmos5l_tielo
XFILLER_47_994 VPWR VGND sg13cmos5l_decap_8
XFILLER_46_482 VPWR VGND sg13cmos5l_fill_1
XFILLER_34_644 VPWR VGND sg13cmos5l_fill_2
XFILLER_21_327 VPWR VGND sg13cmos5l_fill_1
XFILLER_30_883 VPWR VGND sg13cmos5l_decap_8
X_3624_ _3624_/X _4260_/Q _4239_/Q VPWR VGND sg13cmos5l_and2_1
X_3555_ _4227_/D _3555_/A _3555_/B VPWR VGND sg13cmos5l_and2_1
X_3486_ _3600_/A hold999/X _3764_/C _3457_/Y _3459_/Y _3782_/A VPWR VGND sg13cmos5l_a221oi_1
X_2506_ _2695_/A _2688_/B _2506_/B VPWR VGND sg13cmos5l_nand2_1
X_2437_ _2437_/Y _2434_/A _4016_/Q _2441_/B _2491_/B VPWR VGND sg13cmos5l_a22oi_1
X_2368_ _3966_/D _2417_/A0 hold672/X _2371_/S VPWR VGND sg13cmos5l_mux2_1
X_2299_ _3908_/D _3873_/A0 hold678/X _2299_/S VPWR VGND sg13cmos5l_mux2_1
X_4107_ _4107_/Q _4136_/CLK _4107_/D _4107_/RESET_B VPWR VGND sg13cmos5l_dfrbpq_1
X_4038_ _4038_/Q clkload4/A _4038_/D _4038_/RESET_B VPWR VGND sg13cmos5l_dfrbpq_1
XFILLER_37_482 VPWR VGND sg13cmos5l_fill_1
XFILLER_25_611 VPWR VGND sg13cmos5l_fill_2
XFILLER_12_305 VPWR VGND sg13cmos5l_fill_1
XFILLER_25_699 VPWR VGND sg13cmos5l_decap_4
X_4128__516 _4128_/RESET_B VPWR VGND sg13cmos5l_tiehi
XFILLER_21_21 VPWR VGND sg13cmos5l_fill_1
XFILLER_21_54 VPWR VGND sg13cmos5l_decap_8
XFILLER_0_732 VPWR VGND sg13cmos5l_decap_8
XFILLER_47_213 VPWR VGND sg13cmos5l_fill_1
XFILLER_48_769 VPWR VGND sg13cmos5l_decap_8
XFILLER_16_611 VPWR VGND sg13cmos5l_decap_8
XFILLER_28_493 VPWR VGND sg13cmos5l_decap_4
XFILLER_44_953 VPWR VGND sg13cmos5l_decap_8
XFILLER_30_135 VPWR VGND sg13cmos5l_decap_8
XFILLER_8_821 VPWR VGND sg13cmos5l_decap_4
XFILLER_8_810 VPWR VGND sg13cmos5l_decap_4
XFILLER_11_382 VPWR VGND sg13cmos5l_fill_1
XFILLER_8_887 VPWR VGND sg13cmos5l_fill_2
XFILLER_7_56 VPWR VGND sg13cmos5l_fill_1
XFILLER_7_386 VPWR VGND sg13cmos5l_decap_8
X_3340_ _3342_/B _3396_/C _3396_/D VPWR VGND sg13cmos5l_nand2_1
X_3271_ _4173_/D _3255_/Y _3262_/X _3270_/Y VPWR VGND sg13cmos5l_a21oi_1
X_2222_ _2222_/Y _2222_/A VPWR VGND sg13cmos5l_inv_1
Xhold1009 _3244_/A _3243_/Y VPWR VGND sg13cmos5l_dlygate4sd3_1
X_4079__581 _4079_/RESET_B VPWR VGND sg13cmos5l_tiehi
XFILLER_39_747 VPWR VGND sg13cmos5l_decap_8
XFILLER_47_791 VPWR VGND sg13cmos5l_decap_8
XFILLER_35_942 VPWR VGND sg13cmos5l_decap_8
XFILLER_34_496 VPWR VGND sg13cmos5l_decap_8
X_2986_ _2994_/C _2985_/Y _2986_/B _2986_/C VPWR VGND sg13cmos5l_nand3b_1
X_4086__574 _4086_/RESET_B VPWR VGND sg13cmos5l_tiehi
X_3607_ _3608_/B _3575_/Y _3583_/X _3600_/Y _3604_/A VPWR VGND sg13cmos5l_a22oi_1
Xhold821 _3560_/A _4205_/Q VPWR VGND sg13cmos5l_dlygate4sd3_1
Xhold810 hold810/X _3996_/Q VPWR VGND sg13cmos5l_dlygate4sd3_1
X_3538_ _3539_/S _4221_/Q _3538_/B _3538_/C VPWR VGND sg13cmos5l_or3_1
Xhold832 _2167_/A _4247_/Q VPWR VGND sg13cmos5l_dlygate4sd3_1
Xhold854 _4122_/D _3027_/Y VPWR VGND sg13cmos5l_dlygate4sd3_1
Xhold843 hold843/X _2532_/Y VPWR VGND sg13cmos5l_dlygate4sd3_1
Xhold887 _2231_/A _4068_/Q VPWR VGND sg13cmos5l_dlygate4sd3_1
Xhold865 _2203_/A _4084_/Q VPWR VGND sg13cmos5l_dlygate4sd3_1
Xhold876 _2208_/A _4204_/Q VPWR VGND sg13cmos5l_dlygate4sd3_1
Xhold898 _4123_/D _3029_/Y VPWR VGND sg13cmos5l_dlygate4sd3_1
X_3469_ _3469_/Y _4208_/Q _4207_/Q VPWR VGND sg13cmos5l_xnor2_1
XFILLER_29_202 VPWR VGND sg13cmos5l_fill_1
XFILLER_29_224 VPWR VGND sg13cmos5l_fill_2
X_4093__567 _4093_/RESET_B VPWR VGND sg13cmos5l_tiehi
XFILLER_41_923 VPWR VGND sg13cmos5l_fill_2
XFILLER_25_485 VPWR VGND sg13cmos5l_fill_2
XFILLER_9_607 VPWR VGND sg13cmos5l_decap_8
XFILLER_41_978 VPWR VGND sg13cmos5l_decap_8
XFILLER_40_466 VPWR VGND sg13cmos5l_fill_2
XFILLER_12_146 VPWR VGND sg13cmos5l_decap_8
XFILLER_10_1022 VPWR VGND sg13cmos5l_decap_8
XFILLER_0_551 VPWR VGND sg13cmos5l_decap_8
XFILLER_17_920 VPWR VGND sg13cmos5l_decap_8
XFILLER_17_931 VPWR VGND sg13cmos5l_fill_1
XFILLER_35_227 VPWR VGND sg13cmos5l_decap_8
XFILLER_16_430 VPWR VGND sg13cmos5l_decap_8
XFILLER_17_953 VPWR VGND sg13cmos5l_decap_8
XFILLER_28_290 VPWR VGND sg13cmos5l_decap_8
X_2840_ _2892_/A _2838_/X _2839_/Y _2836_/Y VPWR VGND sg13cmos5l_a21o_1
X_2771_ _2772_/B _2771_/A _2773_/B VPWR VGND sg13cmos5l_xnor2_1
X_4064__179 _4064_/D VPWR VGND sg13cmos5l_tielo
X_3323_ _3323_/X _4171_/Q _3323_/B VPWR VGND sg13cmos5l_or2_1
XFILLER_39_511 VPWR VGND sg13cmos5l_decap_8
X_3254_ _3254_/X _3254_/A _3254_/B _3254_/C VPWR VGND sg13cmos5l_or3_1
XFILLER_39_522 VPWR VGND sg13cmos5l_decap_8
X_2205_ _3682_/A _4262_/Q VPWR VGND sg13cmos5l_inv_1
X_4118__526 _4118_/RESET_B VPWR VGND sg13cmos5l_tiehi
X_3185_ _3185_/Y _4126_/Q _3185_/B VPWR VGND sg13cmos5l_nor2_1
XFILLER_39_599 VPWR VGND sg13cmos5l_decap_8
XFILLER_26_205 VPWR VGND sg13cmos5l_decap_8
XFILLER_26_216 VPWR VGND sg13cmos5l_fill_2
XFILLER_41_219 VPWR VGND sg13cmos5l_decap_8
XFILLER_22_422 VPWR VGND sg13cmos5l_fill_2
XFILLER_33_1011 VPWR VGND sg13cmos5l_decap_8
XFILLER_22_488 VPWR VGND sg13cmos5l_decap_8
X_2969_ _4115_/D _3090_/A _3064_/A VPWR VGND sg13cmos5l_nor2_1
X_4125__519 _4125_/RESET_B VPWR VGND sg13cmos5l_tiehi
XFILLER_2_849 VPWR VGND sg13cmos5l_decap_8
Xhold640 _4225_/D _3553_/Y VPWR VGND sg13cmos5l_dlygate4sd3_1
Xhold662 hold662/X _3974_/Q VPWR VGND sg13cmos5l_dlygate4sd3_1
Xhold651 _4073_/D _2754_/Y VPWR VGND sg13cmos5l_dlygate4sd3_1
Xhold673 hold673/X _3904_/Q VPWR VGND sg13cmos5l_dlygate4sd3_1
Xhold684 hold684/X _3960_/Q VPWR VGND sg13cmos5l_dlygate4sd3_1
Xhold695 hold695/X _3923_/Q VPWR VGND sg13cmos5l_dlygate4sd3_1
XFILLER_33_709 VPWR VGND sg13cmos5l_fill_1
XFILLER_14_923 VPWR VGND sg13cmos5l_fill_1
XFILLER_14_967 VPWR VGND sg13cmos5l_decap_8
XFILLER_13_499 VPWR VGND sg13cmos5l_fill_2
XFILLER_4_186 VPWR VGND sg13cmos5l_fill_2
XFILLER_49_842 VPWR VGND sg13cmos5l_decap_8
X_4076__584 _4076_/RESET_B VPWR VGND sg13cmos5l_tiehi
XFILLER_36_525 VPWR VGND sg13cmos5l_fill_1
XFILLER_16_260 VPWR VGND sg13cmos5l_decap_8
X_3941_ _3941_/Q clkload2/A _3941_/D _3941_/RESET_B VPWR VGND sg13cmos5l_dfrbpq_1
X_3872_ _3899_/D _3872_/A0 hold671/X _3872_/S VPWR VGND sg13cmos5l_mux2_1
X_2823_ _2888_/A _2894_/A VPWR VGND sg13cmos5l_inv_1
XFILLER_31_285 VPWR VGND sg13cmos5l_decap_8
X_2754_ _2754_/Y _2191_/Y _3035_/A2 _2753_/Y VPWR VGND sg13cmos5l_a21oi_1
X_4083__577 _4083_/RESET_B VPWR VGND sg13cmos5l_tiehi
X_2685_ _4051_/D _2756_/A2 _2693_/B _2684_/Y VPWR VGND sg13cmos5l_a21oi_1
X_3306_ _3396_/B _3298_/A _3312_/B _3304_/X VPWR VGND sg13cmos5l_o21ai_1
X_3237_ _3260_/C _4168_/Q _3246_/B _3257_/A VPWR VGND sg13cmos5l_o21ai_1
XFILLER_39_363 VPWR VGND sg13cmos5l_decap_4
XFILLER_27_536 VPWR VGND sg13cmos5l_fill_1
X_3168_ _3223_/B _3152_/A _3147_/A _3167_/Y VPWR VGND sg13cmos5l_a21oi_1
XFILLER_39_396 VPWR VGND sg13cmos5l_decap_8
X_3099_ _3099_/Y _3099_/A VPWR VGND sg13cmos5l_inv_1
XFILLER_23_731 VPWR VGND sg13cmos5l_decap_8
XFILLER_23_742 VPWR VGND sg13cmos5l_fill_2
Xfanout56 _2885_/B _2792_/Y VPWR VGND sg13cmos5l_buf_1
Xfanout45 _3561_/B _3540_/A VPWR VGND sg13cmos5l_buf_1
XFILLER_23_764 VPWR VGND sg13cmos5l_decap_4
Xfanout23 _3706_/A2 _2755_/A2 VPWR VGND sg13cmos5l_buf_1
Xfanout34 _2321_/S _2318_/S VPWR VGND sg13cmos5l_buf_1
XFILLER_10_425 VPWR VGND sg13cmos5l_fill_1
Xfanout78 _2621_/S1 fanout84/X VPWR VGND sg13cmos5l_buf_1
Xfanout89 _2667_/A1 fanout99/X VPWR VGND sg13cmos5l_buf_1
Xfanout67 _2883_/A hold965/X VPWR VGND sg13cmos5l_buf_1
XFILLER_10_458 VPWR VGND sg13cmos5l_decap_8
XFILLER_8_4 VPWR VGND sg13cmos5l_decap_8
XFILLER_2_646 VPWR VGND sg13cmos5l_fill_2
XFILLER_49_105 VPWR VGND sg13cmos5l_fill_2
XFILLER_18_514 VPWR VGND sg13cmos5l_decap_8
XFILLER_46_856 VPWR VGND sg13cmos5l_decap_8
XFILLER_18_569 VPWR VGND sg13cmos5l_fill_1
XFILLER_41_561 VPWR VGND sg13cmos5l_decap_8
XFILLER_9_234 VPWR VGND sg13cmos5l_decap_4
XFILLER_14_797 VPWR VGND sg13cmos5l_fill_2
X_4108__536 _4108_/RESET_B VPWR VGND sg13cmos5l_tiehi
Xclkload15 clkload15/Y _4277_/CLK VPWR VGND sg13cmos5l_inv_2
XFILLER_6_996 VPWR VGND sg13cmos5l_decap_8
X_2470_ _2470_/Y _2278_/A _2468_/Y _2469_/Y VPWR VGND sg13cmos5l_a21oi_1
XFILLER_5_495 VPWR VGND sg13cmos5l_decap_8
X_4140_ _4140_/Q _4193_/CLK _4140_/D _4140_/RESET_B VPWR VGND sg13cmos5l_dfrbpq_1
XFILLER_37_801 VPWR VGND sg13cmos5l_decap_4
X_4071_ _4071_/Q _4277_/CLK _4071_/D _4071_/RESET_B VPWR VGND sg13cmos5l_dfrbpq_1
XFILLER_49_694 VPWR VGND sg13cmos5l_decap_8
XFILLER_37_834 VPWR VGND sg13cmos5l_fill_2
X_3022_ _3022_/Y _4124_/Q _3011_/Y _3021_/Y _3032_/B VPWR VGND sg13cmos5l_a22oi_1
XFILLER_37_867 VPWR VGND sg13cmos5l_fill_2
XFILLER_37_845 VPWR VGND sg13cmos5l_decap_8
X_4115__529 _4115_/RESET_B VPWR VGND sg13cmos5l_tiehi
XFILLER_36_322 VPWR VGND sg13cmos5l_decap_8
XFILLER_36_344 VPWR VGND sg13cmos5l_decap_8
XFILLER_24_506 VPWR VGND sg13cmos5l_decap_8
X_3924_ _3924_/Q clkload2/A _3924_/D _3924_/RESET_B VPWR VGND sg13cmos5l_dfrbpq_1
X_3855_ _3862_/S _4031_/Q _4030_/Q _3855_/C _3855_/D VPWR VGND sg13cmos5l_nand4_1
Xclkload9 clkload9/Y clkload9/A VPWR VGND sg13cmos5l_inv_1
X_2806_ _2806_/Y _2806_/A _2805_/Y VPWR VGND sg13cmos5l_nor2b_1
X_3786_ _3786_/Y _3765_/X _3766_/Y _3780_/Y _3783_/Y _3784_/Y VPWR VGND sg13cmos5l_a221oi_1
XFILLER_30_1025 VPWR VGND sg13cmos5l_decap_4
X_2737_ _2737_/Y _2737_/A _2737_/B VPWR VGND sg13cmos5l_nor2_1
X_2668_ _2668_/Y _2668_/A _3967_/Q VPWR VGND sg13cmos5l_nor2b_1
X_2599_ _2599_/Y _2634_/A _3949_/Q _2598_/Y VPWR VGND sg13cmos5l_a21oi_1
XFILLER_8_1004 VPWR VGND sg13cmos5l_decap_8
X_4269_ _4269_/Q _4277_/CLK _4269_/D _4269_/RESET_B VPWR VGND sg13cmos5l_dfrbpq_1
XFILLER_27_300 VPWR VGND sg13cmos5l_decap_8
XFILLER_28_834 VPWR VGND sg13cmos5l_fill_2
XFILLER_39_193 VPWR VGND sg13cmos5l_fill_1
XFILLER_27_333 VPWR VGND sg13cmos5l_fill_1
XFILLER_11_701 VPWR VGND sg13cmos5l_decap_4
XFILLER_23_572 VPWR VGND sg13cmos5l_fill_2
XFILLER_7_716 VPWR VGND sg13cmos5l_decap_8
XFILLER_10_244 VPWR VGND sg13cmos5l_decap_8
XFILLER_6_204 VPWR VGND sg13cmos5l_fill_2
XFILLER_3_944 VPWR VGND sg13cmos5l_decap_8
XFILLER_46_1010 VPWR VGND sg13cmos5l_decap_8
XFILLER_49_73 VPWR VGND sg13cmos5l_fill_1
XFILLER_46_653 VPWR VGND sg13cmos5l_fill_1
XFILLER_34_804 VPWR VGND sg13cmos5l_fill_2
XFILLER_41_391 VPWR VGND sg13cmos5l_decap_8
XFILLER_14_1009 VPWR VGND sg13cmos5l_decap_8
X_3640_ _3645_/B _4243_/Q _3640_/B VPWR VGND sg13cmos5l_xor2_1
X_3571_ _3571_/Y _4225_/Q _4196_/Q VPWR VGND sg13cmos5l_nand2_1
X_2522_ _4042_/D _2522_/A _2513_/Y VPWR VGND sg13cmos5l_nor2b_1
X_2453_ _2453_/Y _2458_/A _2464_/A _2466_/A VPWR VGND sg13cmos5l_o21ai_1
X_2384_ _3979_/D hold677/X _2413_/A0 _2391_/S VPWR VGND sg13cmos5l_mux2_1
X_4123_ _4123_/Q _4193_/CLK _4123_/D _4123_/RESET_B VPWR VGND sg13cmos5l_dfrbpq_1
Xinput2 input2/X ui_in[0] VPWR VGND sg13cmos5l_buf_1
X_4054_ _4054_/Q _4129_/CLK _4054_/D _4054_/RESET_B VPWR VGND sg13cmos5l_dfrbpq_1
X_3005_ _3005_/Y _4142_/Q _3005_/B VPWR VGND sg13cmos5l_nand2_1
XFILLER_24_303 VPWR VGND sg13cmos5l_decap_8
X_4189__449 _4189_/RESET_B VPWR VGND sg13cmos5l_tiehi
XFILLER_33_892 VPWR VGND sg13cmos5l_decap_8
X_3907_ _3907_/Q clkload2/A _3907_/D _3907_/RESET_B VPWR VGND sg13cmos5l_dfrbpq_1
XFILLER_32_391 VPWR VGND sg13cmos5l_fill_1
X_3838_ _4269_/D _4272_/D _3838_/B VPWR VGND sg13cmos5l_nor2_1
XFILLER_3_218 VPWR VGND sg13cmos5l_fill_1
XFILLER_3_207 VPWR VGND sg13cmos5l_decap_8
X_3769_ _3770_/B _3769_/A _3775_/A VPWR VGND sg13cmos5l_and2_1
XFILLER_0_914 VPWR VGND sg13cmos5l_decap_8
XFILLER_19_108 VPWR VGND sg13cmos5l_fill_1
XFILLER_28_631 VPWR VGND sg13cmos5l_fill_2
XFILLER_16_815 VPWR VGND sg13cmos5l_decap_8
XFILLER_43_645 VPWR VGND sg13cmos5l_fill_1
XFILLER_43_623 VPWR VGND sg13cmos5l_fill_2
XFILLER_16_837 VPWR VGND sg13cmos5l_fill_1
XFILLER_27_163 VPWR VGND sg13cmos5l_fill_1
XFILLER_43_689 VPWR VGND sg13cmos5l_decap_8
XFILLER_35_86 VPWR VGND sg13cmos5l_decap_8
X_4105__539 _4105_/RESET_B VPWR VGND sg13cmos5l_tiehi
XFILLER_38_439 VPWR VGND sg13cmos5l_decap_8
X_4253__230 _4253_/RESET_B VPWR VGND sg13cmos5l_tiehi
XFILLER_20_1013 VPWR VGND sg13cmos5l_decap_8
XFILLER_47_973 VPWR VGND sg13cmos5l_decap_8
XFILLER_46_461 VPWR VGND sg13cmos5l_decap_8
XFILLER_46_494 VPWR VGND sg13cmos5l_decap_8
XFILLER_18_163 VPWR VGND sg13cmos5l_decap_8
XFILLER_18_185 VPWR VGND sg13cmos5l_decap_8
XFILLER_19_697 VPWR VGND sg13cmos5l_decap_8
XFILLER_30_862 VPWR VGND sg13cmos5l_fill_1
X_3623_ _3623_/Y _3623_/A VPWR VGND sg13cmos5l_inv_1
X_3554_ _4226_/D _3556_/A _3554_/B VPWR VGND sg13cmos5l_and2_1
X_3485_ _3782_/A _3531_/A _3485_/B VPWR VGND sg13cmos5l_nor2_1
X_2505_ _2506_/B _2505_/A _2505_/B VPWR VGND sg13cmos5l_and2_1
X_2436_ _2441_/B input4/X input2/X VPWR VGND sg13cmos5l_and2_1
X_2367_ _3965_/D _2416_/A0 hold805/X _2371_/S VPWR VGND sg13cmos5l_mux2_1
XFILLER_29_406 VPWR VGND sg13cmos5l_decap_4
X_4106_ _4106_/Q _4136_/CLK _4106_/D _4106_/RESET_B VPWR VGND sg13cmos5l_dfrbpq_1
X_2298_ _3907_/D _3872_/A0 hold654/X _2301_/S VPWR VGND sg13cmos5l_mux2_1
XFILLER_38_984 VPWR VGND sg13cmos5l_decap_8
X_4037_ _4037_/Q clkload4/A _4037_/D _4037_/RESET_B VPWR VGND sg13cmos5l_dfrbpq_1
XFILLER_13_807 VPWR VGND sg13cmos5l_fill_2
XFILLER_24_122 VPWR VGND sg13cmos5l_fill_1
XFILLER_12_317 VPWR VGND sg13cmos5l_decap_8
XFILLER_25_678 VPWR VGND sg13cmos5l_decap_8
XFILLER_0_711 VPWR VGND sg13cmos5l_decap_8
XFILLER_43_1024 VPWR VGND sg13cmos5l_decap_4
XFILLER_0_788 VPWR VGND sg13cmos5l_decap_8
XFILLER_48_748 VPWR VGND sg13cmos5l_decap_8
XFILLER_29_940 VPWR VGND sg13cmos5l_decap_8
XFILLER_28_450 VPWR VGND sg13cmos5l_decap_8
XFILLER_44_932 VPWR VGND sg13cmos5l_decap_8
XFILLER_12_840 VPWR VGND sg13cmos5l_decap_8
XFILLER_8_844 VPWR VGND sg13cmos5l_decap_8
XFILLER_7_354 VPWR VGND sg13cmos5l_decap_8
XFILLER_7_68 VPWR VGND sg13cmos5l_decap_8
X_3270_ _3270_/Y _3258_/Y _3262_/X _3094_/Y VPWR VGND sg13cmos5l_o21ai_1
X_4179__459 _4179_/RESET_B VPWR VGND sg13cmos5l_tiehi
X_2221_ _3394_/A _2221_/A VPWR VGND sg13cmos5l_inv_1
XFILLER_23_4 VPWR VGND sg13cmos5l_fill_2
XFILLER_47_770 VPWR VGND sg13cmos5l_decap_8
XFILLER_35_921 VPWR VGND sg13cmos5l_decap_8
XFILLER_35_998 VPWR VGND sg13cmos5l_decap_8
X_2985_ _2985_/Y _2976_/A _2976_/B _2981_/Y _2983_/X _2984_/X VPWR VGND sg13cmos5l_a221oi_1
XFILLER_21_169 VPWR VGND sg13cmos5l_decap_8
XFILLER_30_692 VPWR VGND sg13cmos5l_fill_2
Xhold811 hold811/X _3982_/Q VPWR VGND sg13cmos5l_dlygate4sd3_1
X_3606_ _3608_/A _3593_/Y _3598_/Y _3605_/Y VPWR VGND sg13cmos5l_o21ai_1
Xhold800 hold800/X _3941_/Q VPWR VGND sg13cmos5l_dlygate4sd3_1
X_3537_ _3538_/C _3545_/B _3537_/B VPWR VGND sg13cmos5l_nor2_1
Xhold833 _4034_/D _2484_/Y VPWR VGND sg13cmos5l_dlygate4sd3_1
Xhold822 _3702_/B _4249_/Q VPWR VGND sg13cmos5l_dlygate4sd3_1
Xhold855 _2422_/A _4040_/Q VPWR VGND sg13cmos5l_dlygate4sd3_1
Xhold844 _4043_/D _2534_/Y VPWR VGND sg13cmos5l_dlygate4sd3_1
Xhold888 _4068_/D _2747_/Y VPWR VGND sg13cmos5l_dlygate4sd3_1
Xhold877 hold877/X _4218_/Q VPWR VGND sg13cmos5l_dlygate4sd3_1
Xhold866 _3704_/B _4222_/Q VPWR VGND sg13cmos5l_dlygate4sd3_1
XFILLER_27_1008 VPWR VGND sg13cmos5l_decap_8
X_3468_ _3468_/X _3468_/A _3468_/B VPWR VGND sg13cmos5l_xor2_1
Xhold899 hold899/X _4186_/Q VPWR VGND sg13cmos5l_dlygate4sd3_1
X_3399_ _3399_/Y _3311_/B _3428_/A _3396_/Y _3397_/Y _3398_/Y VPWR VGND sg13cmos5l_a221oi_1
X_2419_ _4010_/D _2419_/A0 hold815/X _2421_/S VPWR VGND sg13cmos5l_mux2_1
XFILLER_38_770 VPWR VGND sg13cmos5l_fill_2
XFILLER_26_932 VPWR VGND sg13cmos5l_fill_1
XFILLER_44_239 VPWR VGND sg13cmos5l_decap_4
XFILLER_41_902 VPWR VGND sg13cmos5l_decap_8
XFILLER_26_987 VPWR VGND sg13cmos5l_decap_8
XFILLER_41_957 VPWR VGND sg13cmos5l_decap_8
XFILLER_5_803 VPWR VGND sg13cmos5l_decap_8
XFILLER_4_302 VPWR VGND sg13cmos5l_fill_2
XFILLER_10_1001 VPWR VGND sg13cmos5l_decap_8
XFILLER_4_357 VPWR VGND sg13cmos5l_decap_8
XFILLER_4_335 VPWR VGND sg13cmos5l_decap_8
XFILLER_0_574 VPWR VGND sg13cmos5l_fill_1
XFILLER_16_442 VPWR VGND sg13cmos5l_decap_8
XFILLER_32_935 VPWR VGND sg13cmos5l_decap_8
XFILLER_31_445 VPWR VGND sg13cmos5l_decap_8
X_2770_ _2779_/A _2770_/A _2770_/B VPWR VGND sg13cmos5l_nor2_1
XFILLER_8_641 VPWR VGND sg13cmos5l_fill_2
X_3322_ _3323_/B _4170_/Q _4149_/Q _4148_/Q VPWR VGND sg13cmos5l_nor3_1
X_3253_ _3254_/C _3253_/A _3253_/B VPWR VGND sg13cmos5l_nor2_1
X_2204_ _2204_/Y _4263_/Q VPWR VGND sg13cmos5l_inv_1
X_3184_ _3184_/Y _3184_/A _3184_/B VPWR VGND sg13cmos5l_nand2_1
XFILLER_39_545 VPWR VGND sg13cmos5l_fill_1
X_4192__445 _4192_/RESET_B VPWR VGND sg13cmos5l_tiehi
XFILLER_26_228 VPWR VGND sg13cmos5l_decap_4
XFILLER_34_250 VPWR VGND sg13cmos5l_decap_8
XFILLER_23_968 VPWR VGND sg13cmos5l_decap_8
XFILLER_23_979 VPWR VGND sg13cmos5l_fill_2
X_2968_ _3064_/A _2964_/A _3147_/A _2940_/Y _2959_/A VPWR VGND sg13cmos5l_a22oi_1
X_2899_ _2916_/B _2897_/Y _2898_/Y _2896_/Y VPWR VGND sg13cmos5l_a21oi_1
Xhold630 _2271_/A _4268_/Q VPWR VGND sg13cmos5l_dlygate4sd3_1
Xhold663 hold663/X _4037_/Q VPWR VGND sg13cmos5l_dlygate4sd3_1
XFILLER_2_828 VPWR VGND sg13cmos5l_decap_8
XFILLER_1_316 VPWR VGND sg13cmos5l_fill_1
Xhold652 _3547_/B _4190_/Q VPWR VGND sg13cmos5l_dlygate4sd3_1
Xhold641 _2424_/A _4041_/Q VPWR VGND sg13cmos5l_dlygate4sd3_1
Xhold674 _2884_/A _4083_/Q VPWR VGND sg13cmos5l_dlygate4sd3_1
Xhold696 hold696/X _3909_/Q VPWR VGND sg13cmos5l_dlygate4sd3_1
Xhold685 hold685/X _3988_/Q VPWR VGND sg13cmos5l_dlygate4sd3_1
XFILLER_45_548 VPWR VGND sg13cmos5l_decap_8
XFILLER_17_239 VPWR VGND sg13cmos5l_fill_2
XFILLER_27_76 VPWR VGND sg13cmos5l_decap_4
XFILLER_14_902 VPWR VGND sg13cmos5l_decap_8
XFILLER_14_946 VPWR VGND sg13cmos5l_decap_8
XFILLER_40_231 VPWR VGND sg13cmos5l_decap_4
X_4169__469 _4169_/RESET_B VPWR VGND sg13cmos5l_tiehi
XFILLER_43_75 VPWR VGND sg13cmos5l_decap_4
XFILLER_41_787 VPWR VGND sg13cmos5l_fill_2
XFILLER_9_427 VPWR VGND sg13cmos5l_decap_8
XFILLER_9_438 VPWR VGND sg13cmos5l_fill_2
XFILLER_5_622 VPWR VGND sg13cmos5l_decap_8
XFILLER_5_600 VPWR VGND sg13cmos5l_decap_4
XFILLER_5_666 VPWR VGND sg13cmos5l_fill_1
XFILLER_4_36 VPWR VGND sg13cmos5l_fill_2
XFILLER_49_821 VPWR VGND sg13cmos5l_decap_8
XFILLER_1_883 VPWR VGND sg13cmos5l_decap_8
XFILLER_49_898 VPWR VGND sg13cmos5l_decap_8
X_3940_ _3940_/Q _4280_/CLK _3940_/D _3940_/RESET_B VPWR VGND sg13cmos5l_dfrbpq_1
XFILLER_44_592 VPWR VGND sg13cmos5l_decap_4
X_3871_ _3898_/D _3871_/A0 hold718/X _3872_/S VPWR VGND sg13cmos5l_mux2_1
XFILLER_31_220 VPWR VGND sg13cmos5l_decap_8
XFILLER_31_231 VPWR VGND sg13cmos5l_fill_1
X_2822_ _2894_/A _2217_/A _2799_/B _2821_/Y VPWR VGND sg13cmos5l_a21oi_1
XFILLER_31_275 VPWR VGND sg13cmos5l_fill_1
X_2753_ _2753_/Y _4073_/Q _3035_/A2 _2792_/B VPWR VGND sg13cmos5l_o21ai_1
XFILLER_8_460 VPWR VGND sg13cmos5l_decap_8
XFILLER_9_983 VPWR VGND sg13cmos5l_decap_8
X_2684_ _2684_/Y _2693_/A _2756_/A2 _2688_/A VPWR VGND sg13cmos5l_o21ai_1
X_4124__520 _4124_/RESET_B VPWR VGND sg13cmos5l_tiehi
X_3305_ _3396_/A _3305_/A _3305_/B _3305_/C VPWR VGND sg13cmos5l_nand3_1
X_3236_ _3257_/A _4167_/Q _3246_/B _3250_/A VPWR VGND sg13cmos5l_a21o_1
X_3877__444 _3877_/RESET_B VPWR VGND sg13cmos5l_tiehi
X_3167_ _3167_/Y _3167_/A _3167_/B VPWR VGND sg13cmos5l_nor2_1
X_3098_ _3099_/A _4147_/Q _3098_/B VPWR VGND sg13cmos5l_xnor2_1
XFILLER_42_507 VPWR VGND sg13cmos5l_fill_2
XFILLER_35_581 VPWR VGND sg13cmos5l_decap_8
Xfanout46 _3540_/A _3451_/Y VPWR VGND sg13cmos5l_buf_1
XFILLER_22_231 VPWR VGND sg13cmos5l_decap_8
Xfanout35 _2301_/S _2299_/S VPWR VGND sg13cmos5l_buf_1
Xfanout24 _3040_/A2 _2755_/A2 VPWR VGND sg13cmos5l_buf_1
Xfanout79 _2643_/S1 fanout84/X VPWR VGND sg13cmos5l_buf_1
Xfanout57 _2646_/A _2675_/C1 VPWR VGND sg13cmos5l_buf_1
Xfanout68 _2422_/B _4039_/Q VPWR VGND sg13cmos5l_buf_1
XFILLER_10_437 VPWR VGND sg13cmos5l_decap_8
XFILLER_10_448 VPWR VGND sg13cmos5l_fill_2
XFILLER_13_34 VPWR VGND sg13cmos5l_fill_2
XFILLER_2_669 VPWR VGND sg13cmos5l_decap_4
XFILLER_49_128 VPWR VGND sg13cmos5l_fill_1
XFILLER_49_117 VPWR VGND sg13cmos5l_decap_8
XFILLER_1_168 VPWR VGND sg13cmos5l_fill_1
XFILLER_38_31 VPWR VGND sg13cmos5l_decap_8
XFILLER_46_835 VPWR VGND sg13cmos5l_decap_8
XFILLER_13_253 VPWR VGND sg13cmos5l_decap_4
XFILLER_41_595 VPWR VGND sg13cmos5l_fill_2
XFILLER_13_286 VPWR VGND sg13cmos5l_decap_4
Xclkload16 clkload16/X _4137_/CLK VPWR VGND sg13cmos5l_buf_8
XFILLER_5_430 VPWR VGND sg13cmos5l_decap_4
XFILLER_6_975 VPWR VGND sg13cmos5l_decap_8
X_4070_ _4070_/Q _4136_/CLK _4070_/D _4070_/RESET_B VPWR VGND sg13cmos5l_dfrbpq_1
XFILLER_49_662 VPWR VGND sg13cmos5l_decap_8
X_3021_ _3021_/Y _3217_/A _3216_/A VPWR VGND sg13cmos5l_nand2b_1
XFILLER_36_312 VPWR VGND sg13cmos5l_fill_1
XFILLER_17_592 VPWR VGND sg13cmos5l_decap_4
X_3923_ _3923_/Q _4280_/CLK _3923_/D _3923_/RESET_B VPWR VGND sg13cmos5l_dfrbpq_1
X_3854_ _3884_/D hold793/X _3854_/A1 _3854_/S VPWR VGND sg13cmos5l_mux2_1
X_2805_ _2805_/Y _4086_/Q _4085_/Q _4087_/Q VPWR VGND sg13cmos5l_o21ai_1
XFILLER_20_735 VPWR VGND sg13cmos5l_decap_4
X_3785_ _3795_/S _3780_/Y _3783_/Y _3784_/Y VPWR VGND sg13cmos5l_a21o_1
XFILLER_30_1004 VPWR VGND sg13cmos5l_decap_8
X_2736_ _2736_/Y _2885_/A _2882_/A VPWR VGND sg13cmos5l_nand2_1
X_2667_ _2667_/Y _2667_/A1 _3984_/Q _2670_/B2 VPWR VGND sg13cmos5l_a21oi_1
X_2598_ _2598_/Y _2634_/A _3966_/Q VPWR VGND sg13cmos5l_nor2b_1
X_4268_ _4268_/Q clkload3/A _4268_/D _4268_/RESET_B VPWR VGND sg13cmos5l_dfrbpq_1
XFILLER_28_813 VPWR VGND sg13cmos5l_fill_2
X_3219_ _3219_/Y _3157_/A _3157_/B _3119_/X VPWR VGND sg13cmos5l_o21ai_1
XFILLER_39_183 VPWR VGND sg13cmos5l_fill_1
X_4199_ _4199_/Q _4205_/CLK _4199_/D _4199_/RESET_B VPWR VGND sg13cmos5l_dfrbpq_1
XFILLER_27_312 VPWR VGND sg13cmos5l_decap_8
XFILLER_43_838 VPWR VGND sg13cmos5l_fill_1
XFILLER_36_890 VPWR VGND sg13cmos5l_decap_4
XFILLER_23_551 VPWR VGND sg13cmos5l_decap_4
XFILLER_11_713 VPWR VGND sg13cmos5l_decap_4
XFILLER_23_562 VPWR VGND sg13cmos5l_fill_1
XFILLER_24_66 VPWR VGND sg13cmos5l_decap_8
XFILLER_10_223 VPWR VGND sg13cmos5l_decap_8
XFILLER_23_595 VPWR VGND sg13cmos5l_decap_4
XFILLER_24_99 VPWR VGND sg13cmos5l_decap_8
XFILLER_6_249 VPWR VGND sg13cmos5l_decap_8
XFILLER_3_923 VPWR VGND sg13cmos5l_decap_8
X_4114__530 _4114_/RESET_B VPWR VGND sg13cmos5l_tiehi
XFILLER_33_315 VPWR VGND sg13cmos5l_decap_4
XFILLER_45_197 VPWR VGND sg13cmos5l_decap_8
X_3570_ _3570_/Y _3505_/B _3596_/S _3569_/Y VPWR VGND sg13cmos5l_o21ai_1
X_2521_ _4041_/D _2521_/A _2522_/A _2521_/C VPWR VGND sg13cmos5l_nor3_1
XFILLER_5_271 VPWR VGND sg13cmos5l_decap_8
XFILLER_5_260 VPWR VGND sg13cmos5l_fill_2
X_4121__523 _4121_/RESET_B VPWR VGND sg13cmos5l_tiehi
X_2452_ _2464_/A _2452_/A _2452_/B VPWR VGND sg13cmos5l_xnor2_1
X_2383_ _2391_/S _2474_/B _3846_/D _2392_/C VPWR VGND sg13cmos5l_and3_1
X_4122_ _4122_/Q _4193_/CLK _4122_/D _4122_/RESET_B VPWR VGND sg13cmos5l_dfrbpq_1
X_4053_ _4053_/Q _4129_/CLK _4053_/D _4053_/RESET_B VPWR VGND sg13cmos5l_dfrbpq_1
X_4271__556 _4271_/RESET_B VPWR VGND sg13cmos5l_tiehi
Xinput3 input3/X ui_in[1] VPWR VGND sg13cmos5l_buf_1
X_3004_ _3005_/B _4096_/Q _4141_/Q VPWR VGND sg13cmos5l_nand2_1
XFILLER_37_698 VPWR VGND sg13cmos5l_decap_8
XFILLER_24_348 VPWR VGND sg13cmos5l_fill_1
X_3906_ _3906_/Q _4280_/CLK _3906_/D _3906_/RESET_B VPWR VGND sg13cmos5l_dfrbpq_1
X_3837_ _3837_/Y _3835_/A _3834_/X _3835_/Y _3836_/Y VPWR VGND sg13cmos5l_a22oi_1
XFILLER_20_554 VPWR VGND sg13cmos5l_fill_1
X_3768_ _3768_/Y _4212_/Q _3768_/B VPWR VGND sg13cmos5l_nor2_1
XFILLER_20_587 VPWR VGND sg13cmos5l_fill_2
X_2719_ _4059_/D _2789_/A _2776_/A VPWR VGND sg13cmos5l_nor2_1
XFILLER_4_709 VPWR VGND sg13cmos5l_fill_2
X_3699_ _4247_/D _3715_/B _3699_/B VPWR VGND sg13cmos5l_nor2_1
XFILLER_47_429 VPWR VGND sg13cmos5l_decap_8
XFILLER_28_610 VPWR VGND sg13cmos5l_fill_2
XFILLER_28_643 VPWR VGND sg13cmos5l_decap_8
XFILLER_43_635 VPWR VGND sg13cmos5l_fill_1
XFILLER_43_657 VPWR VGND sg13cmos5l_decap_4
XFILLER_23_381 VPWR VGND sg13cmos5l_decap_8
XFILLER_24_893 VPWR VGND sg13cmos5l_decap_8
XFILLER_11_543 VPWR VGND sg13cmos5l_decap_8
XFILLER_11_587 VPWR VGND sg13cmos5l_decap_4
XFILLER_3_720 VPWR VGND sg13cmos5l_fill_1
XFILLER_3_797 VPWR VGND sg13cmos5l_decap_8
XFILLER_2_285 VPWR VGND sg13cmos5l_decap_8
XFILLER_2_296 VPWR VGND sg13cmos5l_decap_8
XFILLER_47_952 VPWR VGND sg13cmos5l_decap_8
XFILLER_19_654 VPWR VGND sg13cmos5l_decap_4
XFILLER_18_153 VPWR VGND sg13cmos5l_fill_1
XFILLER_34_624 VPWR VGND sg13cmos5l_decap_8
XFILLER_34_646 VPWR VGND sg13cmos5l_fill_1
X_4188__450 _4188_/RESET_B VPWR VGND sg13cmos5l_tiehi
XFILLER_15_882 VPWR VGND sg13cmos5l_decap_8
XFILLER_14_392 VPWR VGND sg13cmos5l_decap_8
XFILLER_30_841 VPWR VGND sg13cmos5l_fill_1
X_3622_ _3623_/A _3635_/B _3622_/B VPWR VGND sg13cmos5l_nand2b_1
X_3553_ _3553_/Y _2170_/Y _3553_/A2 _3552_/Y VPWR VGND sg13cmos5l_a21oi_1
X_3484_ _4209_/D _3561_/B _3563_/A VPWR VGND sg13cmos5l_nor2_1
X_2504_ _2511_/B _2504_/A _2688_/B _2505_/A _2505_/B VPWR VGND sg13cmos5l_nor4_1
X_2435_ _2435_/Y _2435_/A _2435_/B VPWR VGND sg13cmos5l_nand2_1
X_2366_ _3964_/D _2415_/A0 hold709/X _2371_/S VPWR VGND sg13cmos5l_mux2_1
X_4105_ _4105_/Q _4136_/CLK _4105_/D _4105_/RESET_B VPWR VGND sg13cmos5l_dfrbpq_1
X_2297_ _3906_/D _3871_/A0 hold659/X _2301_/S VPWR VGND sg13cmos5l_mux2_1
XFILLER_38_963 VPWR VGND sg13cmos5l_decap_8
XFILLER_37_451 VPWR VGND sg13cmos5l_fill_1
XFILLER_37_440 VPWR VGND sg13cmos5l_decap_8
X_4036_ _4036_/Q clkload4/A _4036_/D _4036_/RESET_B VPWR VGND sg13cmos5l_dfrbpq_1
XFILLER_25_613 VPWR VGND sg13cmos5l_fill_1
XFILLER_36_1010 VPWR VGND sg13cmos5l_decap_8
XFILLER_21_830 VPWR VGND sg13cmos5l_fill_2
XFILLER_4_506 VPWR VGND sg13cmos5l_fill_2
XFILLER_4_539 VPWR VGND sg13cmos5l_decap_8
X_4104__540 _4104_/RESET_B VPWR VGND sg13cmos5l_tiehi
XFILLER_43_1003 VPWR VGND sg13cmos5l_decap_8
XFILLER_48_705 VPWR VGND sg13cmos5l_fill_2
XFILLER_0_767 VPWR VGND sg13cmos5l_decap_8
XFILLER_44_911 VPWR VGND sg13cmos5l_decap_8
XFILLER_16_646 VPWR VGND sg13cmos5l_decap_8
X_4111__533 _4111_/RESET_B VPWR VGND sg13cmos5l_tiehi
XFILLER_44_988 VPWR VGND sg13cmos5l_decap_8
XFILLER_15_145 VPWR VGND sg13cmos5l_decap_8
XFILLER_31_616 VPWR VGND sg13cmos5l_decap_8
XFILLER_12_830 VPWR VGND sg13cmos5l_fill_2
XFILLER_30_104 VPWR VGND sg13cmos5l_fill_2
XFILLER_12_863 VPWR VGND sg13cmos5l_fill_2
XFILLER_8_889 VPWR VGND sg13cmos5l_fill_1
XFILLER_3_594 VPWR VGND sg13cmos5l_fill_2
X_2220_ _3393_/A _2220_/A VPWR VGND sg13cmos5l_inv_1
XFILLER_38_259 VPWR VGND sg13cmos5l_fill_1
XFILLER_19_462 VPWR VGND sg13cmos5l_fill_1
XFILLER_34_421 VPWR VGND sg13cmos5l_fill_1
XFILLER_35_977 VPWR VGND sg13cmos5l_decap_8
X_2984_ _2984_/X _2984_/A _2984_/B _2984_/C VPWR VGND sg13cmos5l_and3_1
XFILLER_34_487 VPWR VGND sg13cmos5l_decap_4
XFILLER_21_159 VPWR VGND sg13cmos5l_decap_4
Xhold801 hold801/X _3981_/Q VPWR VGND sg13cmos5l_dlygate4sd3_1
X_3605_ _3605_/Y _3597_/A _3597_/B _3599_/X _3604_/Y VPWR VGND sg13cmos5l_a22oi_1
Xhold812 hold812/X _3888_/Q VPWR VGND sg13cmos5l_dlygate4sd3_1
X_3536_ _3538_/B _4219_/Q _3525_/Y _3537_/B _3545_/B _3534_/Y VPWR VGND sg13cmos5l_a221oi_1
Xhold845 _3686_/C _4263_/Q VPWR VGND sg13cmos5l_dlygate4sd3_1
Xhold823 _4036_/D _2488_/Y VPWR VGND sg13cmos5l_dlygate4sd3_1
Xhold834 _2278_/A _4025_/Q VPWR VGND sg13cmos5l_dlygate4sd3_1
Xhold889 _2748_/B _4069_/Q VPWR VGND sg13cmos5l_dlygate4sd3_1
XFILLER_1_509 VPWR VGND sg13cmos5l_fill_2
Xhold878 _4218_/D _3542_/Y VPWR VGND sg13cmos5l_dlygate4sd3_1
Xhold856 _2518_/D _2517_/Y VPWR VGND sg13cmos5l_dlygate4sd3_1
Xhold867 _3217_/A _4142_/Q VPWR VGND sg13cmos5l_dlygate4sd3_1
X_3467_ _3467_/Y _3769_/A _4207_/Q VPWR VGND sg13cmos5l_nand2_1
X_4277__562 _4277_/RESET_B VPWR VGND sg13cmos5l_tiehi
X_3398_ _3398_/Y _3396_/A _3396_/B _3396_/C _3396_/D VPWR VGND sg13cmos5l_a22oi_1
X_2418_ _2418_/X _2418_/A0 hold760/X _2418_/S VPWR VGND sg13cmos5l_mux2_1
X_2349_ _3950_/D hold725/X _2418_/A0 _2351_/S VPWR VGND sg13cmos5l_mux2_1
XFILLER_29_226 VPWR VGND sg13cmos5l_fill_1
X_4019_ _4019_/Q clkload4/A _4019_/D _4019_/RESET_B VPWR VGND sg13cmos5l_dfrbpq_1
XFILLER_25_432 VPWR VGND sg13cmos5l_decap_8
XFILLER_26_944 VPWR VGND sg13cmos5l_decap_8
XFILLER_41_936 VPWR VGND sg13cmos5l_decap_8
XFILLER_12_104 VPWR VGND sg13cmos5l_fill_2
XFILLER_48_502 VPWR VGND sg13cmos5l_fill_2
X_4178__460 _4178_/RESET_B VPWR VGND sg13cmos5l_tiehi
XFILLER_0_586 VPWR VGND sg13cmos5l_decap_8
XFILLER_44_774 VPWR VGND sg13cmos5l_decap_8
XFILLER_16_465 VPWR VGND sg13cmos5l_fill_1
XFILLER_17_988 VPWR VGND sg13cmos5l_decap_8
XFILLER_32_914 VPWR VGND sg13cmos5l_decap_8
XFILLER_8_620 VPWR VGND sg13cmos5l_decap_4
X_4185__453 _4185_/RESET_B VPWR VGND sg13cmos5l_tiehi
XFILLER_8_664 VPWR VGND sg13cmos5l_decap_8
XFILLER_8_686 VPWR VGND sg13cmos5l_fill_2
XFILLER_8_675 VPWR VGND sg13cmos5l_fill_1
X_3321_ _3321_/Y _3320_/A _3320_/B _3124_/A VPWR VGND sg13cmos5l_a21oi_1
XFILLER_3_391 VPWR VGND sg13cmos5l_decap_8
X_3252_ _3254_/B _3252_/A _3252_/B VPWR VGND sg13cmos5l_nor2_1
X_2203_ _2885_/A _2203_/A VPWR VGND sg13cmos5l_inv_1
X_3183_ _3183_/Y _3184_/B VPWR VGND sg13cmos5l_inv_1
XFILLER_35_741 VPWR VGND sg13cmos5l_fill_2
XFILLER_23_958 VPWR VGND sg13cmos5l_decap_4
X_2967_ _4114_/D _3047_/B _2967_/B VPWR VGND sg13cmos5l_nor2_1
X_2898_ _2898_/Y _4099_/Q _4076_/Q VPWR VGND sg13cmos5l_xnor2_1
Xhold620 _2180_/A _4129_/Q VPWR VGND sg13cmos5l_dlygate4sd3_1
XFILLER_2_807 VPWR VGND sg13cmos5l_decap_8
Xhold631 _3831_/B _3830_/Y VPWR VGND sg13cmos5l_dlygate4sd3_1
Xhold642 _2162_/A _4224_/Q VPWR VGND sg13cmos5l_dlygate4sd3_1
Xhold653 _2186_/A _4073_/Q VPWR VGND sg13cmos5l_dlygate4sd3_1
Xhold686 hold686/X _3986_/Q VPWR VGND sg13cmos5l_dlygate4sd3_1
Xhold675 hold675/X _3963_/Q VPWR VGND sg13cmos5l_dlygate4sd3_1
Xhold664 _2449_/B _2448_/Y VPWR VGND sg13cmos5l_dlygate4sd3_1
X_3519_ _3520_/B _4238_/Q _3378_/A _4188_/Q _3714_/A VPWR VGND sg13cmos5l_a22oi_1
Xhold697 hold697/X _3925_/Q VPWR VGND sg13cmos5l_dlygate4sd3_1
X_4101__543 _4101_/RESET_B VPWR VGND sg13cmos5l_tiehi
XFILLER_40_1028 VPWR VGND sg13cmos5l_fill_1
XFILLER_40_1017 VPWR VGND sg13cmos5l_decap_8
XFILLER_45_516 VPWR VGND sg13cmos5l_decap_8
XFILLER_38_590 VPWR VGND sg13cmos5l_decap_8
XFILLER_25_262 VPWR VGND sg13cmos5l_fill_1
XFILLER_25_273 VPWR VGND sg13cmos5l_decap_4
XFILLER_13_435 VPWR VGND sg13cmos5l_decap_8
Xclkbuf_leaf_20_clk _4237_/CLK clkbuf_leaf_3_clk/A VPWR VGND sg13cmos5l_buf_8
XFILLER_5_645 VPWR VGND sg13cmos5l_decap_8
XFILLER_4_188 VPWR VGND sg13cmos5l_fill_1
XFILLER_49_800 VPWR VGND sg13cmos5l_decap_8
XFILLER_1_862 VPWR VGND sg13cmos5l_decap_8
XFILLER_49_877 VPWR VGND sg13cmos5l_decap_8
X_3870_ _3897_/D _2227_/Y _3873_/S _3869_/Y VPWR VGND sg13cmos5l_a21oi_1
X_4111__171 _4111_/D VPWR VGND sg13cmos5l_tielo
X_2821_ _2821_/Y hold969/X _2806_/Y _2820_/Y VPWR VGND sg13cmos5l_o21ai_1
XFILLER_32_777 VPWR VGND sg13cmos5l_fill_2
XFILLER_9_962 VPWR VGND sg13cmos5l_decap_8
XFILLER_13_991 VPWR VGND sg13cmos5l_decap_8
X_2752_ _4072_/D _2192_/Y _2756_/A2 _2751_/Y VPWR VGND sg13cmos5l_a21oi_1
Xclkbuf_leaf_11_clk _4129_/CLK clkload1/A VPWR VGND sg13cmos5l_buf_8
X_2683_ _2693_/B _2631_/Y _2649_/Y _2665_/Y _2682_/Y VPWR VGND sg13cmos5l_a22oi_1
X_3304_ _3304_/X _3304_/A _3309_/B VPWR VGND sg13cmos5l_and2_1
X_3235_ _3250_/A _3249_/A _3249_/B _3249_/C VPWR VGND sg13cmos5l_a21oi_1
X_3166_ _4150_/D _3169_/A _3222_/B VPWR VGND sg13cmos5l_nor2_1
X_3097_ _3098_/B _4146_/Q _3112_/B VPWR VGND sg13cmos5l_nor2_1
Xfanout36 _3873_/S _3872_/S VPWR VGND sg13cmos5l_buf_1
Xfanout47 _3560_/B _3450_/Y VPWR VGND sg13cmos5l_buf_1
XFILLER_23_744 VPWR VGND sg13cmos5l_fill_1
Xfanout25 _3708_/A2 _3553_/A2 VPWR VGND sg13cmos5l_buf_1
X_3999_ _3999_/Q clkload6/A _3999_/D _3999_/RESET_B VPWR VGND sg13cmos5l_dfrbpq_1
XFILLER_11_917 VPWR VGND sg13cmos5l_decap_8
XFILLER_23_799 VPWR VGND sg13cmos5l_fill_2
Xfanout69 _2665_/A1 _4039_/Q VPWR VGND sg13cmos5l_buf_1
Xfanout58 _2662_/A _2675_/C1 VPWR VGND sg13cmos5l_buf_1
X_4168__470 _4168_/RESET_B VPWR VGND sg13cmos5l_tiehi
XFILLER_2_648 VPWR VGND sg13cmos5l_fill_1
XFILLER_49_107 VPWR VGND sg13cmos5l_fill_1
XFILLER_46_814 VPWR VGND sg13cmos5l_decap_8
X_4175__463 _4175_/RESET_B VPWR VGND sg13cmos5l_tiehi
XFILLER_33_508 VPWR VGND sg13cmos5l_fill_1
XFILLER_14_755 VPWR VGND sg13cmos5l_decap_8
XFILLER_41_585 VPWR VGND sg13cmos5l_fill_1
XFILLER_41_574 VPWR VGND sg13cmos5l_decap_4
Xclkload17 clkload17/Y _4168_/CLK VPWR VGND sg13cmos5l_inv_2
X_4182__456 _4182_/RESET_B VPWR VGND sg13cmos5l_tiehi
XFILLER_6_954 VPWR VGND sg13cmos5l_decap_8
XFILLER_10_994 VPWR VGND sg13cmos5l_decap_8
XFILLER_48_7 VPWR VGND sg13cmos5l_decap_8
XFILLER_1_670 VPWR VGND sg13cmos5l_decap_8
XFILLER_49_641 VPWR VGND sg13cmos5l_decap_8
Xclkbuf_leaf_0_clk _4027_/CLK clkbuf_leaf_4_clk/A VPWR VGND sg13cmos5l_buf_8
X_3020_ _3020_/Y hold897/X _3015_/Y _3012_/Y VPWR VGND sg13cmos5l_o21ai_1
XFILLER_37_836 VPWR VGND sg13cmos5l_fill_1
XFILLER_45_880 VPWR VGND sg13cmos5l_decap_8
X_3922_ _3922_/Q clkload2/A _3922_/D _3922_/RESET_B VPWR VGND sg13cmos5l_dfrbpq_1
X_3853_ _3883_/D hold807/X _3873_/A0 _3854_/S VPWR VGND sg13cmos5l_mux2_1
XFILLER_20_714 VPWR VGND sg13cmos5l_fill_2
X_2804_ _2984_/A _2817_/A _4110_/Q VPWR VGND sg13cmos5l_xnor2_1
X_3784_ _3784_/Y _3798_/A _3797_/B _3805_/A VPWR VGND sg13cmos5l_o21ai_1
X_2735_ _2735_/Y _2857_/B _2740_/B VPWR VGND sg13cmos5l_nand2_1
X_2666_ _2666_/Y _2667_/A1 _4001_/Q VPWR VGND sg13cmos5l_nand2b_1
X_2597_ _2597_/Y _2667_/A1 _3983_/Q _2678_/S1 VPWR VGND sg13cmos5l_a21oi_1
X_4267_ _4267_/Q clkload3/A _4267_/D _4267_/RESET_B VPWR VGND sg13cmos5l_dfrbpq_1
X_4198_ _4198_/Q _4205_/CLK _4198_/D _4198_/RESET_B VPWR VGND sg13cmos5l_dfrbpq_1
X_3218_ _3218_/Y _3218_/A _3218_/B _3218_/C VPWR VGND sg13cmos5l_nand3_1
X_3149_ _3154_/B _3135_/X _3144_/X _3167_/B _2964_/A _3147_/X VPWR VGND sg13cmos5l_a221oi_1
XFILLER_27_379 VPWR VGND sg13cmos5l_fill_2
XFILLER_42_349 VPWR VGND sg13cmos5l_fill_2
XFILLER_24_89 VPWR VGND sg13cmos5l_fill_1
XFILLER_40_22 VPWR VGND sg13cmos5l_fill_2
XFILLER_3_902 VPWR VGND sg13cmos5l_decap_8
XFILLER_3_979 VPWR VGND sg13cmos5l_decap_8
XFILLER_2_456 VPWR VGND sg13cmos5l_decap_8
XFILLER_2_434 VPWR VGND sg13cmos5l_fill_1
XFILLER_49_53 VPWR VGND sg13cmos5l_decap_8
XFILLER_18_368 VPWR VGND sg13cmos5l_decap_8
XFILLER_6_762 VPWR VGND sg13cmos5l_decap_8
X_2520_ _2521_/C _2516_/A _2647_/A _2424_/A VPWR VGND sg13cmos5l_a21oi_1
X_2451_ _2451_/Y _2451_/A _2474_/C _2519_/B VPWR VGND sg13cmos5l_nor3_1
X_2382_ _2392_/C _4031_/Q _3846_/B VPWR VGND sg13cmos5l_nor2_1
X_4121_ _4121_/Q _4168_/CLK _4121_/D _4121_/RESET_B VPWR VGND sg13cmos5l_dfrbpq_1
XFILLER_37_600 VPWR VGND sg13cmos5l_decap_4
X_4052_ _4052_/Q _4280_/CLK _4052_/D _4052_/RESET_B VPWR VGND sg13cmos5l_dfrbpq_1
XFILLER_49_471 VPWR VGND sg13cmos5l_decap_8
Xinput4 input4/X ui_in[2] VPWR VGND sg13cmos5l_buf_1
X_3003_ _3003_/Y _4094_/Q _3214_/A _3215_/A _4095_/Q _3002_/Y VPWR VGND sg13cmos5l_a221oi_1
XFILLER_36_110 VPWR VGND sg13cmos5l_fill_1
Xclkbuf_2_1__f_clk clkload0/A clkbuf_0_clk/X VPWR VGND sg13cmos5l_buf_8
XFILLER_18_891 VPWR VGND sg13cmos5l_decap_8
X_3905_ _3905_/Q clkload2/A _3905_/D _3905_/RESET_B VPWR VGND sg13cmos5l_dfrbpq_1
X_3836_ _3836_/Y _2510_/A _4272_/Q _3834_/X VPWR VGND sg13cmos5l_a21oi_1
X_3767_ _3779_/B _3765_/B _3762_/Y _3776_/S VPWR VGND sg13cmos5l_mux2_1
X_4165__473 _4165_/RESET_B VPWR VGND sg13cmos5l_tiehi
X_2718_ _2776_/A hold933/X _2717_/Y _2721_/A VPWR VGND sg13cmos5l_mux2_1
X_3698_ _3699_/B _3685_/B _2167_/Y _3698_/S VPWR VGND sg13cmos5l_mux2_1
X_2649_ _2649_/Y _2649_/A _2649_/B VPWR VGND sg13cmos5l_nor2_1
XFILLER_48_909 VPWR VGND sg13cmos5l_decap_8
XFILLER_0_949 VPWR VGND sg13cmos5l_decap_8
XFILLER_28_633 VPWR VGND sg13cmos5l_fill_1
X_4172__466 _4172_/RESET_B VPWR VGND sg13cmos5l_tiehi
XFILLER_27_121 VPWR VGND sg13cmos5l_decap_8
XFILLER_27_154 VPWR VGND sg13cmos5l_decap_4
XFILLER_27_187 VPWR VGND sg13cmos5l_fill_2
XFILLER_11_522 VPWR VGND sg13cmos5l_decap_8
XFILLER_11_566 VPWR VGND sg13cmos5l_decap_8
X_4220__412 _4220_/RESET_B VPWR VGND sg13cmos5l_tiehi
XFILLER_3_776 VPWR VGND sg13cmos5l_decap_8
XFILLER_39_909 VPWR VGND sg13cmos5l_decap_8
XFILLER_47_931 VPWR VGND sg13cmos5l_decap_8
XFILLER_18_8 VPWR VGND sg13cmos5l_decap_8
XFILLER_19_633 VPWR VGND sg13cmos5l_decap_8
XFILLER_19_644 VPWR VGND sg13cmos5l_fill_2
XFILLER_15_861 VPWR VGND sg13cmos5l_fill_2
XFILLER_21_308 VPWR VGND sg13cmos5l_decap_8
X_3621_ _3622_/B _4239_/Q _4240_/Q _4241_/Q VPWR VGND sg13cmos5l_o21ai_1
XFILLER_30_897 VPWR VGND sg13cmos5l_decap_4
X_3552_ _3552_/Y _4225_/Q _3553_/A2 _3555_/A VPWR VGND sg13cmos5l_o21ai_1
XFILLER_6_581 VPWR VGND sg13cmos5l_decap_4
X_2503_ _2505_/B _2503_/A _2503_/B VPWR VGND sg13cmos5l_and2_1
X_3483_ _3563_/A _3465_/X _3472_/Y _3483_/S VPWR VGND sg13cmos5l_mux2_1
X_2434_ _2435_/B _2434_/A input2/X VPWR VGND sg13cmos5l_nor2_1
XFILLER_37_0 VPWR VGND sg13cmos5l_decap_4
X_2365_ _3963_/D _2414_/A0 hold675/X _2371_/S VPWR VGND sg13cmos5l_mux2_1
XFILLER_5_1009 VPWR VGND sg13cmos5l_decap_8
X_4104_ _4104_/Q _4136_/CLK _4104_/D _4104_/RESET_B VPWR VGND sg13cmos5l_dfrbpq_1
XFILLER_38_942 VPWR VGND sg13cmos5l_decap_8
X_2296_ _3905_/D _3859_/A0 hold655/X _2301_/S VPWR VGND sg13cmos5l_mux2_1
X_4035_ _4035_/Q clkload4/A _4035_/D _4035_/RESET_B VPWR VGND sg13cmos5l_dfrbpq_1
XFILLER_24_113 VPWR VGND sg13cmos5l_decap_8
XFILLER_40_628 VPWR VGND sg13cmos5l_decap_8
XFILLER_21_864 VPWR VGND sg13cmos5l_decap_8
X_4046__219 _4046_/RESET_B VPWR VGND sg13cmos5l_tiehi
X_3819_ _3819_/Y _3819_/A _3819_/B VPWR VGND sg13cmos5l_nor2_1
XFILLER_20_352 VPWR VGND sg13cmos5l_decap_4
X_4022__263 _4022_/RESET_B VPWR VGND sg13cmos5l_tiehi
XFILLER_0_746 VPWR VGND sg13cmos5l_decap_8
XFILLER_46_76 VPWR VGND sg13cmos5l_decap_8
XFILLER_16_625 VPWR VGND sg13cmos5l_decap_8
XFILLER_44_967 VPWR VGND sg13cmos5l_decap_8
XFILLER_15_102 VPWR VGND sg13cmos5l_fill_2
XFILLER_7_323 VPWR VGND sg13cmos5l_decap_8
XFILLER_12_886 VPWR VGND sg13cmos5l_decap_8
XFILLER_8_857 VPWR VGND sg13cmos5l_decap_8
XFILLER_3_573 VPWR VGND sg13cmos5l_fill_2
XFILLER_3_562 VPWR VGND sg13cmos5l_decap_8
XFILLER_19_485 VPWR VGND sg13cmos5l_decap_8
XFILLER_35_956 VPWR VGND sg13cmos5l_decap_8
X_2983_ _2983_/X _2984_/B _2984_/C _2984_/A VPWR VGND sg13cmos5l_a21o_1
X_3604_ _3604_/Y _3604_/A VPWR VGND sg13cmos5l_inv_1
Xhold802 hold802/X _3890_/Q VPWR VGND sg13cmos5l_dlygate4sd3_1
Xhold813 _2458_/A _4022_/Q VPWR VGND sg13cmos5l_dlygate4sd3_1
Xhold824 _2168_/A _4246_/Q VPWR VGND sg13cmos5l_dlygate4sd3_1
Xhold846 hold846/X _3700_/Y VPWR VGND sg13cmos5l_dlygate4sd3_1
Xhold835 _4025_/D _2470_/Y VPWR VGND sg13cmos5l_dlygate4sd3_1
X_3535_ _3537_/B _2212_/A _3715_/A _3378_/A _3378_/B VPWR VGND sg13cmos5l_a22oi_1
X_4162__476 _4162_/RESET_B VPWR VGND sg13cmos5l_tiehi
Xhold857 _2820_/A _4110_/Q VPWR VGND sg13cmos5l_dlygate4sd3_1
X_3466_ _3466_/X _3473_/A _3473_/C _3775_/B VPWR VGND sg13cmos5l_a21o_1
Xhold879 _3825_/A _4267_/Q VPWR VGND sg13cmos5l_dlygate4sd3_1
Xhold868 _3835_/A _4269_/Q VPWR VGND sg13cmos5l_dlygate4sd3_1
X_2417_ _4008_/D _2417_/A0 hold689/X _2421_/S VPWR VGND sg13cmos5l_mux2_1
X_3397_ _3397_/Y _3397_/A _3397_/B _3397_/C _3397_/D VPWR VGND sg13cmos5l_nand4_1
X_2348_ _3949_/D hold775/X _2417_/A0 _2351_/S VPWR VGND sg13cmos5l_mux2_1
X_2279_ _2495_/B _4274_/Q _2272_/A hold922/X VPWR VGND sg13cmos5l_a21o_1
XFILLER_38_783 VPWR VGND sg13cmos5l_decap_8
X_4018_ _4018_/Q clkload4/A _4018_/D _4018_/RESET_B VPWR VGND sg13cmos5l_dfrbpq_1
XFILLER_16_68 VPWR VGND sg13cmos5l_fill_2
XFILLER_12_116 VPWR VGND sg13cmos5l_fill_2
XFILLER_13_639 VPWR VGND sg13cmos5l_decap_8
XFILLER_25_499 VPWR VGND sg13cmos5l_fill_2
XFILLER_21_683 VPWR VGND sg13cmos5l_decap_4
X_4243__264 _4243_/RESET_B VPWR VGND sg13cmos5l_tiehi
XFILLER_0_565 VPWR VGND sg13cmos5l_decap_8
XFILLER_48_525 VPWR VGND sg13cmos5l_fill_1
X_4096__172 _4096_/D VPWR VGND sg13cmos5l_tielo
XFILLER_35_208 VPWR VGND sg13cmos5l_decap_4
XFILLER_44_753 VPWR VGND sg13cmos5l_decap_8
XFILLER_17_967 VPWR VGND sg13cmos5l_decap_8
XFILLER_44_786 VPWR VGND sg13cmos5l_decap_8
XFILLER_31_425 VPWR VGND sg13cmos5l_fill_2
XFILLER_32_959 VPWR VGND sg13cmos5l_decap_8
XFILLER_8_654 VPWR VGND sg13cmos5l_decap_4
XFILLER_11_193 VPWR VGND sg13cmos5l_fill_1
XFILLER_7_186 VPWR VGND sg13cmos5l_decap_8
X_3320_ _3343_/A _3320_/A _3320_/B VPWR VGND sg13cmos5l_and2_1
X_3251_ _3252_/B _3128_/B _3222_/B _3251_/S VPWR VGND sg13cmos5l_mux2_1
X_2202_ _3044_/A _2990_/A VPWR VGND sg13cmos5l_inv_1
X_3182_ _3184_/B _4126_/Q _3180_/Y _3181_/Y VPWR VGND sg13cmos5l_o21ai_1
XFILLER_39_536 VPWR VGND sg13cmos5l_fill_1
XFILLER_47_591 VPWR VGND sg13cmos5l_decap_8
XFILLER_35_720 VPWR VGND sg13cmos5l_decap_8
XFILLER_35_753 VPWR VGND sg13cmos5l_fill_2
XFILLER_23_937 VPWR VGND sg13cmos5l_decap_8
X_2966_ _2966_/Y _2967_/B VPWR VGND sg13cmos5l_inv_1
XFILLER_33_1025 VPWR VGND sg13cmos5l_decap_4
X_2897_ _2897_/Y _4098_/Q _4075_/Q VPWR VGND sg13cmos5l_xnor2_1
XFILLER_31_992 VPWR VGND sg13cmos5l_decap_8
Xhold621 _2198_/A _4028_/Q VPWR VGND sg13cmos5l_dlygate4sd3_1
Xhold610 _2190_/A _4052_/Q VPWR VGND sg13cmos5l_dlygate4sd3_1
Xhold643 _4253_/D _3708_/Y VPWR VGND sg13cmos5l_dlygate4sd3_1
Xhold632 _3034_/B _4097_/Q VPWR VGND sg13cmos5l_dlygate4sd3_1
Xhold654 hold654/X _3907_/Q VPWR VGND sg13cmos5l_dlygate4sd3_1
Xhold676 hold676/X _3951_/Q VPWR VGND sg13cmos5l_dlygate4sd3_1
X_3518_ _3520_/A _3714_/A _4188_/Q _3517_/Y VPWR VGND sg13cmos5l_o21ai_1
Xhold665 hold665/X _3942_/Q VPWR VGND sg13cmos5l_dlygate4sd3_1
Xhold687 hold687/X _3895_/Q VPWR VGND sg13cmos5l_dlygate4sd3_1
X_3449_ _4205_/D _3432_/X _3440_/Y _3448_/Y VPWR VGND sg13cmos5l_a21oi_1
Xhold698 hold698/X _3957_/Q VPWR VGND sg13cmos5l_dlygate4sd3_1
XFILLER_27_23 VPWR VGND sg13cmos5l_decap_4
XFILLER_26_775 VPWR VGND sg13cmos5l_fill_2
XFILLER_41_712 VPWR VGND sg13cmos5l_decap_8
XFILLER_13_414 VPWR VGND sg13cmos5l_decap_8
XFILLER_41_767 VPWR VGND sg13cmos5l_decap_8
XFILLER_41_789 VPWR VGND sg13cmos5l_fill_1
XFILLER_40_277 VPWR VGND sg13cmos5l_decap_8
XFILLER_40_266 VPWR VGND sg13cmos5l_fill_1
XFILLER_49_1010 VPWR VGND sg13cmos5l_decap_8
XFILLER_1_841 VPWR VGND sg13cmos5l_decap_8
XFILLER_0_373 VPWR VGND sg13cmos5l_decap_8
XFILLER_49_856 VPWR VGND sg13cmos5l_decap_8
XFILLER_36_506 VPWR VGND sg13cmos5l_decap_4
XFILLER_1_1023 VPWR VGND sg13cmos5l_decap_4
XFILLER_17_753 VPWR VGND sg13cmos5l_fill_2
XFILLER_17_797 VPWR VGND sg13cmos5l_decap_4
XFILLER_17_1009 VPWR VGND sg13cmos5l_decap_8
XFILLER_32_767 VPWR VGND sg13cmos5l_fill_1
X_2820_ _2820_/Y _2820_/A _2820_/B VPWR VGND sg13cmos5l_nand2_1
XFILLER_9_930 VPWR VGND sg13cmos5l_decap_8
XFILLER_13_970 VPWR VGND sg13cmos5l_decap_8
XFILLER_31_255 VPWR VGND sg13cmos5l_fill_2
X_2751_ _2751_/Y _2187_/A _2756_/A2 _3547_/A VPWR VGND sg13cmos5l_o21ai_1
X_2682_ _2682_/Y _4041_/Q _2682_/B _2682_/C VPWR VGND sg13cmos5l_nor3_1
X_3303_ _4175_/D _3394_/B _3303_/B VPWR VGND sg13cmos5l_nor2_1
X_3234_ _3249_/C _4167_/Q _3246_/B VPWR VGND sg13cmos5l_xnor2_1
X_3165_ _3222_/B _2964_/Y _3164_/X _3165_/S VPWR VGND sg13cmos5l_mux2_1
X_3096_ _3112_/B _4145_/Q _4143_/Q _4144_/Q VPWR VGND sg13cmos5l_or3_1
XFILLER_42_509 VPWR VGND sg13cmos5l_fill_1
Xfanout37 _2451_/A _2264_/Y VPWR VGND sg13cmos5l_buf_1
Xfanout26 _3553_/A2 _2755_/A2 VPWR VGND sg13cmos5l_buf_1
X_3998_ _3998_/Q _4031_/CLK _3998_/D _3998_/RESET_B VPWR VGND sg13cmos5l_dfrbpq_1
Xfanout59 _2675_/C1 _2225_/Y VPWR VGND sg13cmos5l_buf_1
Xfanout48 _3394_/B _3373_/A VPWR VGND sg13cmos5l_buf_1
X_2949_ _2949_/Y _2946_/Y _2959_/B _2948_/Y _4139_/Q VPWR VGND sg13cmos5l_a22oi_1
X_3884__406 _3884_/RESET_B VPWR VGND sg13cmos5l_tiehi
X_3997__294 _3997_/RESET_B VPWR VGND sg13cmos5l_tiehi
XFILLER_45_369 VPWR VGND sg13cmos5l_decap_8
XFILLER_26_550 VPWR VGND sg13cmos5l_decap_4
XFILLER_14_701 VPWR VGND sg13cmos5l_decap_4
XFILLER_16_1020 VPWR VGND sg13cmos5l_decap_8
XFILLER_10_973 VPWR VGND sg13cmos5l_decap_8
XFILLER_6_933 VPWR VGND sg13cmos5l_decap_8
Xclkload18 clkload18/Y _4173_/CLK VPWR VGND sg13cmos5l_inv_1
XFILLER_5_465 VPWR VGND sg13cmos5l_fill_1
XFILLER_5_454 VPWR VGND sg13cmos5l_decap_8
XFILLER_5_443 VPWR VGND sg13cmos5l_decap_4
XFILLER_49_631 VPWR VGND sg13cmos5l_fill_2
XFILLER_49_620 VPWR VGND sg13cmos5l_decap_8
XFILLER_23_1013 VPWR VGND sg13cmos5l_decap_8
XFILLER_36_303 VPWR VGND sg13cmos5l_decap_4
XFILLER_36_336 VPWR VGND sg13cmos5l_decap_4
XFILLER_48_196 VPWR VGND sg13cmos5l_decap_4
XFILLER_36_358 VPWR VGND sg13cmos5l_decap_8
X_3921_ _3921_/Q _4278_/CLK _3921_/D _3921_/RESET_B VPWR VGND sg13cmos5l_dfrbpq_1
XFILLER_32_542 VPWR VGND sg13cmos5l_decap_8
X_3852_ _3882_/D hold712/X _3872_/A0 _3854_/S VPWR VGND sg13cmos5l_mux2_1
XFILLER_32_553 VPWR VGND sg13cmos5l_fill_2
X_2803_ _2803_/Y _4088_/Q _2806_/A VPWR VGND sg13cmos5l_xnor2_1
XFILLER_32_586 VPWR VGND sg13cmos5l_fill_2
X_3783_ _3783_/Y _3657_/B _3777_/Y _3797_/B _3798_/A VPWR VGND sg13cmos5l_a22oi_1
X_2734_ _2740_/B _2539_/Y _2737_/B _2733_/Y VPWR VGND sg13cmos5l_o21ai_1
XFILLER_8_292 VPWR VGND sg13cmos5l_decap_8
X_2665_ _2665_/Y _2665_/A1 _2656_/Y _2664_/Y VPWR VGND sg13cmos5l_o21ai_1
X_2596_ _2596_/Y _2667_/A1 _4000_/Q VPWR VGND sg13cmos5l_nand2b_1
XFILLER_8_1018 VPWR VGND sg13cmos5l_decap_8
X_4266_ _4266_/Q clkload3/A _4266_/D _4266_/RESET_B VPWR VGND sg13cmos5l_dfrbpq_1
X_4197_ _4197_/Q _4205_/CLK _4197_/D _4197_/RESET_B VPWR VGND sg13cmos5l_dfrbpq_1
X_3217_ _4169_/D _3217_/A _3217_/B VPWR VGND sg13cmos5l_and2_1
XFILLER_28_859 VPWR VGND sg13cmos5l_fill_1
X_3148_ _3148_/Y _3147_/A _3167_/A _3167_/B _2964_/A VPWR VGND sg13cmos5l_a22oi_1
XFILLER_43_807 VPWR VGND sg13cmos5l_decap_8
XFILLER_43_829 VPWR VGND sg13cmos5l_decap_8
X_3079_ _3080_/B _3079_/A _3079_/B VPWR VGND sg13cmos5l_nor2_1
XFILLER_11_748 VPWR VGND sg13cmos5l_decap_8
XFILLER_11_759 VPWR VGND sg13cmos5l_fill_1
XFILLER_2_402 VPWR VGND sg13cmos5l_decap_8
XFILLER_46_1024 VPWR VGND sg13cmos5l_decap_4
XFILLER_6_4 VPWR VGND sg13cmos5l_fill_2
XFILLER_3_958 VPWR VGND sg13cmos5l_decap_8
XFILLER_2_446 VPWR VGND sg13cmos5l_decap_8
XFILLER_49_32 VPWR VGND sg13cmos5l_decap_8
XFILLER_45_111 VPWR VGND sg13cmos5l_fill_1
XFILLER_18_336 VPWR VGND sg13cmos5l_decap_4
XFILLER_45_166 VPWR VGND sg13cmos5l_decap_4
XFILLER_34_829 VPWR VGND sg13cmos5l_decap_8
XFILLER_42_840 VPWR VGND sg13cmos5l_decap_4
X_4032__243 _4032_/RESET_B VPWR VGND sg13cmos5l_tiehi
XFILLER_41_350 VPWR VGND sg13cmos5l_decap_4
XFILLER_41_383 VPWR VGND sg13cmos5l_decap_4
XFILLER_14_90 VPWR VGND sg13cmos5l_fill_1
XFILLER_6_730 VPWR VGND sg13cmos5l_decap_8
XFILLER_6_741 VPWR VGND sg13cmos5l_decap_8
XFILLER_6_796 VPWR VGND sg13cmos5l_decap_8
X_2450_ _2461_/B _2451_/A _2519_/B _2474_/C VPWR VGND sg13cmos5l_o21ai_1
X_2381_ _3978_/D input5/X hold719/X _2381_/S VPWR VGND sg13cmos5l_mux2_1
X_4120_ _4120_/Q _4168_/CLK _4120_/D _4120_/RESET_B VPWR VGND sg13cmos5l_dfrbpq_1
X_4051_ _4051_/Q _4280_/CLK _4051_/D _4051_/RESET_B VPWR VGND sg13cmos5l_dfrbpq_1
Xinput5 input5/X ui_in[3] VPWR VGND sg13cmos5l_buf_1
X_3002_ _3002_/Y _3013_/B _4139_/Q _4138_/Q _3016_/B VPWR VGND sg13cmos5l_a22oi_1
XFILLER_37_678 VPWR VGND sg13cmos5l_fill_2
XFILLER_18_870 VPWR VGND sg13cmos5l_decap_8
XFILLER_24_317 VPWR VGND sg13cmos5l_decap_8
X_3904_ _3904_/Q _4027_/CLK _3904_/D _3904_/RESET_B VPWR VGND sg13cmos5l_dfrbpq_1
XFILLER_32_350 VPWR VGND sg13cmos5l_decap_8
X_3835_ _3835_/Y _3835_/A _4277_/Q VPWR VGND sg13cmos5l_nand2_1
XFILLER_20_545 VPWR VGND sg13cmos5l_decap_8
X_3766_ _3766_/Y _3766_/A _3776_/S VPWR VGND sg13cmos5l_nand2_1
X_2717_ _2717_/Y _2882_/A _2837_/A VPWR VGND sg13cmos5l_nand2_1
XFILLER_10_15 VPWR VGND sg13cmos5l_fill_2
X_3697_ _4246_/D _3715_/B _3697_/B VPWR VGND sg13cmos5l_nor2_1
X_2648_ _2649_/B _4041_/Q _2648_/B VPWR VGND sg13cmos5l_nand2_1
XFILLER_0_928 VPWR VGND sg13cmos5l_decap_8
X_2579_ _2579_/Y _2579_/A _2579_/B VPWR VGND sg13cmos5l_nor2_1
X_4249_ _4249_/Q clkload4/A _4249_/D _4249_/RESET_B VPWR VGND sg13cmos5l_dfrbpq_1
XFILLER_28_612 VPWR VGND sg13cmos5l_fill_1
XFILLER_16_807 VPWR VGND sg13cmos5l_decap_4
XFILLER_43_604 VPWR VGND sg13cmos5l_fill_1
XFILLER_42_103 VPWR VGND sg13cmos5l_decap_8
XFILLER_16_829 VPWR VGND sg13cmos5l_fill_1
X_3994__297 _3994_/RESET_B VPWR VGND sg13cmos5l_tiehi
XFILLER_13_1012 VPWR VGND sg13cmos5l_decap_8
XFILLER_3_755 VPWR VGND sg13cmos5l_decap_8
XFILLER_47_910 VPWR VGND sg13cmos5l_decap_8
XFILLER_19_612 VPWR VGND sg13cmos5l_decap_8
XFILLER_20_1027 VPWR VGND sg13cmos5l_fill_2
XFILLER_47_987 VPWR VGND sg13cmos5l_decap_8
XFILLER_46_475 VPWR VGND sg13cmos5l_decap_8
XFILLER_18_144 VPWR VGND sg13cmos5l_decap_4
XFILLER_18_177 VPWR VGND sg13cmos5l_decap_4
XFILLER_18_199 VPWR VGND sg13cmos5l_decap_4
XFILLER_33_114 VPWR VGND sg13cmos5l_fill_1
XFILLER_33_136 VPWR VGND sg13cmos5l_fill_2
XFILLER_34_659 VPWR VGND sg13cmos5l_decap_4
XFILLER_14_372 VPWR VGND sg13cmos5l_fill_1
XFILLER_30_832 VPWR VGND sg13cmos5l_decap_8
X_3620_ _3635_/B _4241_/Q _4239_/Q _4240_/Q VPWR VGND sg13cmos5l_nor3_1
XFILLER_30_876 VPWR VGND sg13cmos5l_decap_8
X_3551_ _4224_/D _2171_/Y _3708_/A2 _3550_/Y VPWR VGND sg13cmos5l_a21oi_1
XFILLER_6_560 VPWR VGND sg13cmos5l_decap_8
X_2502_ _2503_/B _2502_/A _2502_/B VPWR VGND sg13cmos5l_nor2_1
X_3482_ _4208_/D _3561_/B _3589_/A VPWR VGND sg13cmos5l_nor2_1
X_2433_ _2433_/Y _2198_/Y _2430_/B _2432_/Y VPWR VGND sg13cmos5l_a21oi_1
X_2364_ _3962_/D _2413_/A0 hold690/X _2371_/S VPWR VGND sg13cmos5l_mux2_1
X_4103_ _4103_/Q _4136_/CLK _4103_/D _4103_/RESET_B VPWR VGND sg13cmos5l_dfrbpq_1
XFILLER_38_921 VPWR VGND sg13cmos5l_decap_8
X_2295_ _3904_/D _3867_/A hold673/X _2301_/S VPWR VGND sg13cmos5l_mux2_1
X_4034_ _4034_/Q clkload4/A _4034_/D _4034_/RESET_B VPWR VGND sg13cmos5l_dfrbpq_1
XFILLER_38_998 VPWR VGND sg13cmos5l_decap_8
XFILLER_25_604 VPWR VGND sg13cmos5l_decap_8
XFILLER_25_626 VPWR VGND sg13cmos5l_fill_2
X_3818_ _3819_/B _3818_/A _3833_/B VPWR VGND sg13cmos5l_nor2b_1
X_3749_ _3749_/X _3463_/Y _3774_/B _3745_/Y VPWR VGND sg13cmos5l_a21o_1
XFILLER_21_47 VPWR VGND sg13cmos5l_decap_8
XFILLER_0_725 VPWR VGND sg13cmos5l_decap_8
XFILLER_29_921 VPWR VGND sg13cmos5l_fill_2
XFILLER_16_604 VPWR VGND sg13cmos5l_decap_8
XFILLER_44_946 VPWR VGND sg13cmos5l_decap_8
XFILLER_28_486 VPWR VGND sg13cmos5l_decap_8
XFILLER_28_497 VPWR VGND sg13cmos5l_fill_1
XFILLER_30_128 VPWR VGND sg13cmos5l_decap_8
XFILLER_8_814 VPWR VGND sg13cmos5l_fill_1
XFILLER_8_803 VPWR VGND sg13cmos5l_decap_8
XFILLER_12_865 VPWR VGND sg13cmos5l_fill_1
XFILLER_11_342 VPWR VGND sg13cmos5l_decap_8
XFILLER_7_49 VPWR VGND sg13cmos5l_decap_8
XFILLER_7_379 VPWR VGND sg13cmos5l_decap_8
XFILLER_7_368 VPWR VGND sg13cmos5l_fill_2
XFILLER_3_596 VPWR VGND sg13cmos5l_fill_1
XFILLER_19_431 VPWR VGND sg13cmos5l_decap_8
XFILLER_47_784 VPWR VGND sg13cmos5l_decap_8
XFILLER_46_283 VPWR VGND sg13cmos5l_fill_1
XFILLER_34_412 VPWR VGND sg13cmos5l_decap_4
XFILLER_35_935 VPWR VGND sg13cmos5l_decap_8
X_2982_ _2984_/C _4089_/Q _4090_/Q _4091_/Q VPWR VGND sg13cmos5l_o21ai_1
XFILLER_30_651 VPWR VGND sg13cmos5l_decap_4
X_3603_ _3604_/A _3595_/B _3603_/B VPWR VGND sg13cmos5l_nand2b_1
Xhold803 hold803/X _3933_/Q VPWR VGND sg13cmos5l_dlygate4sd3_1
X_4045__220 _4045_/RESET_B VPWR VGND sg13cmos5l_tiehi
X_3534_ _3534_/Y _3681_/B _3525_/A _3529_/A _3673_/B _3533_/Y VPWR VGND sg13cmos5l_a221oi_1
Xhold825 _4033_/D _2482_/Y VPWR VGND sg13cmos5l_dlygate4sd3_1
Xhold814 _2169_/A _4245_/Q VPWR VGND sg13cmos5l_dlygate4sd3_1
Xhold836 _3216_/A _4141_/Q VPWR VGND sg13cmos5l_dlygate4sd3_1
Xhold847 _2990_/A _4108_/Q VPWR VGND sg13cmos5l_dlygate4sd3_1
X_3465_ _3465_/X _3473_/A _3473_/C VPWR VGND sg13cmos5l_and2_1
Xhold869 _3838_/B _3837_/Y VPWR VGND sg13cmos5l_dlygate4sd3_1
Xhold858 _3201_/B _4156_/Q VPWR VGND sg13cmos5l_dlygate4sd3_1
X_2416_ _4007_/D _2416_/A0 hold762/X _2421_/S VPWR VGND sg13cmos5l_mux2_1
X_3396_ _3396_/Y _3396_/A _3396_/B _3396_/C _3396_/D VPWR VGND sg13cmos5l_nand4_1
X_2347_ _3948_/D hold723/X _2416_/A0 _2351_/S VPWR VGND sg13cmos5l_mux2_1
XFILLER_29_217 VPWR VGND sg13cmos5l_decap_8
X_2278_ _2278_/Y _2278_/A _3833_/B _2278_/C VPWR VGND sg13cmos5l_nor3_1
X_4017_ _4017_/Q clkload4/A _4017_/D _4017_/RESET_B VPWR VGND sg13cmos5l_dfrbpq_1
XFILLER_41_916 VPWR VGND sg13cmos5l_decap_8
XFILLER_40_426 VPWR VGND sg13cmos5l_fill_1
XFILLER_12_106 VPWR VGND sg13cmos5l_fill_1
XFILLER_34_990 VPWR VGND sg13cmos5l_decap_8
XFILLER_12_139 VPWR VGND sg13cmos5l_fill_2
XFILLER_32_35 VPWR VGND sg13cmos5l_fill_1
XFILLER_5_839 VPWR VGND sg13cmos5l_decap_4
XFILLER_10_1015 VPWR VGND sg13cmos5l_decap_8
XFILLER_4_349 VPWR VGND sg13cmos5l_decap_4
XFILLER_0_522 VPWR VGND sg13cmos5l_decap_8
XFILLER_0_544 VPWR VGND sg13cmos5l_decap_8
XFILLER_17_913 VPWR VGND sg13cmos5l_decap_8
XFILLER_29_762 VPWR VGND sg13cmos5l_decap_4
XFILLER_44_732 VPWR VGND sg13cmos5l_decap_8
XFILLER_17_946 VPWR VGND sg13cmos5l_decap_8
XFILLER_40_982 VPWR VGND sg13cmos5l_decap_8
XFILLER_11_172 VPWR VGND sg13cmos5l_decap_8
XFILLER_4_861 VPWR VGND sg13cmos5l_decap_8
XFILLER_26_1022 VPWR VGND sg13cmos5l_decap_8
X_3250_ _3252_/A _3250_/A _3258_/A _3250_/C VPWR VGND sg13cmos5l_nor3_1
X_2201_ _3045_/A _2817_/A VPWR VGND sg13cmos5l_inv_1
XFILLER_39_504 VPWR VGND sg13cmos5l_decap_8
X_3181_ _3181_/Y _3181_/A _3394_/A _3181_/C VPWR VGND sg13cmos5l_nand3_1
XFILLER_19_250 VPWR VGND sg13cmos5l_fill_2
XFILLER_35_710 VPWR VGND sg13cmos5l_fill_1
XFILLER_35_743 VPWR VGND sg13cmos5l_fill_1
XFILLER_22_415 VPWR VGND sg13cmos5l_decap_8
XFILLER_23_927 VPWR VGND sg13cmos5l_decap_8
XFILLER_34_264 VPWR VGND sg13cmos5l_fill_1
XFILLER_34_275 VPWR VGND sg13cmos5l_decap_4
X_2965_ _2967_/B _2964_/Y _2943_/X _2965_/S VPWR VGND sg13cmos5l_mux2_1
XFILLER_31_971 VPWR VGND sg13cmos5l_decap_8
XFILLER_33_1004 VPWR VGND sg13cmos5l_decap_8
X_2896_ _2896_/Y _2896_/A _2896_/B VPWR VGND sg13cmos5l_nand2_1
Xhold611 _4074_/D _2756_/Y VPWR VGND sg13cmos5l_dlygate4sd3_1
Xhold600 _2880_/B _4076_/Q VPWR VGND sg13cmos5l_dlygate4sd3_1
Xhold622 _4015_/D _2433_/Y VPWR VGND sg13cmos5l_dlygate4sd3_1
X_3517_ _3517_/Y _4236_/Q _3522_/B _3516_/Y VPWR VGND sg13cmos5l_a21oi_1
Xhold633 _2172_/A _4191_/Q VPWR VGND sg13cmos5l_dlygate4sd3_1
Xhold644 _2183_/A _4099_/Q VPWR VGND sg13cmos5l_dlygate4sd3_1
Xhold666 hold666/X _4012_/Q VPWR VGND sg13cmos5l_dlygate4sd3_1
Xhold688 hold688/X _3955_/Q VPWR VGND sg13cmos5l_dlygate4sd3_1
Xhold655 hold655/X _3905_/Q VPWR VGND sg13cmos5l_dlygate4sd3_1
Xhold677 hold677/X _3979_/Q VPWR VGND sg13cmos5l_dlygate4sd3_1
X_3448_ _3448_/Y _3435_/Y _3440_/Y _3390_/B VPWR VGND sg13cmos5l_o21ai_1
Xhold699 hold699/X _3994_/Q VPWR VGND sg13cmos5l_dlygate4sd3_1
X_3379_ _4188_/D _3367_/Y hold882/X _3373_/A VPWR VGND sg13cmos5l_a21oi_1
XFILLER_38_570 VPWR VGND sg13cmos5l_fill_1
XFILLER_26_710 VPWR VGND sg13cmos5l_decap_4
XFILLER_26_754 VPWR VGND sg13cmos5l_fill_2
XFILLER_40_201 VPWR VGND sg13cmos5l_decap_8
XFILLER_14_916 VPWR VGND sg13cmos5l_decap_8
XFILLER_40_212 VPWR VGND sg13cmos5l_fill_2
XFILLER_41_779 VPWR VGND sg13cmos5l_decap_4
XFILLER_22_993 VPWR VGND sg13cmos5l_decap_8
XFILLER_5_614 VPWR VGND sg13cmos5l_decap_4
XFILLER_5_636 VPWR VGND sg13cmos5l_decap_4
XFILLER_4_102 VPWR VGND sg13cmos5l_decap_8
XFILLER_4_179 VPWR VGND sg13cmos5l_decap_8
XFILLER_1_820 VPWR VGND sg13cmos5l_decap_8
XFILLER_0_352 VPWR VGND sg13cmos5l_decap_4
XFILLER_1_897 VPWR VGND sg13cmos5l_decap_8
XFILLER_49_835 VPWR VGND sg13cmos5l_decap_8
X_4217__418 _4217_/RESET_B VPWR VGND sg13cmos5l_tiehi
XFILLER_1_1002 VPWR VGND sg13cmos5l_decap_8
X_4070__176 _4070_/D VPWR VGND sg13cmos5l_tielo
XFILLER_32_746 VPWR VGND sg13cmos5l_fill_2
XFILLER_32_779 VPWR VGND sg13cmos5l_fill_1
XFILLER_8_430 VPWR VGND sg13cmos5l_fill_2
X_2750_ _4071_/D _3547_/A _2750_/B VPWR VGND sg13cmos5l_and2_1
X_2681_ _2682_/C _2644_/A _2677_/X _2680_/Y VPWR VGND sg13cmos5l_a21oi_1
XFILLER_9_997 VPWR VGND sg13cmos5l_decap_8
XFILLER_8_496 VPWR VGND sg13cmos5l_decap_4
XFILLER_8_485 VPWR VGND sg13cmos5l_fill_2
X_4042__223 _4042_/RESET_B VPWR VGND sg13cmos5l_tiehi
XFILLER_4_691 VPWR VGND sg13cmos5l_decap_8
X_3302_ _3303_/B _3397_/A _3397_/B VPWR VGND sg13cmos5l_and2_1
X_3233_ _3249_/B _4161_/Q _4133_/Q _4166_/Q VPWR VGND sg13cmos5l_nand3_1
XFILLER_39_367 VPWR VGND sg13cmos5l_fill_2
XFILLER_39_356 VPWR VGND sg13cmos5l_decap_8
XFILLER_39_345 VPWR VGND sg13cmos5l_fill_2
X_3164_ _3164_/X _3137_/B _3137_/C _3167_/B VPWR VGND sg13cmos5l_a21o_1
X_3095_ _3095_/Y _3380_/B _3389_/A VPWR VGND sg13cmos5l_nand2b_1
Xfanout38 _3733_/B _3719_/Y VPWR VGND sg13cmos5l_buf_1
Xfanout27 _2755_/A2 _2544_/Y VPWR VGND sg13cmos5l_buf_1
XFILLER_35_595 VPWR VGND sg13cmos5l_decap_8
X_3997_ _3997_/Q _4031_/CLK _3997_/D _3997_/RESET_B VPWR VGND sg13cmos5l_dfrbpq_1
XFILLER_11_908 VPWR VGND sg13cmos5l_fill_2
Xfanout49 _3347_/A _3373_/A VPWR VGND sg13cmos5l_buf_1
XFILLER_22_245 VPWR VGND sg13cmos5l_decap_8
XFILLER_23_768 VPWR VGND sg13cmos5l_fill_2
X_2948_ _2948_/Y _4113_/Q _4112_/Q _4138_/Q VPWR VGND sg13cmos5l_nand3b_1
X_2879_ _4101_/D _3041_/A _2879_/B VPWR VGND sg13cmos5l_and2_1
XFILLER_2_617 VPWR VGND sg13cmos5l_decap_4
XFILLER_46_849 VPWR VGND sg13cmos5l_decap_8
XFILLER_45_359 VPWR VGND sg13cmos5l_fill_1
X_4019__269 _4019_/RESET_B VPWR VGND sg13cmos5l_tiehi
XFILLER_14_724 VPWR VGND sg13cmos5l_decap_4
XFILLER_41_554 VPWR VGND sg13cmos5l_decap_8
XFILLER_9_238 VPWR VGND sg13cmos5l_fill_2
XFILLER_22_790 VPWR VGND sg13cmos5l_decap_8
XFILLER_6_912 VPWR VGND sg13cmos5l_decap_8
XFILLER_5_411 VPWR VGND sg13cmos5l_fill_1
XFILLER_6_989 VPWR VGND sg13cmos5l_decap_8
XFILLER_5_488 VPWR VGND sg13cmos5l_decap_8
XFILLER_0_193 VPWR VGND sg13cmos5l_decap_8
XFILLER_49_687 VPWR VGND sg13cmos5l_decap_8
XFILLER_37_827 VPWR VGND sg13cmos5l_decap_8
X_3920_ _3920_/Q _4280_/CLK _3920_/D _3920_/RESET_B VPWR VGND sg13cmos5l_dfrbpq_1
X_3851_ _3881_/D hold755/X _3871_/A0 _3854_/S VPWR VGND sg13cmos5l_mux2_1
X_2802_ _2802_/X _2802_/A _2806_/A VPWR VGND sg13cmos5l_xor2_1
X_3782_ _3797_/B _3782_/A _3782_/B VPWR VGND sg13cmos5l_or2_1
X_2733_ _2733_/Y _2885_/A _2883_/A _2737_/B VPWR VGND sg13cmos5l_nand3_1
X_4228__399 _4228_/RESET_B VPWR VGND sg13cmos5l_tiehi
XFILLER_30_1018 VPWR VGND sg13cmos5l_decap_8
X_2664_ _2664_/Y _2665_/A1 _2663_/Y _4040_/Q VPWR VGND sg13cmos5l_a21oi_1
X_2595_ _2595_/Y _2665_/A1 _2586_/Y _2594_/Y VPWR VGND sg13cmos5l_o21ai_1
X_4265_ _4265_/Q _4265_/CLK _4265_/D _4265_/RESET_B VPWR VGND sg13cmos5l_dfrbpq_1
X_4196_ _4196_/Q _4227_/CLK _4196_/D _4196_/RESET_B VPWR VGND sg13cmos5l_dfrbpq_1
X_3216_ _4168_/D _3216_/A _3217_/B VPWR VGND sg13cmos5l_and2_1
XFILLER_39_175 VPWR VGND sg13cmos5l_decap_4
XFILLER_27_326 VPWR VGND sg13cmos5l_decap_8
XFILLER_28_827 VPWR VGND sg13cmos5l_decap_8
X_3147_ _3147_/X _3147_/A _3167_/A VPWR VGND sg13cmos5l_and2_1
XFILLER_39_1021 VPWR VGND sg13cmos5l_decap_8
X_3078_ _3079_/B _3078_/A _3078_/B VPWR VGND sg13cmos5l_nand2_1
XFILLER_11_705 VPWR VGND sg13cmos5l_fill_1
XFILLER_7_709 VPWR VGND sg13cmos5l_decap_8
XFILLER_10_237 VPWR VGND sg13cmos5l_decap_8
XFILLER_40_24 VPWR VGND sg13cmos5l_fill_1
X_4207__428 _4207_/RESET_B VPWR VGND sg13cmos5l_tiehi
XFILLER_3_937 VPWR VGND sg13cmos5l_decap_8
XFILLER_49_11 VPWR VGND sg13cmos5l_decap_8
XFILLER_46_1003 VPWR VGND sg13cmos5l_decap_8
XFILLER_1_18 VPWR VGND sg13cmos5l_decap_4
XFILLER_46_624 VPWR VGND sg13cmos5l_decap_4
XFILLER_19_849 VPWR VGND sg13cmos5l_decap_4
XFILLER_46_646 VPWR VGND sg13cmos5l_decap_8
XFILLER_26_370 VPWR VGND sg13cmos5l_fill_2
XFILLER_26_392 VPWR VGND sg13cmos5l_fill_2
XFILLER_14_543 VPWR VGND sg13cmos5l_fill_1
X_4264__566 _4264_/RESET_B VPWR VGND sg13cmos5l_tiehi
XFILLER_10_771 VPWR VGND sg13cmos5l_decap_8
X_2380_ _3977_/D _3863_/A0 hold763/X _2381_/S VPWR VGND sg13cmos5l_mux2_1
XFILLER_1_480 VPWR VGND sg13cmos5l_decap_8
XFILLER_49_440 VPWR VGND sg13cmos5l_decap_8
X_4050_ _4050_/Q _4280_/CLK _4050_/D _4050_/RESET_B VPWR VGND sg13cmos5l_dfrbpq_1
Xinput6 input6/X uio_in[0] VPWR VGND sg13cmos5l_buf_1
X_3001_ _3001_/Y _4095_/Q _3215_/A VPWR VGND sg13cmos5l_nor2_1
XFILLER_17_381 VPWR VGND sg13cmos5l_fill_1
XFILLER_33_830 VPWR VGND sg13cmos5l_decap_8
X_3903_ _3903_/Q _4280_/CLK _3903_/D _3903_/RESET_B VPWR VGND sg13cmos5l_dfrbpq_1
XFILLER_32_340 VPWR VGND sg13cmos5l_fill_1
X_3834_ _3834_/X _2496_/A _3833_/Y _2502_/B VPWR VGND sg13cmos5l_a21o_1
XFILLER_20_513 VPWR VGND sg13cmos5l_fill_2
X_3765_ _3765_/X _3776_/S _3765_/B VPWR VGND sg13cmos5l_or2_1
X_2716_ _2721_/A _2712_/Y _2715_/Y _2702_/Y VPWR VGND sg13cmos5l_o21ai_1
X_3696_ _3697_/B _3676_/B _2168_/Y _3698_/S VPWR VGND sg13cmos5l_mux2_1
X_2647_ _2648_/B _2647_/A _2647_/B _2647_/C VPWR VGND sg13cmos5l_nand3_1
XFILLER_0_907 VPWR VGND sg13cmos5l_decap_8
X_2578_ _2579_/B _4041_/Q _2578_/B VPWR VGND sg13cmos5l_nand2_1
X_4248_ _4248_/Q _4265_/CLK _4248_/D _4248_/RESET_B VPWR VGND sg13cmos5l_dfrbpq_1
XFILLER_28_624 VPWR VGND sg13cmos5l_decap_8
X_4179_ _4179_/Q _4231_/CLK _4179_/D _4179_/RESET_B VPWR VGND sg13cmos5l_dfrbpq_1
XFILLER_27_112 VPWR VGND sg13cmos5l_decap_4
XFILLER_43_616 VPWR VGND sg13cmos5l_decap_8
XFILLER_28_679 VPWR VGND sg13cmos5l_fill_2
XFILLER_35_79 VPWR VGND sg13cmos5l_decap_8
XFILLER_11_502 VPWR VGND sg13cmos5l_fill_2
XFILLER_23_395 VPWR VGND sg13cmos5l_decap_8
XFILLER_3_701 VPWR VGND sg13cmos5l_fill_1
XFILLER_2_244 VPWR VGND sg13cmos5l_fill_2
XFILLER_47_966 VPWR VGND sg13cmos5l_decap_8
XFILLER_20_1006 VPWR VGND sg13cmos5l_decap_8
XFILLER_46_454 VPWR VGND sg13cmos5l_decap_8
XFILLER_19_668 VPWR VGND sg13cmos5l_fill_1
XFILLER_46_487 VPWR VGND sg13cmos5l_decap_8
XFILLER_27_690 VPWR VGND sg13cmos5l_fill_2
XFILLER_14_362 VPWR VGND sg13cmos5l_fill_1
X_3550_ _3550_/Y _2162_/A _3708_/A2 _3389_/A VPWR VGND sg13cmos5l_o21ai_1
X_2501_ _2501_/Y _4277_/Q _2500_/X hold940/X VPWR VGND sg13cmos5l_o21ai_1
X_3481_ _3589_/A _3468_/X _3480_/Y _3483_/S VPWR VGND sg13cmos5l_mux2_1
X_2432_ _2432_/Y _2198_/Y _2430_/B _2466_/A VPWR VGND sg13cmos5l_o21ai_1
X_2363_ _2371_/S _3846_/D _2372_/B VPWR VGND sg13cmos5l_nand2_1
X_4102_ _4102_/Q _4129_/CLK _4102_/D _4102_/RESET_B VPWR VGND sg13cmos5l_dfrbpq_1
XFILLER_38_900 VPWR VGND sg13cmos5l_decap_8
X_4033_ _4033_/Q clkload4/A _4033_/D _4033_/RESET_B VPWR VGND sg13cmos5l_dfrbpq_1
X_2294_ _3903_/D _3866_/A0 hold658/X _2301_/S VPWR VGND sg13cmos5l_mux2_1
XFILLER_38_977 VPWR VGND sg13cmos5l_decap_8
XFILLER_24_137 VPWR VGND sg13cmos5l_fill_1
XFILLER_36_1024 VPWR VGND sg13cmos5l_decap_4
XFILLER_21_844 VPWR VGND sg13cmos5l_decap_4
X_3817_ _3818_/A _4274_/Q _4272_/Q VPWR VGND sg13cmos5l_nor2_1
XFILLER_21_899 VPWR VGND sg13cmos5l_decap_4
X_3748_ _3774_/B _4214_/Q _3748_/B VPWR VGND sg13cmos5l_xor2_1
XFILLER_21_15 VPWR VGND sg13cmos5l_fill_2
X_3679_ _3680_/C _3677_/Y _3679_/B VPWR VGND sg13cmos5l_nand2b_1
XFILLER_0_704 VPWR VGND sg13cmos5l_decap_8
XFILLER_43_1028 VPWR VGND sg13cmos5l_fill_1
XFILLER_43_1017 VPWR VGND sg13cmos5l_decap_8
XFILLER_29_900 VPWR VGND sg13cmos5l_fill_2
XFILLER_29_933 VPWR VGND sg13cmos5l_decap_8
XFILLER_44_925 VPWR VGND sg13cmos5l_decap_8
XFILLER_28_443 VPWR VGND sg13cmos5l_decap_8
XFILLER_28_476 VPWR VGND sg13cmos5l_fill_2
XFILLER_43_413 VPWR VGND sg13cmos5l_fill_2
XFILLER_15_159 VPWR VGND sg13cmos5l_fill_1
XFILLER_30_118 VPWR VGND sg13cmos5l_decap_4
XFILLER_8_837 VPWR VGND sg13cmos5l_decap_8
XFILLER_7_303 VPWR VGND sg13cmos5l_fill_2
XFILLER_12_899 VPWR VGND sg13cmos5l_decap_8
XFILLER_7_347 VPWR VGND sg13cmos5l_decap_8
XFILLER_11_398 VPWR VGND sg13cmos5l_fill_2
XFILLER_4_1022 VPWR VGND sg13cmos5l_decap_8
XFILLER_47_763 VPWR VGND sg13cmos5l_decap_8
XFILLER_35_914 VPWR VGND sg13cmos5l_decap_8
X_4073__185 _4073_/RESET_B VPWR VGND sg13cmos5l_tiehi
X_2981_ _2981_/Y _4109_/Q _2994_/B _2979_/Y _2980_/Y VPWR VGND sg13cmos5l_a22oi_1
XFILLER_30_663 VPWR VGND sg13cmos5l_fill_1
X_3602_ _3603_/B _3602_/A _3602_/B VPWR VGND sg13cmos5l_xnor2_1
XFILLER_30_685 VPWR VGND sg13cmos5l_decap_8
Xhold826 _2166_/A _4248_/Q VPWR VGND sg13cmos5l_dlygate4sd3_1
X_3533_ _3533_/Y _4218_/Q _3529_/Y _3532_/Y _4217_/Q VPWR VGND sg13cmos5l_a22oi_1
Xhold804 hold804/X _3893_/Q VPWR VGND sg13cmos5l_dlygate4sd3_1
Xhold815 hold815/X _4010_/Q VPWR VGND sg13cmos5l_dlygate4sd3_1
Xhold837 _2247_/B _4270_/Q VPWR VGND sg13cmos5l_dlygate4sd3_1
X_3464_ _3473_/C _4208_/Q _4207_/Q _4209_/Q VPWR VGND sg13cmos5l_o21ai_1
Xhold848 _2212_/A _4237_/Q VPWR VGND sg13cmos5l_dlygate4sd3_1
Xhold859 hold859/X _3201_/Y VPWR VGND sg13cmos5l_dlygate4sd3_1
X_2415_ _4006_/D _2415_/A0 hold789/X _2421_/S VPWR VGND sg13cmos5l_mux2_1
X_3395_ _3395_/Y _3313_/A _3313_/B _3432_/B VPWR VGND sg13cmos5l_o21ai_1
X_2346_ _3947_/D hold773/X _2415_/A0 _2351_/S VPWR VGND sg13cmos5l_mux2_1
X_2277_ _4279_/D _2282_/B _2277_/B VPWR VGND sg13cmos5l_nand2_1
XFILLER_38_763 VPWR VGND sg13cmos5l_decap_8
XFILLER_37_240 VPWR VGND sg13cmos5l_decap_4
X_4016_ _4016_/Q clkload4/A _4016_/D _4016_/RESET_B VPWR VGND sg13cmos5l_dfrbpq_1
XFILLER_37_273 VPWR VGND sg13cmos5l_fill_2
XFILLER_26_925 VPWR VGND sg13cmos5l_decap_8
XFILLER_26_958 VPWR VGND sg13cmos5l_decap_8
XFILLER_12_118 VPWR VGND sg13cmos5l_fill_1
XFILLER_20_151 VPWR VGND sg13cmos5l_fill_1
XFILLER_21_696 VPWR VGND sg13cmos5l_decap_8
XFILLER_32_69 VPWR VGND sg13cmos5l_fill_2
XFILLER_4_328 VPWR VGND sg13cmos5l_decap_8
XFILLER_16_424 VPWR VGND sg13cmos5l_fill_2
XFILLER_43_243 VPWR VGND sg13cmos5l_decap_4
XFILLER_43_221 VPWR VGND sg13cmos5l_fill_2
XFILLER_25_980 VPWR VGND sg13cmos5l_decap_8
XFILLER_31_416 VPWR VGND sg13cmos5l_decap_4
XFILLER_32_928 VPWR VGND sg13cmos5l_decap_8
Xclkbuf_leaf_23_clk clkload3/A clkbuf_leaf_4_clk/A VPWR VGND sg13cmos5l_buf_8
XFILLER_31_438 VPWR VGND sg13cmos5l_decap_8
XFILLER_40_961 VPWR VGND sg13cmos5l_decap_8
X_4029__249 _4029_/RESET_B VPWR VGND sg13cmos5l_tiehi
X_2200_ _2434_/A input4/X VPWR VGND sg13cmos5l_inv_1
XFILLER_26_1001 VPWR VGND sg13cmos5l_decap_8
X_3180_ _3180_/Y _4124_/Q _3180_/B VPWR VGND sg13cmos5l_nand2_1
XFILLER_14_4 VPWR VGND sg13cmos5l_decap_4
XFILLER_47_571 VPWR VGND sg13cmos5l_fill_2
XFILLER_47_560 VPWR VGND sg13cmos5l_decap_8
XFILLER_35_766 VPWR VGND sg13cmos5l_decap_4
XFILLER_35_799 VPWR VGND sg13cmos5l_decap_8
X_2964_ _2964_/Y _2964_/A _3137_/A VPWR VGND sg13cmos5l_nand2_1
Xclkbuf_leaf_14_clk _4168_/CLK clkload1/A VPWR VGND sg13cmos5l_buf_8
X_2895_ _2895_/Y _2910_/A VPWR VGND sg13cmos5l_inv_1
Xhold612 _2227_/A _3897_/Q VPWR VGND sg13cmos5l_dlygate4sd3_1
Xhold601 _2896_/B _4077_/Q VPWR VGND sg13cmos5l_dlygate4sd3_1
X_3516_ _3516_/Y _3713_/A _4187_/Q _4186_/Q _3712_/A _3515_/Y VPWR VGND sg13cmos5l_a221oi_1
Xhold623 _2502_/A _4273_/Q VPWR VGND sg13cmos5l_dlygate4sd3_1
Xhold634 _4223_/D _3549_/Y VPWR VGND sg13cmos5l_dlygate4sd3_1
Xhold645 _2872_/B _4071_/Q VPWR VGND sg13cmos5l_dlygate4sd3_1
Xhold656 hold656/X _3927_/Q VPWR VGND sg13cmos5l_dlygate4sd3_1
Xhold678 hold678/X _3908_/Q VPWR VGND sg13cmos5l_dlygate4sd3_1
Xhold667 hold667/X _3924_/Q VPWR VGND sg13cmos5l_dlygate4sd3_1
X_3447_ _4204_/D _3429_/Y _3440_/Y _3446_/Y VPWR VGND sg13cmos5l_a21oi_1
Xhold689 hold689/X _4008_/Q VPWR VGND sg13cmos5l_dlygate4sd3_1
X_3378_ _3378_/Y _3378_/A _3378_/B VPWR VGND sg13cmos5l_nand2_1
X_2329_ _3933_/D _3872_/A0 hold803/X _2331_/S VPWR VGND sg13cmos5l_mux2_1
XFILLER_27_69 VPWR VGND sg13cmos5l_decap_8
XFILLER_25_221 VPWR VGND sg13cmos5l_decap_8
XFILLER_13_405 VPWR VGND sg13cmos5l_decap_4
XFILLER_14_939 VPWR VGND sg13cmos5l_decap_8
XFILLER_41_747 VPWR VGND sg13cmos5l_fill_2
XFILLER_40_235 VPWR VGND sg13cmos5l_fill_2
XFILLER_40_224 VPWR VGND sg13cmos5l_decap_8
XFILLER_13_449 VPWR VGND sg13cmos5l_decap_4
XFILLER_25_298 VPWR VGND sg13cmos5l_fill_1
XFILLER_43_57 VPWR VGND sg13cmos5l_fill_1
XFILLER_22_950 VPWR VGND sg13cmos5l_decap_8
XFILLER_21_482 VPWR VGND sg13cmos5l_decap_8
XFILLER_5_604 VPWR VGND sg13cmos5l_fill_2
XFILLER_5_659 VPWR VGND sg13cmos5l_decap_8
XFILLER_49_814 VPWR VGND sg13cmos5l_decap_8
XFILLER_1_876 VPWR VGND sg13cmos5l_decap_8
XFILLER_0_397 VPWR VGND sg13cmos5l_decap_8
X_3894__228 _3894_/RESET_B VPWR VGND sg13cmos5l_tiehi
XFILLER_17_722 VPWR VGND sg13cmos5l_fill_2
XFILLER_44_530 VPWR VGND sg13cmos5l_fill_1
XFILLER_17_80 VPWR VGND sg13cmos5l_decap_8
XFILLER_17_91 VPWR VGND sg13cmos5l_fill_1
XFILLER_44_585 VPWR VGND sg13cmos5l_decap_8
XFILLER_16_298 VPWR VGND sg13cmos5l_fill_2
XFILLER_31_213 VPWR VGND sg13cmos5l_decap_8
XFILLER_20_909 VPWR VGND sg13cmos5l_fill_2
XFILLER_40_791 VPWR VGND sg13cmos5l_decap_8
X_2680_ _2680_/Y _2680_/A1 _2679_/Y _2647_/A VPWR VGND sg13cmos5l_o21ai_1
XFILLER_8_453 VPWR VGND sg13cmos5l_decap_8
XFILLER_8_442 VPWR VGND sg13cmos5l_fill_1
XFILLER_9_976 VPWR VGND sg13cmos5l_decap_8
XFILLER_12_493 VPWR VGND sg13cmos5l_decap_8
XFILLER_4_670 VPWR VGND sg13cmos5l_fill_1
X_3301_ _3397_/B hold1004/X _3305_/B _3301_/C VPWR VGND sg13cmos5l_nand3b_1
XFILLER_3_180 VPWR VGND sg13cmos5l_fill_2
XFILLER_3_191 VPWR VGND sg13cmos5l_decap_8
Xclkbuf_leaf_3_clk _4280_/CLK clkbuf_leaf_3_clk/A VPWR VGND sg13cmos5l_buf_8
X_3232_ _3249_/A _3246_/A _3246_/B VPWR VGND sg13cmos5l_nand2_1
X_3163_ _4149_/D _3169_/A _3163_/B VPWR VGND sg13cmos5l_nor2_1
X_4237__390 _4237_/RESET_B VPWR VGND sg13cmos5l_tiehi
X_3094_ _3094_/Y _3272_/A _3380_/B VPWR VGND sg13cmos5l_nor2_1
XFILLER_22_224 VPWR VGND sg13cmos5l_decap_8
Xfanout28 _3864_/S _3862_/S VPWR VGND sg13cmos5l_buf_1
Xfanout39 _3591_/B _3601_/B VPWR VGND sg13cmos5l_buf_1
X_3996_ _3996_/Q _4031_/CLK _3996_/D _3996_/RESET_B VPWR VGND sg13cmos5l_dfrbpq_1
X_2947_ _2959_/B _4112_/Q _4113_/Q VPWR VGND sg13cmos5l_xnor2_1
XFILLER_31_780 VPWR VGND sg13cmos5l_decap_4
X_2878_ _4100_/D _2185_/Y _3035_/A2 _2877_/Y VPWR VGND sg13cmos5l_a21oi_1
X_4279__446 _4279_/RESET_B VPWR VGND sg13cmos5l_tiehi
X_4238__154 _4238_/D VPWR VGND sg13cmos5l_tielo
XFILLER_46_828 VPWR VGND sg13cmos5l_decap_8
XFILLER_13_279 VPWR VGND sg13cmos5l_decap_8
XFILLER_6_968 VPWR VGND sg13cmos5l_decap_8
XFILLER_5_423 VPWR VGND sg13cmos5l_decap_8
XFILLER_1_662 VPWR VGND sg13cmos5l_fill_1
XFILLER_49_655 VPWR VGND sg13cmos5l_decap_8
XFILLER_17_541 VPWR VGND sg13cmos5l_fill_2
XFILLER_17_563 VPWR VGND sg13cmos5l_fill_2
XFILLER_45_894 VPWR VGND sg13cmos5l_decap_8
XFILLER_44_382 VPWR VGND sg13cmos5l_decap_4
XFILLER_17_596 VPWR VGND sg13cmos5l_fill_2
XFILLER_32_533 VPWR VGND sg13cmos5l_fill_1
X_3850_ _3880_/D hold759/X _3859_/A0 _3854_/S VPWR VGND sg13cmos5l_mux2_1
X_2801_ _2806_/A _4086_/Q _4085_/Q _4087_/Q VPWR VGND sg13cmos5l_nor3_1
X_3781_ _3782_/B _3781_/A _4216_/Q _3781_/C VPWR VGND sg13cmos5l_nor3_1
X_2732_ _2737_/B _2713_/Y _2730_/Y _2731_/Y _4084_/Q VPWR VGND sg13cmos5l_a22oi_1
XFILLER_9_740 VPWR VGND sg13cmos5l_decap_8
XFILLER_8_261 VPWR VGND sg13cmos5l_fill_1
X_2663_ _2663_/Y _2659_/Y _2660_/Y _2662_/Y VPWR VGND sg13cmos5l_o21ai_1
X_2594_ _2594_/Y _2665_/A1 _2593_/Y _4040_/Q VPWR VGND sg13cmos5l_a21oi_1
XFILLER_5_50 VPWR VGND sg13cmos5l_fill_1
X_4264_ _4264_/Q clkload3/A _4264_/D _4264_/RESET_B VPWR VGND sg13cmos5l_dfrbpq_1
X_3215_ _4167_/D _3215_/A _3215_/B VPWR VGND sg13cmos5l_nor2_1
X_4157__163 _4157_/D VPWR VGND sg13cmos5l_tielo
X_4195_ _4195_/Q _4227_/CLK _4195_/D _4195_/RESET_B VPWR VGND sg13cmos5l_dfrbpq_1
X_3146_ _3159_/B _3167_/B VPWR VGND sg13cmos5l_inv_1
XFILLER_39_198 VPWR VGND sg13cmos5l_fill_1
X_3077_ _3078_/B _3077_/A _3077_/B _3077_/C VPWR VGND sg13cmos5l_nand3_1
XFILLER_39_1000 VPWR VGND sg13cmos5l_decap_8
XFILLER_36_883 VPWR VGND sg13cmos5l_decap_8
XFILLER_23_555 VPWR VGND sg13cmos5l_fill_2
XFILLER_10_216 VPWR VGND sg13cmos5l_decap_8
XFILLER_24_59 VPWR VGND sg13cmos5l_decap_8
X_3979_ _3979_/Q clkload5/A _3979_/D _3979_/RESET_B VPWR VGND sg13cmos5l_dfrbpq_1
XFILLER_3_916 VPWR VGND sg13cmos5l_decap_8
XFILLER_49_67 VPWR VGND sg13cmos5l_fill_2
XFILLER_33_308 VPWR VGND sg13cmos5l_decap_8
XFILLER_33_319 VPWR VGND sg13cmos5l_fill_2
XFILLER_42_853 VPWR VGND sg13cmos5l_decap_4
X_4069__190 _4069_/RESET_B VPWR VGND sg13cmos5l_tiehi
XFILLER_10_750 VPWR VGND sg13cmos5l_fill_1
XFILLER_5_231 VPWR VGND sg13cmos5l_fill_2
XFILLER_46_7 VPWR VGND sg13cmos5l_decap_4
XFILLER_2_982 VPWR VGND sg13cmos5l_decap_8
X_3000_ _4119_/D _3000_/A _3000_/B VPWR VGND sg13cmos5l_and2_1
Xinput7 input7/X uio_in[1] VPWR VGND sg13cmos5l_buf_1
X_4158__483 _4158_/RESET_B VPWR VGND sg13cmos5l_tiehi
XFILLER_25_809 VPWR VGND sg13cmos5l_decap_4
X_4234__393 _4234_/RESET_B VPWR VGND sg13cmos5l_tiehi
X_3902_ _3902_/Q clkload3/A _3902_/D _3902_/RESET_B VPWR VGND sg13cmos5l_dfrbpq_1
XFILLER_17_393 VPWR VGND sg13cmos5l_fill_2
XFILLER_33_864 VPWR VGND sg13cmos5l_fill_1
X_3833_ _3833_/Y _3832_/Y _3833_/B VPWR VGND sg13cmos5l_nand2b_1
XFILLER_33_886 VPWR VGND sg13cmos5l_fill_1
X_3764_ _3765_/B _4235_/Q _4238_/Q _3764_/C VPWR VGND sg13cmos5l_nor3_1
X_2715_ _2715_/Y _2704_/Y _2707_/A _2837_/A VPWR VGND sg13cmos5l_o21ai_1
X_3695_ _3695_/Y _3680_/A _3698_/S hold818/X VPWR VGND sg13cmos5l_a21oi_1
X_2646_ _2647_/C _2646_/A _2646_/B VPWR VGND sg13cmos5l_nand2_1
X_2577_ _2578_/B _2647_/A _2577_/B _2577_/C VPWR VGND sg13cmos5l_nand3_1
X_4247_ _4247_/Q _4265_/CLK _4247_/D _4247_/RESET_B VPWR VGND sg13cmos5l_dfrbpq_1
XFILLER_19_37 VPWR VGND sg13cmos5l_fill_1
X_4178_ _4178_/Q _4231_/CLK _4178_/D _4178_/RESET_B VPWR VGND sg13cmos5l_dfrbpq_1
XFILLER_19_48 VPWR VGND sg13cmos5l_decap_4
XFILLER_27_135 VPWR VGND sg13cmos5l_decap_4
X_4213__422 _4213_/RESET_B VPWR VGND sg13cmos5l_tiehi
X_3129_ _3255_/A _3099_/Y _3112_/X _3115_/Y VPWR VGND sg13cmos5l_o21ai_1
XFILLER_24_842 VPWR VGND sg13cmos5l_fill_2
XFILLER_23_374 VPWR VGND sg13cmos5l_decap_8
XFILLER_11_536 VPWR VGND sg13cmos5l_decap_8
XFILLER_11_558 VPWR VGND sg13cmos5l_decap_4
XFILLER_2_201 VPWR VGND sg13cmos5l_decap_8
XFILLER_2_278 VPWR VGND sg13cmos5l_decap_8
XFILLER_47_945 VPWR VGND sg13cmos5l_decap_8
XFILLER_46_422 VPWR VGND sg13cmos5l_decap_4
XFILLER_18_102 VPWR VGND sg13cmos5l_decap_4
XFILLER_19_658 VPWR VGND sg13cmos5l_fill_1
XFILLER_34_617 VPWR VGND sg13cmos5l_decap_8
XFILLER_33_149 VPWR VGND sg13cmos5l_fill_2
XFILLER_42_683 VPWR VGND sg13cmos5l_fill_2
XFILLER_14_341 VPWR VGND sg13cmos5l_decap_8
XFILLER_41_182 VPWR VGND sg13cmos5l_decap_8
XFILLER_41_171 VPWR VGND sg13cmos5l_fill_2
XFILLER_41_160 VPWR VGND sg13cmos5l_decap_8
XFILLER_10_580 VPWR VGND sg13cmos5l_fill_1
XFILLER_6_540 VPWR VGND sg13cmos5l_decap_8
X_3480_ _3480_/Y _3712_/A _3480_/B VPWR VGND sg13cmos5l_nand2_1
X_2500_ _2500_/X _4275_/Q _2264_/Y _2497_/C VPWR VGND sg13cmos5l_a21o_1
X_2431_ _2431_/Y _3875_/A _3875_/B VPWR VGND sg13cmos5l_nor2_1
XFILLER_44_4 VPWR VGND sg13cmos5l_fill_2
XFILLER_29_1021 VPWR VGND sg13cmos5l_decap_8
X_2362_ _2372_/B _2474_/B _2352_/C VPWR VGND sg13cmos5l_nor2b_1
X_2293_ _3902_/D _3865_/A0 hold657/X _2301_/S VPWR VGND sg13cmos5l_mux2_1
X_4101_ _4101_/Q _4129_/CLK _4101_/D _4101_/RESET_B VPWR VGND sg13cmos5l_dfrbpq_1
XFILLER_37_400 VPWR VGND sg13cmos5l_fill_1
X_4032_ _4032_/Q clkload4/A _4032_/D _4032_/RESET_B VPWR VGND sg13cmos5l_dfrbpq_1
X_4039__229 _4039_/RESET_B VPWR VGND sg13cmos5l_tiehi
XFILLER_38_956 VPWR VGND sg13cmos5l_decap_8
XFILLER_37_433 VPWR VGND sg13cmos5l_decap_8
XFILLER_2_73 VPWR VGND sg13cmos5l_fill_2
XFILLER_36_1003 VPWR VGND sg13cmos5l_decap_8
X_3989__302 _3989_/RESET_B VPWR VGND sg13cmos5l_tiehi
XFILLER_21_823 VPWR VGND sg13cmos5l_decap_8
XFILLER_20_333 VPWR VGND sg13cmos5l_fill_1
X_3816_ _4264_/D _3805_/A _3736_/B _3815_/A VPWR VGND sg13cmos5l_a21oi_1
X_3747_ _3747_/Y _4214_/Q _3748_/B VPWR VGND sg13cmos5l_xnor2_1
XFILLER_20_388 VPWR VGND sg13cmos5l_decap_4
XFILLER_21_38 VPWR VGND sg13cmos5l_decap_4
X_3678_ _3679_/B _4265_/Q _3686_/B _3678_/C VPWR VGND sg13cmos5l_nand3b_1
X_2629_ _2629_/X _2675_/C1 _2628_/X _2627_/Y VPWR VGND sg13cmos5l_a21o_1
XFILLER_29_923 VPWR VGND sg13cmos5l_fill_1
XFILLER_28_411 VPWR VGND sg13cmos5l_decap_4
XFILLER_44_904 VPWR VGND sg13cmos5l_decap_8
XFILLER_16_639 VPWR VGND sg13cmos5l_decap_8
XFILLER_12_823 VPWR VGND sg13cmos5l_decap_8
XFILLER_23_171 VPWR VGND sg13cmos5l_decap_8
XFILLER_7_315 VPWR VGND sg13cmos5l_decap_4
XFILLER_7_337 VPWR VGND sg13cmos5l_decap_4
X_4148__493 _4148_/RESET_B VPWR VGND sg13cmos5l_tiehi
X_4066__193 _4066_/RESET_B VPWR VGND sg13cmos5l_tiehi
XFILLER_3_521 VPWR VGND sg13cmos5l_fill_2
XFILLER_3_543 VPWR VGND sg13cmos5l_decap_8
XFILLER_3_587 VPWR VGND sg13cmos5l_decap_8
XFILLER_4_1001 VPWR VGND sg13cmos5l_decap_8
XFILLER_19_400 VPWR VGND sg13cmos5l_decap_8
XFILLER_47_742 VPWR VGND sg13cmos5l_decap_8
X_4155__486 _4155_/RESET_B VPWR VGND sg13cmos5l_tiehi
X_2980_ _2980_/Y _4109_/Q _4090_/Q VPWR VGND sg13cmos5l_nand2b_1
X_4231__396 _4231_/RESET_B VPWR VGND sg13cmos5l_tiehi
XFILLER_22_609 VPWR VGND sg13cmos5l_fill_2
XFILLER_42_491 VPWR VGND sg13cmos5l_decap_4
XFILLER_14_171 VPWR VGND sg13cmos5l_fill_1
XFILLER_14_182 VPWR VGND sg13cmos5l_decap_4
Xinput10 input10/X uio_in[4] VPWR VGND sg13cmos5l_buf_1
X_3601_ _3602_/B _3601_/A _3601_/B VPWR VGND sg13cmos5l_xnor2_1
Xhold805 hold805/X _3965_/Q VPWR VGND sg13cmos5l_dlygate4sd3_1
Xhold816 _3678_/C _4260_/Q VPWR VGND sg13cmos5l_dlygate4sd3_1
Xhold827 _4035_/D _2486_/Y VPWR VGND sg13cmos5l_dlygate4sd3_1
X_3532_ _3532_/Y _3520_/Y _3530_/Y _3531_/Y _3528_/S VPWR VGND sg13cmos5l_a22oi_1
X_3463_ _3463_/Y _3775_/B VPWR VGND sg13cmos5l_inv_1
X_4203__432 _4203_/RESET_B VPWR VGND sg13cmos5l_tiehi
Xhold849 hold849/X _4254_/Q VPWR VGND sg13cmos5l_dlygate4sd3_1
Xhold838 _3842_/B _3841_/Y VPWR VGND sg13cmos5l_dlygate4sd3_1
X_2414_ _4005_/D _2414_/A0 hold769/X _2421_/S VPWR VGND sg13cmos5l_mux2_1
X_3394_ _4201_/D _3394_/A _3394_/B VPWR VGND sg13cmos5l_nor2_1
XFILLER_35_0 VPWR VGND sg13cmos5l_fill_1
X_2345_ _3946_/D hold765/X _2414_/A0 _2351_/S VPWR VGND sg13cmos5l_mux2_1
X_2276_ _4274_/D _2277_/B VPWR VGND sg13cmos5l_inv_1
X_4015_ _4015_/Q _4027_/CLK _4015_/D _4015_/RESET_B VPWR VGND sg13cmos5l_dfrbpq_1
XFILLER_38_797 VPWR VGND sg13cmos5l_decap_8
XFILLER_25_425 VPWR VGND sg13cmos5l_decap_8
XFILLER_26_937 VPWR VGND sg13cmos5l_decap_8
XFILLER_41_929 VPWR VGND sg13cmos5l_decap_8
X_4210__425 _4210_/RESET_B VPWR VGND sg13cmos5l_tiehi
XFILLER_20_130 VPWR VGND sg13cmos5l_decap_8
XFILLER_0_502 VPWR VGND sg13cmos5l_fill_2
XFILLER_0_579 VPWR VGND sg13cmos5l_decap_8
XFILLER_16_414 VPWR VGND sg13cmos5l_decap_4
XFILLER_44_767 VPWR VGND sg13cmos5l_decap_8
XFILLER_11_130 VPWR VGND sg13cmos5l_decap_8
XFILLER_8_624 VPWR VGND sg13cmos5l_fill_1
XFILLER_7_101 VPWR VGND sg13cmos5l_decap_8
XFILLER_4_830 VPWR VGND sg13cmos5l_decap_8
XFILLER_3_373 VPWR VGND sg13cmos5l_decap_4
X_3979__312 _3979_/RESET_B VPWR VGND sg13cmos5l_tiehi
XFILLER_19_252 VPWR VGND sg13cmos5l_fill_1
XFILLER_34_200 VPWR VGND sg13cmos5l_decap_8
XFILLER_35_734 VPWR VGND sg13cmos5l_decap_8
XFILLER_23_918 VPWR VGND sg13cmos5l_decap_4
XFILLER_35_778 VPWR VGND sg13cmos5l_decap_4
X_2963_ _4113_/D _3047_/B _2963_/B VPWR VGND sg13cmos5l_nor2_1
XFILLER_16_992 VPWR VGND sg13cmos5l_decap_8
X_3986__305 _3986_/RESET_B VPWR VGND sg13cmos5l_tiehi
X_2894_ _2910_/A _2894_/A _2894_/B VPWR VGND sg13cmos5l_nand2_1
Xhold602 _2726_/A _4056_/Q VPWR VGND sg13cmos5l_dlygate4sd3_1
Xhold613 _2226_/A _3896_/Q VPWR VGND sg13cmos5l_dlygate4sd3_1
Xhold635 _2429_/A _4027_/Q VPWR VGND sg13cmos5l_dlygate4sd3_1
X_3515_ _3515_/Y _4235_/Q _3526_/B _3530_/B _4234_/Q VPWR VGND sg13cmos5l_a22oi_1
Xhold624 _2247_/A _4271_/Q VPWR VGND sg13cmos5l_dlygate4sd3_1
Xhold657 hold657/X _3902_/Q VPWR VGND sg13cmos5l_dlygate4sd3_1
Xhold679 hold679/X _4004_/Q VPWR VGND sg13cmos5l_dlygate4sd3_1
Xhold668 _3924_/D _2318_/X VPWR VGND sg13cmos5l_dlygate4sd3_1
Xhold646 _2775_/A _4057_/Q VPWR VGND sg13cmos5l_dlygate4sd3_1
X_3446_ _3446_/Y _3427_/Y _3440_/Y _3390_/B VPWR VGND sg13cmos5l_o21ai_1
X_3377_ _3377_/Y _3357_/Y _3372_/S _3376_/Y VPWR VGND sg13cmos5l_a21oi_1
X_2328_ _3932_/D _3871_/A0 hold772/X _2331_/S VPWR VGND sg13cmos5l_mux2_1
X_2259_ _2260_/B _2644_/A _2259_/B VPWR VGND sg13cmos5l_nor2_1
XFILLER_25_200 VPWR VGND sg13cmos5l_fill_2
XFILLER_26_756 VPWR VGND sg13cmos5l_fill_1
XFILLER_41_726 VPWR VGND sg13cmos5l_decap_4
XFILLER_13_428 VPWR VGND sg13cmos5l_decap_8
XFILLER_25_277 VPWR VGND sg13cmos5l_fill_2
XFILLER_25_288 VPWR VGND sg13cmos5l_fill_2
XFILLER_40_247 VPWR VGND sg13cmos5l_decap_4
XFILLER_22_940 VPWR VGND sg13cmos5l_decap_4
X_3887__258 _3887_/RESET_B VPWR VGND sg13cmos5l_tiehi
XFILLER_49_1024 VPWR VGND sg13cmos5l_decap_4
X_4145__496 _4145_/RESET_B VPWR VGND sg13cmos5l_tiehi
X_4063__196 _4063_/RESET_B VPWR VGND sg13cmos5l_tiehi
XFILLER_0_321 VPWR VGND sg13cmos5l_decap_8
XFILLER_1_855 VPWR VGND sg13cmos5l_decap_8
XFILLER_0_387 VPWR VGND sg13cmos5l_fill_2
XFILLER_29_550 VPWR VGND sg13cmos5l_decap_8
XFILLER_29_561 VPWR VGND sg13cmos5l_fill_2
XFILLER_44_542 VPWR VGND sg13cmos5l_decap_8
XFILLER_44_564 VPWR VGND sg13cmos5l_fill_2
XFILLER_44_553 VPWR VGND sg13cmos5l_fill_2
X_4152__489 _4152_/RESET_B VPWR VGND sg13cmos5l_tiehi
XFILLER_16_255 VPWR VGND sg13cmos5l_fill_1
XFILLER_32_715 VPWR VGND sg13cmos5l_decap_4
X_4070__189 _4070_/RESET_B VPWR VGND sg13cmos5l_tiehi
XFILLER_12_472 VPWR VGND sg13cmos5l_decap_8
XFILLER_13_984 VPWR VGND sg13cmos5l_decap_8
XFILLER_9_955 VPWR VGND sg13cmos5l_decap_8
XFILLER_8_487 VPWR VGND sg13cmos5l_fill_1
X_4261__186 _4261_/RESET_B VPWR VGND sg13cmos5l_tiehi
X_3300_ _3397_/A _3298_/A _3312_/B _3299_/X VPWR VGND sg13cmos5l_o21ai_1
X_4280_ _4280_/Q _4280_/CLK _4280_/D _4280_/RESET_B VPWR VGND sg13cmos5l_dfrbpq_1
X_4200__435 _4200_/RESET_B VPWR VGND sg13cmos5l_tiehi
X_3231_ _3240_/A _4169_/Q _3246_/B VPWR VGND sg13cmos5l_nor2_1
X_3162_ _3163_/B _3218_/B _3218_/C VPWR VGND sg13cmos5l_nand2_1
XFILLER_48_881 VPWR VGND sg13cmos5l_decap_8
X_3093_ _4141_/D _3000_/A _3064_/B _4115_/D VPWR VGND sg13cmos5l_a21o_1
Xfanout29 _2421_/S _2418_/S VPWR VGND sg13cmos5l_buf_1
X_3995_ _3995_/Q _4027_/CLK _3995_/D _3995_/RESET_B VPWR VGND sg13cmos5l_dfrbpq_1
X_2946_ _2946_/Y _4138_/Q _4112_/Q VPWR VGND sg13cmos5l_nand2_1
XFILLER_10_409 VPWR VGND sg13cmos5l_fill_1
XFILLER_31_770 VPWR VGND sg13cmos5l_fill_1
X_2877_ _2877_/Y _2896_/A _3040_/A2 _3041_/A VPWR VGND sg13cmos5l_o21ai_1
X_3429_ _3429_/Y _3311_/B _3428_/B _3428_/Y VPWR VGND sg13cmos5l_a21oi_1
XFILLER_46_807 VPWR VGND sg13cmos5l_decap_8
XFILLER_39_870 VPWR VGND sg13cmos5l_decap_8
XFILLER_41_501 VPWR VGND sg13cmos5l_decap_8
XFILLER_14_748 VPWR VGND sg13cmos5l_decap_8
XFILLER_13_236 VPWR VGND sg13cmos5l_fill_2
X_3969__322 _3969_/RESET_B VPWR VGND sg13cmos5l_tiehi
XFILLER_41_578 VPWR VGND sg13cmos5l_fill_2
XFILLER_21_291 VPWR VGND sg13cmos5l_decap_8
XFILLER_5_402 VPWR VGND sg13cmos5l_fill_2
XFILLER_10_987 VPWR VGND sg13cmos5l_decap_8
XFILLER_6_947 VPWR VGND sg13cmos5l_decap_8
XFILLER_1_630 VPWR VGND sg13cmos5l_decap_8
XFILLER_1_641 VPWR VGND sg13cmos5l_fill_2
XFILLER_49_601 VPWR VGND sg13cmos5l_decap_8
XFILLER_0_162 VPWR VGND sg13cmos5l_decap_8
X_3976__315 _3976_/RESET_B VPWR VGND sg13cmos5l_tiehi
XFILLER_23_1027 VPWR VGND sg13cmos5l_fill_2
XFILLER_29_391 VPWR VGND sg13cmos5l_fill_1
XFILLER_45_873 VPWR VGND sg13cmos5l_decap_8
XFILLER_20_707 VPWR VGND sg13cmos5l_fill_2
X_2800_ _2800_/Y _3044_/A _2976_/A VPWR VGND sg13cmos5l_nor2_1
X_3780_ _3780_/Y _3773_/Y _3780_/B _3780_/C VPWR VGND sg13cmos5l_nand3b_1
X_2731_ _2731_/Y _4048_/Q _4083_/Q VPWR VGND sg13cmos5l_nand2_1
XFILLER_13_781 VPWR VGND sg13cmos5l_decap_8
X_3983__308 _3983_/RESET_B VPWR VGND sg13cmos5l_tiehi
XFILLER_12_291 VPWR VGND sg13cmos5l_decap_8
X_2662_ _2662_/Y _2662_/A _2662_/B VPWR VGND sg13cmos5l_nand2_1
X_2593_ _2593_/Y _2589_/Y _2590_/Y _2592_/Y VPWR VGND sg13cmos5l_o21ai_1
X_4263_ _4263_/Q clkload3/A _4263_/D _4263_/RESET_B VPWR VGND sg13cmos5l_dfrbpq_1
X_3214_ _4166_/D _3214_/A _3215_/B VPWR VGND sg13cmos5l_nor2_1
X_4194_ _4194_/Q _4227_/CLK _4194_/D _4194_/RESET_B VPWR VGND sg13cmos5l_dfrbpq_1
X_3145_ _3167_/B _4121_/Q _3145_/B VPWR VGND sg13cmos5l_xor2_1
X_3076_ _3080_/A _3064_/A _2999_/Y _2966_/Y VPWR VGND sg13cmos5l_a21oi_1
XFILLER_27_339 VPWR VGND sg13cmos5l_fill_1
X_4018__271 _4018_/RESET_B VPWR VGND sg13cmos5l_tiehi
XFILLER_36_862 VPWR VGND sg13cmos5l_decap_8
XFILLER_24_49 VPWR VGND sg13cmos5l_fill_1
XFILLER_11_729 VPWR VGND sg13cmos5l_decap_8
X_3978_ _3978_/Q _4011_/CLK _3978_/D _3978_/RESET_B VPWR VGND sg13cmos5l_dfrbpq_1
X_2929_ _2929_/Y _3203_/B _3555_/A VPWR VGND sg13cmos5l_nand2b_1
XFILLER_2_427 VPWR VGND sg13cmos5l_decap_8
XFILLER_49_46 VPWR VGND sg13cmos5l_decap_8
X_4142__499 _4142_/RESET_B VPWR VGND sg13cmos5l_tiehi
X_4060__199 _4060_/RESET_B VPWR VGND sg13cmos5l_tiehi
XFILLER_46_659 VPWR VGND sg13cmos5l_fill_2
XFILLER_27_895 VPWR VGND sg13cmos5l_decap_8
XFILLER_14_589 VPWR VGND sg13cmos5l_decap_4
XFILLER_6_700 VPWR VGND sg13cmos5l_decap_8
XFILLER_10_740 VPWR VGND sg13cmos5l_decap_4
XFILLER_6_755 VPWR VGND sg13cmos5l_decap_8
XFILLER_30_81 VPWR VGND sg13cmos5l_decap_4
XFILLER_2_961 VPWR VGND sg13cmos5l_decap_8
XFILLER_7_1021 VPWR VGND sg13cmos5l_decap_8
XFILLER_49_464 VPWR VGND sg13cmos5l_decap_8
Xinput8 input8/X uio_in[2] VPWR VGND sg13cmos5l_buf_1
XFILLER_49_497 VPWR VGND sg13cmos5l_decap_8
XFILLER_37_648 VPWR VGND sg13cmos5l_fill_2
XFILLER_17_350 VPWR VGND sg13cmos5l_decap_8
XFILLER_18_884 VPWR VGND sg13cmos5l_decap_8
X_3901_ _3901_/Q clkload7/A _3901_/D _3901_/RESET_B VPWR VGND sg13cmos5l_dfrbpq_1
XFILLER_44_191 VPWR VGND sg13cmos5l_fill_1
X_3832_ _3832_/Y _4277_/Q _4272_/Q VPWR VGND sg13cmos5l_nor2_1
X_3763_ _3776_/S _3757_/Y _3760_/Y _3758_/X VPWR VGND sg13cmos5l_o21ai_1
XFILLER_9_571 VPWR VGND sg13cmos5l_decap_4
X_2714_ _2837_/A _4084_/Q _2714_/B VPWR VGND sg13cmos5l_xnor2_1
X_3694_ _3694_/Y hold817/X _3698_/S _3711_/B VPWR VGND sg13cmos5l_o21ai_1
X_2645_ _2646_/B _4011_/Q _3994_/Q _3977_/Q _3960_/Q _2563_/A _2645_/S1 VPWR VGND
+ sg13cmos5l_mux4_1
X_2576_ _2577_/C _2646_/A _2576_/B VPWR VGND sg13cmos5l_nand2_1
X_4246_ _4246_/Q _4265_/CLK _4246_/D _4246_/RESET_B VPWR VGND sg13cmos5l_dfrbpq_1
X_4239__272 _4239_/RESET_B VPWR VGND sg13cmos5l_tiehi
X_4177_ _4177_/Q _4231_/CLK _4177_/D _4177_/RESET_B VPWR VGND sg13cmos5l_dfrbpq_1
X_3959__332 _3959_/RESET_B VPWR VGND sg13cmos5l_tiehi
X_3128_ _4145_/D _3215_/B _3128_/B VPWR VGND sg13cmos5l_nor2_1
XFILLER_27_158 VPWR VGND sg13cmos5l_fill_1
XFILLER_42_117 VPWR VGND sg13cmos5l_decap_4
XFILLER_24_821 VPWR VGND sg13cmos5l_decap_8
XFILLER_35_48 VPWR VGND sg13cmos5l_decap_4
X_3059_ _3077_/B _4134_/Q _3073_/B VPWR VGND sg13cmos5l_nand2_1
XFILLER_23_331 VPWR VGND sg13cmos5l_decap_4
XFILLER_11_515 VPWR VGND sg13cmos5l_decap_8
XFILLER_23_353 VPWR VGND sg13cmos5l_fill_1
X_3966__325 _3966_/RESET_B VPWR VGND sg13cmos5l_tiehi
XFILLER_13_1026 VPWR VGND sg13cmos5l_fill_2
XFILLER_3_769 VPWR VGND sg13cmos5l_decap_8
XFILLER_2_246 VPWR VGND sg13cmos5l_fill_1
XFILLER_47_924 VPWR VGND sg13cmos5l_decap_8
XFILLER_19_626 VPWR VGND sg13cmos5l_decap_8
X_3973__318 _3973_/RESET_B VPWR VGND sg13cmos5l_tiehi
XFILLER_14_320 VPWR VGND sg13cmos5l_decap_8
XFILLER_15_854 VPWR VGND sg13cmos5l_decap_8
XFILLER_27_692 VPWR VGND sg13cmos5l_fill_1
XFILLER_42_662 VPWR VGND sg13cmos5l_decap_8
XFILLER_14_353 VPWR VGND sg13cmos5l_decap_4
XFILLER_30_868 VPWR VGND sg13cmos5l_decap_4
X_4260__207 _4260_/RESET_B VPWR VGND sg13cmos5l_tiehi
X_2430_ _3875_/B _2466_/A _2430_/B VPWR VGND sg13cmos5l_nand2_1
XFILLER_6_585 VPWR VGND sg13cmos5l_fill_1
XFILLER_6_574 VPWR VGND sg13cmos5l_decap_8
XFILLER_29_1000 VPWR VGND sg13cmos5l_decap_8
XFILLER_37_4 VPWR VGND sg13cmos5l_fill_2
X_2361_ _3961_/D input5/X hold780/X _2361_/S VPWR VGND sg13cmos5l_mux2_1
X_2292_ _2299_/S _2292_/A _3855_/D VPWR VGND sg13cmos5l_nand2_1
X_4100_ _4100_/Q _4129_/CLK _4100_/D _4100_/RESET_B VPWR VGND sg13cmos5l_dfrbpq_1
X_4031_ _4031_/Q _4031_/CLK _4031_/D _4031_/RESET_B VPWR VGND sg13cmos5l_dfrbpq_1
XFILLER_49_283 VPWR VGND sg13cmos5l_decap_4
XFILLER_38_935 VPWR VGND sg13cmos5l_decap_8
XFILLER_2_85 VPWR VGND sg13cmos5l_decap_8
XFILLER_24_106 VPWR VGND sg13cmos5l_decap_8
XFILLER_32_161 VPWR VGND sg13cmos5l_decap_8
X_3815_ _4263_/D _3815_/A _3815_/B VPWR VGND sg13cmos5l_nor2_1
XFILLER_20_345 VPWR VGND sg13cmos5l_decap_8
XFILLER_20_356 VPWR VGND sg13cmos5l_fill_1
X_3746_ _3781_/C _4214_/Q _4212_/Q _4213_/Q VPWR VGND sg13cmos5l_nor3_1
X_3677_ _3677_/Y _4221_/Q _3677_/B _3686_/B VPWR VGND sg13cmos5l_nor3_1
X_2628_ _2628_/X _4007_/Q _3990_/Q _3973_/Q _3956_/Q _2563_/A _2645_/S1 VPWR VGND
+ sg13cmos5l_mux4_1
X_2559_ _2559_/Y _2422_/B _2558_/X _4040_/Q VPWR VGND sg13cmos5l_a21oi_1
XFILLER_0_739 VPWR VGND sg13cmos5l_decap_8
X_4229_ _4229_/Q _4259_/CLK _4229_/D _4229_/RESET_B VPWR VGND sg13cmos5l_dfrbpq_1
XFILLER_16_618 VPWR VGND sg13cmos5l_decap_8
XFILLER_12_879 VPWR VGND sg13cmos5l_decap_8
XFILLER_3_555 VPWR VGND sg13cmos5l_decap_8
XFILLER_19_423 VPWR VGND sg13cmos5l_fill_1
XFILLER_46_220 VPWR VGND sg13cmos5l_decap_4
XFILLER_19_445 VPWR VGND sg13cmos5l_decap_4
XFILLER_35_905 VPWR VGND sg13cmos5l_decap_4
XFILLER_47_798 VPWR VGND sg13cmos5l_decap_8
XFILLER_19_467 VPWR VGND sg13cmos5l_decap_8
XFILLER_19_478 VPWR VGND sg13cmos5l_decap_8
XFILLER_35_949 VPWR VGND sg13cmos5l_decap_8
XFILLER_28_990 VPWR VGND sg13cmos5l_decap_8
XFILLER_43_982 VPWR VGND sg13cmos5l_decap_8
XFILLER_42_470 VPWR VGND sg13cmos5l_decap_8
XFILLER_30_610 VPWR VGND sg13cmos5l_decap_8
Xinput11 input11/X uio_in[5] VPWR VGND sg13cmos5l_buf_1
X_3600_ _3600_/Y _3600_/A _3600_/B VPWR VGND sg13cmos5l_nand2_1
X_3949__342 _3949_/RESET_B VPWR VGND sg13cmos5l_tiehi
X_3531_ _3531_/Y _3531_/A _3769_/A VPWR VGND sg13cmos5l_nor2b_1
Xhold806 hold806/X _3934_/Q VPWR VGND sg13cmos5l_dlygate4sd3_1
Xhold817 hold817/X _3680_/C VPWR VGND sg13cmos5l_dlygate4sd3_1
Xhold828 _2882_/A _4081_/Q VPWR VGND sg13cmos5l_dlygate4sd3_1
Xhold839 _2232_/A _4067_/Q VPWR VGND sg13cmos5l_dlygate4sd3_1
X_3462_ _3775_/B _4235_/Q _4236_/Q VPWR VGND sg13cmos5l_xnor2_1
X_2413_ _4004_/D _2413_/A0 hold679/X _2421_/S VPWR VGND sg13cmos5l_mux2_1
X_3393_ _4200_/D _3393_/A _3394_/B VPWR VGND sg13cmos5l_nor2_1
X_2344_ _3945_/D hold704/X _2413_/A0 _2351_/S VPWR VGND sg13cmos5l_mux2_1
X_2275_ _2277_/B _2497_/C _3819_/A _3827_/B1 VPWR VGND sg13cmos5l_o21ai_1
XFILLER_37_231 VPWR VGND sg13cmos5l_decap_4
X_4014_ _4014_/Q _4027_/CLK _4014_/D _4014_/RESET_B VPWR VGND sg13cmos5l_dfrbpq_1
X_3956__335 _3956_/RESET_B VPWR VGND sg13cmos5l_tiehi
XFILLER_38_776 VPWR VGND sg13cmos5l_decap_8
XFILLER_16_39 VPWR VGND sg13cmos5l_fill_1
XFILLER_33_481 VPWR VGND sg13cmos5l_decap_4
XFILLER_21_676 VPWR VGND sg13cmos5l_decap_8
X_3963__328 _3963_/RESET_B VPWR VGND sg13cmos5l_tiehi
XFILLER_4_308 VPWR VGND sg13cmos5l_decap_4
X_3729_ _3800_/B _4258_/Q _3733_/B VPWR VGND sg13cmos5l_nand2_1
XFILLER_0_558 VPWR VGND sg13cmos5l_decap_8
XFILLER_28_220 VPWR VGND sg13cmos5l_decap_8
XFILLER_28_231 VPWR VGND sg13cmos5l_fill_2
XFILLER_17_927 VPWR VGND sg13cmos5l_decap_4
XFILLER_44_746 VPWR VGND sg13cmos5l_decap_8
XFILLER_43_223 VPWR VGND sg13cmos5l_fill_1
XFILLER_16_426 VPWR VGND sg13cmos5l_fill_1
XFILLER_16_437 VPWR VGND sg13cmos5l_fill_1
XFILLER_28_297 VPWR VGND sg13cmos5l_fill_2
XFILLER_43_256 VPWR VGND sg13cmos5l_fill_2
XFILLER_12_610 VPWR VGND sg13cmos5l_fill_1
XFILLER_40_996 VPWR VGND sg13cmos5l_decap_8
XFILLER_8_647 VPWR VGND sg13cmos5l_decap_8
XFILLER_8_658 VPWR VGND sg13cmos5l_fill_1
XFILLER_7_179 VPWR VGND sg13cmos5l_fill_2
XFILLER_22_82 VPWR VGND sg13cmos5l_decap_8
XFILLER_4_875 VPWR VGND sg13cmos5l_fill_1
XFILLER_39_529 VPWR VGND sg13cmos5l_fill_2
XFILLER_47_584 VPWR VGND sg13cmos5l_decap_8
X_2962_ _2963_/B _3048_/A _3048_/B VPWR VGND sg13cmos5l_nand2_1
X_2893_ _2893_/Y _2887_/A _2914_/B _2892_/Y VPWR VGND sg13cmos5l_o21ai_1
XFILLER_31_985 VPWR VGND sg13cmos5l_decap_8
XFILLER_33_1018 VPWR VGND sg13cmos5l_decap_8
Xhold603 _4078_/D _2726_/X VPWR VGND sg13cmos5l_dlygate4sd3_1
X_3514_ _4215_/D _3561_/B _3600_/B VPWR VGND sg13cmos5l_nor2_1
Xhold636 _3875_/A _2428_/Y VPWR VGND sg13cmos5l_dlygate4sd3_1
Xhold625 _3845_/B _3844_/Y VPWR VGND sg13cmos5l_dlygate4sd3_1
Xhold614 _2177_/A _4160_/Q VPWR VGND sg13cmos5l_dlygate4sd3_1
Xhold647 _2491_/B _4038_/Q VPWR VGND sg13cmos5l_dlygate4sd3_1
X_3445_ _4203_/D _3422_/Y _3440_/Y _3444_/Y VPWR VGND sg13cmos5l_a21oi_1
Xhold669 _3556_/B _4196_/Q VPWR VGND sg13cmos5l_dlygate4sd3_1
Xhold658 hold658/X _3903_/Q VPWR VGND sg13cmos5l_dlygate4sd3_1
X_3376_ _3376_/Y hold874/X _3372_/S _3390_/B VPWR VGND sg13cmos5l_o21ai_1
X_2327_ _3931_/D _3859_/A0 hold703/X _2331_/S VPWR VGND sg13cmos5l_mux2_1
X_2258_ _2259_/B _4012_/Q _3995_/Q _3978_/Q _3961_/Q _2563_/A _2645_/S1 VPWR VGND
+ sg13cmos5l_mux4_1
XFILLER_27_16 VPWR VGND sg13cmos5l_decap_8
XFILLER_27_27 VPWR VGND sg13cmos5l_fill_2
XFILLER_26_746 VPWR VGND sg13cmos5l_fill_2
X_2189_ _3016_/B _2860_/A VPWR VGND sg13cmos5l_inv_1
XFILLER_41_705 VPWR VGND sg13cmos5l_decap_8
XFILLER_26_768 VPWR VGND sg13cmos5l_decap_8
XFILLER_41_749 VPWR VGND sg13cmos5l_fill_1
XFILLER_49_1003 VPWR VGND sg13cmos5l_decap_8
X_4028__251 _4028_/RESET_B VPWR VGND sg13cmos5l_tiehi
XFILLER_1_834 VPWR VGND sg13cmos5l_decap_8
XFILLER_49_849 VPWR VGND sg13cmos5l_decap_8
XFILLER_0_366 VPWR VGND sg13cmos5l_decap_8
XFILLER_1_1016 VPWR VGND sg13cmos5l_decap_8
XFILLER_17_702 VPWR VGND sg13cmos5l_fill_2
X_3939__352 _3939_/RESET_B VPWR VGND sg13cmos5l_tiehi
XFILLER_1_1027 VPWR VGND sg13cmos5l_fill_2
XFILLER_16_212 VPWR VGND sg13cmos5l_decap_8
XFILLER_16_234 VPWR VGND sg13cmos5l_fill_1
XFILLER_16_267 VPWR VGND sg13cmos5l_decap_8
XFILLER_13_963 VPWR VGND sg13cmos5l_decap_8
XFILLER_9_923 VPWR VGND sg13cmos5l_decap_8
X_3946__345 _3946_/RESET_B VPWR VGND sg13cmos5l_tiehi
XFILLER_4_661 VPWR VGND sg13cmos5l_decap_8
X_3230_ _3260_/B _3228_/Y _3229_/Y _3227_/Y VPWR VGND sg13cmos5l_a21oi_1
X_4274__559 _4274_/RESET_B VPWR VGND sg13cmos5l_tiehi
X_3161_ _3218_/C _3154_/B _3151_/Y _3159_/Y VPWR VGND sg13cmos5l_o21ai_1
XFILLER_39_337 VPWR VGND sg13cmos5l_decap_4
XFILLER_48_860 VPWR VGND sg13cmos5l_decap_8
X_3092_ _4140_/D _3080_/A _3088_/A _3091_/Y VPWR VGND sg13cmos5l_a21oi_1
XFILLER_35_510 VPWR VGND sg13cmos5l_fill_2
X_3953__338 _3953_/RESET_B VPWR VGND sg13cmos5l_tiehi
XFILLER_23_749 VPWR VGND sg13cmos5l_fill_2
X_3994_ _3994_/Q clkload5/A _3994_/D _3994_/RESET_B VPWR VGND sg13cmos5l_dfrbpq_1
XFILLER_13_18 VPWR VGND sg13cmos5l_decap_8
X_2945_ _2945_/X _2945_/A _3137_/A _2945_/C VPWR VGND sg13cmos5l_and3_1
X_2876_ _4099_/D _2186_/Y _3035_/A2 _2875_/Y VPWR VGND sg13cmos5l_a21oi_1
XFILLER_30_292 VPWR VGND sg13cmos5l_fill_1
X_4099__547 _4099_/RESET_B VPWR VGND sg13cmos5l_tiehi
X_3428_ _3428_/Y _3428_/A _3428_/B VPWR VGND sg13cmos5l_nor2_1
XFILLER_38_15 VPWR VGND sg13cmos5l_decap_8
X_3359_ _3359_/Y _4157_/Q _3359_/B VPWR VGND sg13cmos5l_nor2_1
XFILLER_38_59 VPWR VGND sg13cmos5l_fill_2
XFILLER_39_893 VPWR VGND sg13cmos5l_fill_1
XFILLER_38_370 VPWR VGND sg13cmos5l_fill_1
XFILLER_14_705 VPWR VGND sg13cmos5l_fill_2
XFILLER_26_543 VPWR VGND sg13cmos5l_decap_8
XFILLER_26_554 VPWR VGND sg13cmos5l_fill_2
XFILLER_13_226 VPWR VGND sg13cmos5l_fill_1
X_4151__490 _4151_/RESET_B VPWR VGND sg13cmos5l_tiehi
XFILLER_41_568 VPWR VGND sg13cmos5l_fill_2
XFILLER_16_1013 VPWR VGND sg13cmos5l_decap_8
XFILLER_22_760 VPWR VGND sg13cmos5l_decap_8
XFILLER_6_926 VPWR VGND sg13cmos5l_decap_8
XFILLER_10_966 VPWR VGND sg13cmos5l_decap_8
XFILLER_49_613 VPWR VGND sg13cmos5l_decap_8
XFILLER_23_1006 VPWR VGND sg13cmos5l_decap_8
XFILLER_36_307 VPWR VGND sg13cmos5l_fill_1
XFILLER_28_70 VPWR VGND sg13cmos5l_fill_2
XFILLER_29_370 VPWR VGND sg13cmos5l_decap_8
XFILLER_36_329 VPWR VGND sg13cmos5l_decap_8
XFILLER_45_852 VPWR VGND sg13cmos5l_decap_8
XFILLER_44_80 VPWR VGND sg13cmos5l_fill_2
XFILLER_32_579 VPWR VGND sg13cmos5l_decap_8
XFILLER_40_590 VPWR VGND sg13cmos5l_fill_2
X_2730_ _2730_/Y _4048_/Q _2885_/A _2883_/A _2193_/Y _2729_/Y VPWR VGND sg13cmos5l_a221oi_1
X_2661_ _2662_/B _3999_/Q _3982_/Q _3965_/Q _3948_/Q _2667_/A1 _2670_/B2 VPWR VGND
+ sg13cmos5l_mux4_1
X_2592_ _2592_/Y _2662_/A _2592_/B VPWR VGND sg13cmos5l_nand2_1
XFILLER_5_981 VPWR VGND sg13cmos5l_decap_8
X_4262_ _4262_/Q _4265_/CLK _4262_/D _4262_/RESET_B VPWR VGND sg13cmos5l_dfrbpq_1
XFILLER_39_101 VPWR VGND sg13cmos5l_fill_1
X_3213_ _4165_/D _3213_/A _3217_/B VPWR VGND sg13cmos5l_and2_1
XFILLER_39_112 VPWR VGND sg13cmos5l_decap_4
X_4193_ _4193_/Q _4193_/CLK _4193_/D _4193_/RESET_B VPWR VGND sg13cmos5l_dfrbpq_1
X_3144_ _3144_/X _3138_/X _3142_/Y _3137_/X VPWR VGND sg13cmos5l_a21o_1
XFILLER_27_307 VPWR VGND sg13cmos5l_fill_1
XFILLER_28_819 VPWR VGND sg13cmos5l_decap_4
X_3075_ _3082_/A _3070_/Y _3089_/A _3074_/Y VPWR VGND sg13cmos5l_o21ai_1
XFILLER_35_362 VPWR VGND sg13cmos5l_decap_8
XFILLER_23_568 VPWR VGND sg13cmos5l_decap_4
X_3977_ _3977_/Q clkload5/A _3977_/D _3977_/RESET_B VPWR VGND sg13cmos5l_dfrbpq_1
X_2928_ _3000_/A _3272_/A _3203_/B VPWR VGND sg13cmos5l_nor2_1
X_2859_ _2859_/Y _4094_/Q _2859_/B VPWR VGND sg13cmos5l_nor2_1
X_3929__362 _3929_/RESET_B VPWR VGND sg13cmos5l_tiehi
XFILLER_2_439 VPWR VGND sg13cmos5l_fill_2
XFILLER_49_25 VPWR VGND sg13cmos5l_decap_8
XFILLER_46_1028 VPWR VGND sg13cmos5l_fill_1
XFILLER_46_1017 VPWR VGND sg13cmos5l_decap_8
XFILLER_18_329 VPWR VGND sg13cmos5l_decap_8
XFILLER_14_513 VPWR VGND sg13cmos5l_decap_4
X_3936__355 _3936_/RESET_B VPWR VGND sg13cmos5l_tiehi
XFILLER_41_332 VPWR VGND sg13cmos5l_decap_4
XFILLER_41_376 VPWR VGND sg13cmos5l_decap_8
XFILLER_41_354 VPWR VGND sg13cmos5l_fill_2
XFILLER_41_343 VPWR VGND sg13cmos5l_decap_8
XFILLER_41_398 VPWR VGND sg13cmos5l_decap_4
XFILLER_6_723 VPWR VGND sg13cmos5l_decap_8
XFILLER_10_796 VPWR VGND sg13cmos5l_decap_8
XFILLER_2_940 VPWR VGND sg13cmos5l_decap_8
X_3943__348 _3943_/RESET_B VPWR VGND sg13cmos5l_tiehi
XFILLER_7_1000 VPWR VGND sg13cmos5l_decap_8
XFILLER_49_454 VPWR VGND sg13cmos5l_fill_2
Xinput9 input9/X uio_in[3] VPWR VGND sg13cmos5l_buf_1
XFILLER_18_841 VPWR VGND sg13cmos5l_fill_2
XFILLER_18_852 VPWR VGND sg13cmos5l_fill_2
XFILLER_45_682 VPWR VGND sg13cmos5l_decap_4
X_3900_ _3900_/Q clkload8/A _3900_/D _3900_/RESET_B VPWR VGND sg13cmos5l_dfrbpq_1
XFILLER_32_321 VPWR VGND sg13cmos5l_fill_2
X_3831_ _4268_/D _4272_/D _3831_/B VPWR VGND sg13cmos5l_nor2_1
XFILLER_33_899 VPWR VGND sg13cmos5l_decap_8
X_3762_ _3762_/Y _3766_/A VPWR VGND sg13cmos5l_inv_1
X_2713_ _2713_/Y _2885_/A _2884_/A VPWR VGND sg13cmos5l_nand2_1
X_3693_ _3698_/S _3693_/A _3693_/B VPWR VGND sg13cmos5l_nor2_1
X_2644_ _2647_/B _2644_/A _2644_/B VPWR VGND sg13cmos5l_nand2_1
X_2575_ _2576_/B _4010_/Q _3993_/Q _3976_/Q _3959_/Q _2563_/A _2645_/S1 VPWR VGND
+ sg13cmos5l_mux4_1
X_4245_ _4245_/Q _4265_/CLK _4245_/D _4245_/RESET_B VPWR VGND sg13cmos5l_dfrbpq_1
X_4176_ _4176_/Q _4231_/CLK _4176_/D _4176_/RESET_B VPWR VGND sg13cmos5l_dfrbpq_1
X_3127_ _3128_/B _3222_/A VPWR VGND sg13cmos5l_inv_1
XFILLER_24_800 VPWR VGND sg13cmos5l_decap_8
XFILLER_36_671 VPWR VGND sg13cmos5l_decap_8
X_3058_ _3077_/A _4136_/Q _3073_/B VPWR VGND sg13cmos5l_xnor2_1
XFILLER_35_170 VPWR VGND sg13cmos5l_decap_8
XFILLER_13_1005 VPWR VGND sg13cmos5l_decap_8
XFILLER_3_748 VPWR VGND sg13cmos5l_decap_8
XFILLER_47_903 VPWR VGND sg13cmos5l_decap_8
XFILLER_19_605 VPWR VGND sg13cmos5l_decap_8
XFILLER_46_468 VPWR VGND sg13cmos5l_decap_8
XFILLER_18_148 VPWR VGND sg13cmos5l_fill_1
XFILLER_15_811 VPWR VGND sg13cmos5l_fill_2
XFILLER_27_660 VPWR VGND sg13cmos5l_decap_4
XFILLER_33_107 VPWR VGND sg13cmos5l_decap_8
XFILLER_26_181 VPWR VGND sg13cmos5l_decap_8
XFILLER_30_803 VPWR VGND sg13cmos5l_decap_8
XFILLER_30_825 VPWR VGND sg13cmos5l_decap_8
XFILLER_41_92 VPWR VGND sg13cmos5l_decap_8
XFILLER_44_6 VPWR VGND sg13cmos5l_fill_1
X_2360_ _3960_/D _3863_/A0 hold684/X _2361_/S VPWR VGND sg13cmos5l_mux2_1
X_2291_ _3855_/D _3617_/B _2452_/A VPWR VGND sg13cmos5l_nor2_1
XFILLER_49_251 VPWR VGND sg13cmos5l_decap_8
XFILLER_38_914 VPWR VGND sg13cmos5l_decap_8
XFILLER_2_42 VPWR VGND sg13cmos5l_decap_4
X_4030_ _4030_/Q clkload2/A _4030_/D _4030_/RESET_B VPWR VGND sg13cmos5l_dfrbpq_1
XFILLER_49_273 VPWR VGND sg13cmos5l_fill_1
XFILLER_2_75 VPWR VGND sg13cmos5l_fill_1
XFILLER_2_97 VPWR VGND sg13cmos5l_decap_8
XFILLER_25_619 VPWR VGND sg13cmos5l_decap_8
X_3919__372 _3919_/RESET_B VPWR VGND sg13cmos5l_tiehi
X_3814_ _3815_/B _3802_/Y _3799_/Y _3814_/S VPWR VGND sg13cmos5l_mux2_1
XFILLER_32_184 VPWR VGND sg13cmos5l_fill_1
X_3745_ _3745_/Y _3761_/A _3743_/X _3744_/X _3712_/A VPWR VGND sg13cmos5l_a22oi_1
XFILLER_9_391 VPWR VGND sg13cmos5l_fill_2
X_3676_ _3680_/B _4246_/Q _3676_/B VPWR VGND sg13cmos5l_nor2_1
X_2627_ _2627_/Y _2654_/A1 _2625_/Y _2626_/Y _2623_/Y _2662_/A VPWR VGND sg13cmos5l_a221oi_1
XFILLER_0_718 VPWR VGND sg13cmos5l_decap_8
X_2558_ _2558_/X _2646_/A _2557_/X _2556_/Y VPWR VGND sg13cmos5l_a21o_1
X_3926__365 _3926_/RESET_B VPWR VGND sg13cmos5l_tiehi
X_2489_ _2489_/Y _2194_/A hold663/X _2466_/A VPWR VGND sg13cmos5l_o21ai_1
X_4228_ _4228_/Q _4259_/CLK _4228_/D _4228_/RESET_B VPWR VGND sg13cmos5l_dfrbpq_1
XFILLER_29_914 VPWR VGND sg13cmos5l_decap_8
XFILLER_46_15 VPWR VGND sg13cmos5l_decap_8
XFILLER_29_947 VPWR VGND sg13cmos5l_fill_1
X_4159_ _4159_/Q _4193_/CLK _4159_/D _4159_/RESET_B VPWR VGND sg13cmos5l_dfrbpq_1
XFILLER_44_939 VPWR VGND sg13cmos5l_decap_8
XFILLER_37_980 VPWR VGND sg13cmos5l_decap_8
X_3933__358 _3933_/RESET_B VPWR VGND sg13cmos5l_tiehi
XFILLER_12_847 VPWR VGND sg13cmos5l_decap_8
XFILLER_11_335 VPWR VGND sg13cmos5l_decap_8
XFILLER_3_501 VPWR VGND sg13cmos5l_fill_1
XFILLER_3_523 VPWR VGND sg13cmos5l_fill_1
XFILLER_11_84 VPWR VGND sg13cmos5l_fill_1
X_4038__231 _4038_/RESET_B VPWR VGND sg13cmos5l_tiehi
XFILLER_47_777 VPWR VGND sg13cmos5l_decap_8
XFILLER_46_276 VPWR VGND sg13cmos5l_decap_8
XFILLER_46_254 VPWR VGND sg13cmos5l_decap_4
XFILLER_35_928 VPWR VGND sg13cmos5l_decap_8
XFILLER_46_298 VPWR VGND sg13cmos5l_decap_8
XFILLER_34_449 VPWR VGND sg13cmos5l_fill_2
XFILLER_43_961 VPWR VGND sg13cmos5l_decap_8
XFILLER_30_600 VPWR VGND sg13cmos5l_fill_1
XFILLER_30_655 VPWR VGND sg13cmos5l_fill_1
Xinput12 input12/X uio_in[6] VPWR VGND sg13cmos5l_buf_1
X_3530_ _3530_/Y _4189_/Q _3530_/B VPWR VGND sg13cmos5l_nor2_1
XFILLER_11_880 VPWR VGND sg13cmos5l_decap_8
Xhold807 hold807/X _3883_/Q VPWR VGND sg13cmos5l_dlygate4sd3_1
Xhold818 hold818/X _3694_/Y VPWR VGND sg13cmos5l_dlygate4sd3_1
X_3461_ _3480_/B _3531_/A _3764_/C VPWR VGND sg13cmos5l_xnor2_1
Xhold829 _3203_/B _4127_/Q VPWR VGND sg13cmos5l_dlygate4sd3_1
X_3392_ _4199_/D _3392_/A _3394_/B VPWR VGND sg13cmos5l_nor2_1
X_2412_ _2418_/S _3855_/D _2412_/B VPWR VGND sg13cmos5l_nand2_1
X_2343_ _2351_/S _2474_/B _3846_/D _2352_/C VPWR VGND sg13cmos5l_and3_1
X_4013_ _4013_/Q _4027_/CLK _4013_/D _4013_/RESET_B VPWR VGND sg13cmos5l_dfrbpq_1
X_2274_ _3819_/A _3833_/B _2511_/A VPWR VGND sg13cmos5l_nor2_1
XFILLER_19_991 VPWR VGND sg13cmos5l_decap_8
XFILLER_41_909 VPWR VGND sg13cmos5l_decap_8
Xclkbuf_leaf_17_clk _4227_/CLK clkbuf_leaf_3_clk/A VPWR VGND sg13cmos5l_buf_8
XFILLER_34_983 VPWR VGND sg13cmos5l_decap_8
X_3728_ _3728_/Y _3801_/A _3800_/A VPWR VGND sg13cmos5l_nand2_1
XFILLER_10_1008 VPWR VGND sg13cmos5l_decap_8
X_3659_ _3659_/Y _3659_/A _3659_/B VPWR VGND sg13cmos5l_nand2_1
XFILLER_0_515 VPWR VGND sg13cmos5l_decap_8
XFILLER_0_537 VPWR VGND sg13cmos5l_decap_8
X_3898__515 _3898_/RESET_B VPWR VGND sg13cmos5l_tiehi
XFILLER_29_722 VPWR VGND sg13cmos5l_decap_8
XFILLER_29_744 VPWR VGND sg13cmos5l_decap_8
XFILLER_29_755 VPWR VGND sg13cmos5l_decap_8
XFILLER_28_243 VPWR VGND sg13cmos5l_decap_4
XFILLER_29_766 VPWR VGND sg13cmos5l_fill_2
XFILLER_44_725 VPWR VGND sg13cmos5l_fill_2
XFILLER_16_449 VPWR VGND sg13cmos5l_fill_1
XFILLER_28_276 VPWR VGND sg13cmos5l_decap_4
XFILLER_25_994 VPWR VGND sg13cmos5l_decap_8
XFILLER_40_975 VPWR VGND sg13cmos5l_decap_8
XFILLER_11_165 VPWR VGND sg13cmos5l_decap_8
X_4226__401 _4226_/RESET_B VPWR VGND sg13cmos5l_tiehi
XFILLER_7_136 VPWR VGND sg13cmos5l_fill_2
XFILLER_12_699 VPWR VGND sg13cmos5l_decap_8
XFILLER_4_821 VPWR VGND sg13cmos5l_decap_4
XFILLER_4_854 VPWR VGND sg13cmos5l_decap_8
X_3909__382 _3909_/RESET_B VPWR VGND sg13cmos5l_tiehi
XFILLER_26_1015 VPWR VGND sg13cmos5l_decap_8
XFILLER_21_8 VPWR VGND sg13cmos5l_decap_8
XFILLER_47_80 VPWR VGND sg13cmos5l_decap_4
XFILLER_34_224 VPWR VGND sg13cmos5l_fill_2
XFILLER_34_257 VPWR VGND sg13cmos5l_decap_8
X_3916__375 _3916_/RESET_B VPWR VGND sg13cmos5l_tiehi
X_2961_ _3048_/B _2960_/A _2960_/B _3160_/A VPWR VGND sg13cmos5l_o21ai_1
XFILLER_15_471 VPWR VGND sg13cmos5l_decap_8
XFILLER_31_920 VPWR VGND sg13cmos5l_decap_8
XFILLER_34_279 VPWR VGND sg13cmos5l_fill_2
X_2892_ _2892_/Y _2892_/A _2914_/B VPWR VGND sg13cmos5l_nand2_1
X_3513_ _3567_/B _3600_/B VPWR VGND sg13cmos5l_inv_1
Xhold615 _4192_/D _3384_/Y VPWR VGND sg13cmos5l_dlygate4sd3_1
Xhold626 _2187_/A _4072_/Q VPWR VGND sg13cmos5l_dlygate4sd3_1
Xhold604 _3043_/B _4103_/Q VPWR VGND sg13cmos5l_dlygate4sd3_1
Xclkbuf_leaf_6_clk _4031_/CLK clkload0/A VPWR VGND sg13cmos5l_buf_8
Xhold637 _4014_/D _2431_/Y VPWR VGND sg13cmos5l_dlygate4sd3_1
X_3444_ _3444_/Y _3420_/Y _3440_/Y _3390_/B VPWR VGND sg13cmos5l_o21ai_1
Xhold659 hold659/X _3906_/Q VPWR VGND sg13cmos5l_dlygate4sd3_1
Xhold648 _2692_/A _4050_/Q VPWR VGND sg13cmos5l_dlygate4sd3_1
X_3375_ _3375_/Y _3361_/Y _3372_/S _3374_/Y VPWR VGND sg13cmos5l_a21oi_1
X_3923__368 _3923_/RESET_B VPWR VGND sg13cmos5l_tiehi
X_2326_ _3930_/D _3867_/A hold692/X _2331_/S VPWR VGND sg13cmos5l_mux2_1
XFILLER_38_530 VPWR VGND sg13cmos5l_fill_1
X_2257_ _2260_/A _2643_/S1 _2255_/X _2256_/Y VPWR VGND sg13cmos5l_a21oi_1
XFILLER_38_563 VPWR VGND sg13cmos5l_fill_2
XFILLER_26_703 VPWR VGND sg13cmos5l_decap_8
XFILLER_26_714 VPWR VGND sg13cmos5l_fill_1
XFILLER_25_202 VPWR VGND sg13cmos5l_fill_1
X_2188_ _3013_/B _2188_/A VPWR VGND sg13cmos5l_inv_1
XFILLER_14_909 VPWR VGND sg13cmos5l_decap_8
XFILLER_21_441 VPWR VGND sg13cmos5l_decap_8
XFILLER_22_986 VPWR VGND sg13cmos5l_decap_8
XFILLER_21_496 VPWR VGND sg13cmos5l_fill_2
XFILLER_5_629 VPWR VGND sg13cmos5l_decap_8
XFILLER_1_813 VPWR VGND sg13cmos5l_decap_8
XFILLER_0_345 VPWR VGND sg13cmos5l_decap_8
XFILLER_49_828 VPWR VGND sg13cmos5l_decap_8
XFILLER_0_356 VPWR VGND sg13cmos5l_fill_2
XFILLER_48_349 VPWR VGND sg13cmos5l_fill_1
XFILLER_17_736 VPWR VGND sg13cmos5l_fill_2
XFILLER_44_566 VPWR VGND sg13cmos5l_fill_1
XFILLER_25_780 VPWR VGND sg13cmos5l_fill_2
XFILLER_32_739 VPWR VGND sg13cmos5l_decap_8
XFILLER_13_942 VPWR VGND sg13cmos5l_decap_8
XFILLER_31_227 VPWR VGND sg13cmos5l_decap_4
XFILLER_12_452 VPWR VGND sg13cmos5l_fill_2
XFILLER_8_423 VPWR VGND sg13cmos5l_decap_8
XFILLER_8_478 VPWR VGND sg13cmos5l_decap_8
XFILLER_8_467 VPWR VGND sg13cmos5l_decap_8
XFILLER_4_684 VPWR VGND sg13cmos5l_decap_8
X_3160_ _3218_/B _3160_/A _3160_/B _3160_/C VPWR VGND sg13cmos5l_nand3_1
XFILLER_12_4 VPWR VGND sg13cmos5l_decap_8
X_3091_ _3091_/Y _3080_/B _3088_/A _3000_/A VPWR VGND sg13cmos5l_o21ai_1
XFILLER_35_555 VPWR VGND sg13cmos5l_decap_8
XFILLER_35_588 VPWR VGND sg13cmos5l_decap_8
X_3993_ _3993_/Q _4011_/CLK _3993_/D _3993_/RESET_B VPWR VGND sg13cmos5l_dfrbpq_1
XFILLER_22_238 VPWR VGND sg13cmos5l_decap_8
XFILLER_31_761 VPWR VGND sg13cmos5l_decap_8
X_2944_ _2944_/X _2945_/A _2945_/C _3137_/A VPWR VGND sg13cmos5l_a21o_1
X_2875_ _2875_/Y _2183_/A _3035_/A2 _3273_/B VPWR VGND sg13cmos5l_o21ai_1
XFILLER_8_990 VPWR VGND sg13cmos5l_decap_8
X_3427_ _3427_/Y _3427_/A _3435_/A _3427_/C VPWR VGND sg13cmos5l_nor3_1
X_4058__201 _4058_/RESET_B VPWR VGND sg13cmos5l_tiehi
X_3358_ _3358_/Y _3522_/B _3358_/B VPWR VGND sg13cmos5l_nand2_1
X_2309_ _3916_/D hold717/X _3872_/A0 _2311_/S VPWR VGND sg13cmos5l_mux2_1
X_3289_ _3289_/X _3289_/A _3289_/B _3500_/A VPWR VGND sg13cmos5l_and3_1
XFILLER_13_205 VPWR VGND sg13cmos5l_decap_4
XFILLER_41_547 VPWR VGND sg13cmos5l_decap_8
XFILLER_6_905 VPWR VGND sg13cmos5l_decap_8
XFILLER_5_404 VPWR VGND sg13cmos5l_fill_1
Xhold990 hold990/X _3396_/A VPWR VGND sg13cmos5l_dlygate4sd3_1
X_3906__385 _3906_/RESET_B VPWR VGND sg13cmos5l_tiehi
XFILLER_0_186 VPWR VGND sg13cmos5l_decap_8
XFILLER_49_669 VPWR VGND sg13cmos5l_fill_2
XFILLER_45_831 VPWR VGND sg13cmos5l_decap_8
XFILLER_44_92 VPWR VGND sg13cmos5l_fill_2
XFILLER_20_709 VPWR VGND sg13cmos5l_fill_1
XFILLER_32_569 VPWR VGND sg13cmos5l_fill_1
X_3913__378 _3913_/RESET_B VPWR VGND sg13cmos5l_tiehi
X_2660_ _2660_/Y _2677_/S1 _2657_/X _2680_/A1 VPWR VGND sg13cmos5l_o21ai_1
XFILLER_8_231 VPWR VGND sg13cmos5l_fill_2
X_2591_ _2592_/B _3998_/Q _3981_/Q _3964_/Q _3947_/Q _2634_/A _2678_/S1 VPWR VGND
+ sg13cmos5l_mux4_1
XFILLER_5_960 VPWR VGND sg13cmos5l_decap_8
X_4261_ _4261_/Q clkload3/A _4261_/D _4261_/RESET_B VPWR VGND sg13cmos5l_dfrbpq_1
XFILLER_4_481 VPWR VGND sg13cmos5l_decap_8
X_3212_ _4164_/D _3212_/A _3212_/B VPWR VGND sg13cmos5l_and2_1
X_4192_ _4192_/Q _4227_/CLK _4192_/D _4192_/RESET_B VPWR VGND sg13cmos5l_dfrbpq_1
XFILLER_39_168 VPWR VGND sg13cmos5l_fill_2
X_3143_ _3143_/Y _3138_/X _3142_/Y _3137_/X VPWR VGND sg13cmos5l_a21oi_1
XFILLER_28_809 VPWR VGND sg13cmos5l_decap_4
X_3074_ _3074_/Y _3078_/A _3073_/X _3053_/X VPWR VGND sg13cmos5l_a21oi_1
XFILLER_27_319 VPWR VGND sg13cmos5l_decap_8
XFILLER_39_1014 VPWR VGND sg13cmos5l_decap_8
XFILLER_23_514 VPWR VGND sg13cmos5l_fill_1
XFILLER_35_396 VPWR VGND sg13cmos5l_fill_2
X_3976_ _3976_/Q _4011_/CLK _3976_/D _3976_/RESET_B VPWR VGND sg13cmos5l_dfrbpq_1
XFILLER_10_208 VPWR VGND sg13cmos5l_decap_4
XFILLER_31_580 VPWR VGND sg13cmos5l_fill_2
X_2927_ _4110_/D _2895_/Y _2927_/A2 _2885_/B VPWR VGND sg13cmos5l_a21oi_1
X_2858_ _2859_/B _2820_/B _2852_/Y _2854_/Y _2857_/Y VPWR VGND sg13cmos5l_a22oi_1
X_2789_ _2789_/Y _2789_/A _2789_/B _2789_/C VPWR VGND sg13cmos5l_nor3_1
XFILLER_19_809 VPWR VGND sg13cmos5l_decap_8
XFILLER_46_628 VPWR VGND sg13cmos5l_fill_1
XFILLER_26_330 VPWR VGND sg13cmos5l_fill_1
XFILLER_42_812 VPWR VGND sg13cmos5l_fill_1
XFILLER_26_363 VPWR VGND sg13cmos5l_decap_8
XFILLER_26_385 VPWR VGND sg13cmos5l_decap_8
XFILLER_10_764 VPWR VGND sg13cmos5l_decap_8
XFILLER_30_50 VPWR VGND sg13cmos5l_fill_1
XFILLER_5_278 VPWR VGND sg13cmos5l_decap_8
XFILLER_30_61 VPWR VGND sg13cmos5l_fill_2
XFILLER_49_400 VPWR VGND sg13cmos5l_decap_8
XFILLER_49_433 VPWR VGND sg13cmos5l_decap_8
XFILLER_2_996 VPWR VGND sg13cmos5l_decap_8
XFILLER_39_92 VPWR VGND sg13cmos5l_decap_8
XFILLER_45_672 VPWR VGND sg13cmos5l_fill_2
XFILLER_45_661 VPWR VGND sg13cmos5l_decap_8
XFILLER_44_182 VPWR VGND sg13cmos5l_decap_8
X_3830_ _3830_/Y _3819_/A _3818_/A _3829_/Y _2271_/A VPWR VGND sg13cmos5l_a22oi_1
XFILLER_33_878 VPWR VGND sg13cmos5l_fill_2
X_3761_ _3766_/A _3761_/A _3768_/B VPWR VGND sg13cmos5l_or2_1
X_2712_ _2712_/Y _2704_/Y _2707_/A _2709_/Y _2711_/Y VPWR VGND sg13cmos5l_a22oi_1
X_3692_ _3693_/B _3702_/B _3689_/Y _3702_/A VPWR VGND sg13cmos5l_o21ai_1
X_2643_ _2644_/B _3943_/Q _3926_/Q _3909_/Q _3892_/Q _2643_/S0 _2643_/S1 VPWR VGND
+ sg13cmos5l_mux4_1
X_2574_ _2577_/B _2644_/A _2574_/B VPWR VGND sg13cmos5l_nand2_1
X_4244_ _4244_/Q _4265_/CLK _4244_/D _4244_/RESET_B VPWR VGND sg13cmos5l_dfrbpq_1
X_4137__504 _4137_/RESET_B VPWR VGND sg13cmos5l_tiehi
X_4175_ _4175_/Q _4231_/CLK _4175_/D _4175_/RESET_B VPWR VGND sg13cmos5l_dfrbpq_1
XFILLER_27_116 VPWR VGND sg13cmos5l_fill_1
X_3126_ _3222_/A _3122_/S _3124_/X _3125_/Y VPWR VGND sg13cmos5l_a21o_1
XFILLER_28_617 VPWR VGND sg13cmos5l_decap_8
X_4055__204 _4055_/RESET_B VPWR VGND sg13cmos5l_tiehi
XFILLER_43_609 VPWR VGND sg13cmos5l_decap_8
X_3057_ _3073_/B _3055_/Y _3056_/Y _3054_/Y VPWR VGND sg13cmos5l_a21oi_1
XFILLER_23_388 VPWR VGND sg13cmos5l_decap_8
X_4246__256 _4246_/RESET_B VPWR VGND sg13cmos5l_tiehi
X_3959_ _3959_/Q _4011_/CLK _3959_/D _3959_/RESET_B VPWR VGND sg13cmos5l_dfrbpq_1
XFILLER_13_1028 VPWR VGND sg13cmos5l_fill_1
X_3903__388 _3903_/RESET_B VPWR VGND sg13cmos5l_tiehi
XFILLER_47_959 VPWR VGND sg13cmos5l_decap_8
XFILLER_15_823 VPWR VGND sg13cmos5l_decap_4
XFILLER_15_834 VPWR VGND sg13cmos5l_fill_2
XFILLER_27_683 VPWR VGND sg13cmos5l_decap_8
XFILLER_14_399 VPWR VGND sg13cmos5l_fill_1
XFILLER_25_94 VPWR VGND sg13cmos5l_decap_8
XFILLER_41_196 VPWR VGND sg13cmos5l_decap_8
X_4147__165 _4147_/D VPWR VGND sg13cmos5l_tielo
XFILLER_6_554 VPWR VGND sg13cmos5l_fill_2
X_4008__283 _4008_/RESET_B VPWR VGND sg13cmos5l_tiehi
XFILLER_2_793 VPWR VGND sg13cmos5l_decap_8
X_2290_ _2452_/A input3/X input2/X _2290_/C VPWR VGND sg13cmos5l_nand3_1
XFILLER_49_230 VPWR VGND sg13cmos5l_decap_8
XFILLER_2_65 VPWR VGND sg13cmos5l_fill_2
XFILLER_37_447 VPWR VGND sg13cmos5l_decap_4
XFILLER_17_171 VPWR VGND sg13cmos5l_decap_4
XFILLER_36_1017 VPWR VGND sg13cmos5l_decap_8
X_4015__276 _4015_/RESET_B VPWR VGND sg13cmos5l_tiehi
XFILLER_36_1028 VPWR VGND sg13cmos5l_fill_1
X_3813_ _4262_/D _3803_/B _3814_/S _3812_/Y VPWR VGND sg13cmos5l_a21oi_1
XFILLER_32_152 VPWR VGND sg13cmos5l_decap_4
XFILLER_21_848 VPWR VGND sg13cmos5l_fill_1
X_3744_ _3744_/X _3769_/A _4212_/Q _4213_/Q VPWR VGND sg13cmos5l_or3_1
X_3675_ _3676_/B _3686_/B _3674_/Y _3673_/Y VPWR VGND sg13cmos5l_a21oi_1
X_2626_ _2626_/Y _2657_/S _3922_/Q _2654_/A1 VPWR VGND sg13cmos5l_a21oi_1
X_2557_ _2557_/X _4006_/Q _3989_/Q _3972_/Q _3955_/Q _2563_/A _2645_/S1 VPWR VGND
+ sg13cmos5l_mux4_1
X_2488_ _2488_/Y _2165_/Y _2488_/A2 _2487_/Y VPWR VGND sg13cmos5l_a21oi_1
X_4227_ _4227_/Q _4227_/CLK _4227_/D _4227_/RESET_B VPWR VGND sg13cmos5l_dfrbpq_1
XFILLER_46_49 VPWR VGND sg13cmos5l_fill_1
X_4158_ _4158_/Q _4227_/CLK _4158_/D _4158_/RESET_B VPWR VGND sg13cmos5l_dfrbpq_1
X_4089_ _4089_/Q _4137_/CLK _4089_/D _4089_/RESET_B VPWR VGND sg13cmos5l_dfrbpq_1
XFILLER_44_918 VPWR VGND sg13cmos5l_decap_8
XFILLER_43_406 VPWR VGND sg13cmos5l_decap_8
X_3109_ _3114_/B _4172_/Q _4171_/Q _4173_/Q VPWR VGND sg13cmos5l_nor3_1
XFILLER_23_185 VPWR VGND sg13cmos5l_decap_4
XFILLER_11_52 VPWR VGND sg13cmos5l_decap_4
XFILLER_11_96 VPWR VGND sg13cmos5l_decap_8
XFILLER_4_1015 VPWR VGND sg13cmos5l_decap_8
XFILLER_47_756 VPWR VGND sg13cmos5l_decap_8
XFILLER_46_233 VPWR VGND sg13cmos5l_fill_2
XFILLER_46_288 VPWR VGND sg13cmos5l_fill_1
XFILLER_43_940 VPWR VGND sg13cmos5l_decap_8
XFILLER_15_653 VPWR VGND sg13cmos5l_fill_1
XFILLER_27_491 VPWR VGND sg13cmos5l_fill_2
XFILLER_14_163 VPWR VGND sg13cmos5l_fill_2
Xinput13 input13/X uio_in[7] VPWR VGND sg13cmos5l_buf_1
XFILLER_30_678 VPWR VGND sg13cmos5l_decap_8
Xhold808 _2164_/A _4250_/Q VPWR VGND sg13cmos5l_dlygate4sd3_1
Xhold819 _4245_/D _3695_/Y VPWR VGND sg13cmos5l_dlygate4sd3_1
X_3460_ _3775_/A _3531_/A _3764_/C VPWR VGND sg13cmos5l_nor2_1
X_2411_ _4003_/D _3854_/A1 hold778/X _2411_/S VPWR VGND sg13cmos5l_mux2_1
XFILLER_42_4 VPWR VGND sg13cmos5l_decap_8
X_3391_ _4198_/D _3391_/A _3394_/B VPWR VGND sg13cmos5l_nor2_1
X_4121__168 _4121_/D VPWR VGND sg13cmos5l_tielo
X_2342_ _2352_/C _4031_/Q _2342_/B VPWR VGND sg13cmos5l_nor2_1
XFILLER_42_1010 VPWR VGND sg13cmos5l_decap_8
X_4012_ _4012_/Q _4027_/CLK _4012_/D _4012_/RESET_B VPWR VGND sg13cmos5l_dfrbpq_1
X_2273_ _2511_/A _2451_/A _2273_/B VPWR VGND sg13cmos5l_nand2b_1
X_4134__507 _4134_/RESET_B VPWR VGND sg13cmos5l_tiehi
XFILLER_25_439 VPWR VGND sg13cmos5l_fill_2
XFILLER_34_962 VPWR VGND sg13cmos5l_decap_8
XFILLER_20_144 VPWR VGND sg13cmos5l_decap_8
X_3727_ _3805_/C _3801_/A _3800_/A VPWR VGND sg13cmos5l_and2_1
X_3658_ _3659_/B _3658_/A _3658_/B VPWR VGND sg13cmos5l_nand2_1
X_2609_ _2609_/Y _2609_/A VPWR VGND sg13cmos5l_inv_1
X_3589_ _3589_/Y _3589_/A _3596_/S VPWR VGND sg13cmos5l_nand2_1
Xclkbuf_2_2__f_clk clkbuf_leaf_3_clk/A clkbuf_0_clk/X VPWR VGND sg13cmos5l_buf_8
XFILLER_28_299 VPWR VGND sg13cmos5l_fill_1
XFILLER_43_258 VPWR VGND sg13cmos5l_fill_1
XFILLER_43_236 VPWR VGND sg13cmos5l_decap_8
XFILLER_19_1012 VPWR VGND sg13cmos5l_decap_8
XFILLER_25_973 VPWR VGND sg13cmos5l_decap_8
XFILLER_31_409 VPWR VGND sg13cmos5l_decap_8
XFILLER_40_954 VPWR VGND sg13cmos5l_decap_8
XFILLER_24_483 VPWR VGND sg13cmos5l_fill_2
XFILLER_4_844 VPWR VGND sg13cmos5l_decap_4
XFILLER_3_332 VPWR VGND sg13cmos5l_fill_2
XFILLER_0_0 VPWR VGND sg13cmos5l_decap_8
XFILLER_3_398 VPWR VGND sg13cmos5l_decap_8
X_4005__286 _4005_/RESET_B VPWR VGND sg13cmos5l_tiehi
XFILLER_14_8 VPWR VGND sg13cmos5l_fill_2
XFILLER_47_553 VPWR VGND sg13cmos5l_decap_8
XFILLER_19_233 VPWR VGND sg13cmos5l_decap_8
XFILLER_35_759 VPWR VGND sg13cmos5l_decap_8
X_2960_ _3048_/A _2960_/A _2960_/B _2960_/C VPWR VGND sg13cmos5l_or3_1
X_2891_ _2914_/B _2888_/A _2894_/B _2887_/Y _2890_/Y VPWR VGND sg13cmos5l_a22oi_1
XFILLER_42_291 VPWR VGND sg13cmos5l_decap_4
XFILLER_15_494 VPWR VGND sg13cmos5l_decap_4
X_4012__279 _4012_/RESET_B VPWR VGND sg13cmos5l_tiehi
Xhold616 _2761_/A _4058_/Q VPWR VGND sg13cmos5l_dlygate4sd3_1
XFILLER_7_682 VPWR VGND sg13cmos5l_fill_1
X_3512_ _3600_/B hold996/X _3492_/Y _3313_/A VPWR VGND sg13cmos5l_a21oi_1
Xhold605 _3555_/B _4195_/Q VPWR VGND sg13cmos5l_dlygate4sd3_1
Xhold627 _2181_/A _4128_/Q VPWR VGND sg13cmos5l_dlygate4sd3_1
Xhold638 _2429_/B _4026_/Q VPWR VGND sg13cmos5l_dlygate4sd3_1
X_3443_ _4202_/D _3443_/A _3442_/Y VPWR VGND sg13cmos5l_nor2b_1
Xhold649 _2171_/A _4192_/Q VPWR VGND sg13cmos5l_dlygate4sd3_1
X_3374_ _3374_/Y hold899/X _3372_/S _3390_/B VPWR VGND sg13cmos5l_o21ai_1
XFILLER_33_0 VPWR VGND sg13cmos5l_decap_8
X_2325_ _3929_/D _3866_/A0 hold732/X _2331_/S VPWR VGND sg13cmos5l_mux2_1
X_2256_ _2256_/Y _2643_/S1 _2254_/Y _2644_/A VPWR VGND sg13cmos5l_o21ai_1
XFILLER_38_542 VPWR VGND sg13cmos5l_decap_8
XFILLER_38_597 VPWR VGND sg13cmos5l_decap_8
X_2187_ _2187_/Y _2187_/A VPWR VGND sg13cmos5l_inv_1
XFILLER_26_748 VPWR VGND sg13cmos5l_fill_1
XFILLER_25_258 VPWR VGND sg13cmos5l_decap_4
XFILLER_13_409 VPWR VGND sg13cmos5l_fill_2
XFILLER_21_475 VPWR VGND sg13cmos5l_decap_8
XFILLER_49_807 VPWR VGND sg13cmos5l_decap_8
XFILLER_0_335 VPWR VGND sg13cmos5l_decap_4
XFILLER_1_869 VPWR VGND sg13cmos5l_decap_8
XFILLER_44_512 VPWR VGND sg13cmos5l_decap_8
XFILLER_17_715 VPWR VGND sg13cmos5l_decap_8
XFILLER_17_759 VPWR VGND sg13cmos5l_fill_2
XFILLER_31_206 VPWR VGND sg13cmos5l_decap_8
XFILLER_32_729 VPWR VGND sg13cmos5l_fill_1
XFILLER_12_420 VPWR VGND sg13cmos5l_fill_1
XFILLER_40_762 VPWR VGND sg13cmos5l_decap_4
XFILLER_40_784 VPWR VGND sg13cmos5l_decap_8
XFILLER_9_969 VPWR VGND sg13cmos5l_decap_8
XFILLER_12_486 VPWR VGND sg13cmos5l_decap_8
XFILLER_13_998 VPWR VGND sg13cmos5l_decap_8
XFILLER_33_72 VPWR VGND sg13cmos5l_decap_8
X_3090_ _4139_/D _3090_/A _3090_/B _3090_/C VPWR VGND sg13cmos5l_nor3_1
XFILLER_48_895 VPWR VGND sg13cmos5l_decap_8
XFILLER_47_383 VPWR VGND sg13cmos5l_fill_1
XFILLER_16_770 VPWR VGND sg13cmos5l_decap_4
X_3992_ _3992_/Q clkload5/A _3992_/D _3992_/RESET_B VPWR VGND sg13cmos5l_dfrbpq_1
X_2943_ _2943_/X _2945_/A _2945_/C VPWR VGND sg13cmos5l_and2_1
XFILLER_31_740 VPWR VGND sg13cmos5l_decap_8
X_2874_ _4098_/D _2187_/Y _3035_/A2 _2873_/Y VPWR VGND sg13cmos5l_a21oi_1
XFILLER_31_784 VPWR VGND sg13cmos5l_fill_1
X_3426_ _3427_/C _3426_/A _3426_/B _3426_/C VPWR VGND sg13cmos5l_and3_1
X_3357_ _3357_/Y _3358_/B VPWR VGND sg13cmos5l_inv_1
X_2308_ _3915_/D hold735/X _3871_/A0 _2311_/S VPWR VGND sg13cmos5l_mux2_1
X_3288_ _3288_/Y _3292_/A _3312_/A VPWR VGND sg13cmos5l_nand2_1
X_3893__232 _3893_/RESET_B VPWR VGND sg13cmos5l_tiehi
X_2239_ _2239_/Y _4156_/Q VPWR VGND sg13cmos5l_inv_1
XFILLER_41_515 VPWR VGND sg13cmos5l_fill_1
XFILLER_21_261 VPWR VGND sg13cmos5l_decap_4
XFILLER_5_416 VPWR VGND sg13cmos5l_decap_8
Xhold991 _2989_/A _4089_/Q VPWR VGND sg13cmos5l_dlygate4sd3_1
Xhold980 _3000_/B _2999_/Y VPWR VGND sg13cmos5l_dlygate4sd3_1
XFILLER_0_132 VPWR VGND sg13cmos5l_decap_8
XFILLER_1_677 VPWR VGND sg13cmos5l_decap_4
XFILLER_49_648 VPWR VGND sg13cmos5l_decap_8
X_4002__289 _4002_/RESET_B VPWR VGND sg13cmos5l_tiehi
XFILLER_28_72 VPWR VGND sg13cmos5l_fill_1
XFILLER_44_320 VPWR VGND sg13cmos5l_fill_1
XFILLER_17_534 VPWR VGND sg13cmos5l_fill_2
XFILLER_17_556 VPWR VGND sg13cmos5l_decap_8
XFILLER_45_887 VPWR VGND sg13cmos5l_decap_8
XFILLER_44_375 VPWR VGND sg13cmos5l_decap_8
XFILLER_44_353 VPWR VGND sg13cmos5l_fill_2
XFILLER_32_526 VPWR VGND sg13cmos5l_decap_8
XFILLER_13_762 VPWR VGND sg13cmos5l_fill_2
XFILLER_9_733 VPWR VGND sg13cmos5l_decap_8
XFILLER_13_795 VPWR VGND sg13cmos5l_fill_1
XFILLER_8_276 VPWR VGND sg13cmos5l_fill_1
X_2590_ _2590_/Y _2677_/S1 _2587_/X _2680_/A1 VPWR VGND sg13cmos5l_o21ai_1
XFILLER_5_43 VPWR VGND sg13cmos5l_decap_8
X_4260_ _4260_/Q clkload3/A _4260_/D _4260_/RESET_B VPWR VGND sg13cmos5l_dfrbpq_1
X_4198__437 _4198_/RESET_B VPWR VGND sg13cmos5l_tiehi
X_4191_ _4191_/Q _4227_/CLK _4191_/D _4191_/RESET_B VPWR VGND sg13cmos5l_dfrbpq_1
X_3211_ _4163_/D _3212_/A _3211_/B VPWR VGND sg13cmos5l_and2_1
X_3142_ _3142_/Y _3139_/Y _3140_/Y _3159_/A _4139_/Q VPWR VGND sg13cmos5l_a22oi_1
XFILLER_48_670 VPWR VGND sg13cmos5l_fill_1
X_3073_ _3073_/X _3073_/A _3073_/B VPWR VGND sg13cmos5l_xor2_1
XFILLER_47_180 VPWR VGND sg13cmos5l_decap_8
XFILLER_36_832 VPWR VGND sg13cmos5l_fill_1
XFILLER_36_876 VPWR VGND sg13cmos5l_decap_8
X_3975_ _3975_/Q clkload5/A _3975_/D _3975_/RESET_B VPWR VGND sg13cmos5l_dfrbpq_1
X_2926_ _2926_/Y hold953/X _2921_/Y _2925_/Y VPWR VGND sg13cmos5l_a21oi_1
X_2857_ _2857_/Y _4070_/Q _2857_/B VPWR VGND sg13cmos5l_nor2_1
XFILLER_3_909 VPWR VGND sg13cmos5l_decap_8
X_2788_ _2789_/C _2788_/A _2775_/C VPWR VGND sg13cmos5l_nor2b_1
X_3409_ _3426_/A _3423_/A _3438_/B VPWR VGND sg13cmos5l_nand2_1
XFILLER_39_681 VPWR VGND sg13cmos5l_decap_8
XFILLER_38_180 VPWR VGND sg13cmos5l_decap_4
XFILLER_42_857 VPWR VGND sg13cmos5l_fill_1
XFILLER_14_52 VPWR VGND sg13cmos5l_decap_8
XFILLER_14_63 VPWR VGND sg13cmos5l_fill_2
XFILLER_22_581 VPWR VGND sg13cmos5l_fill_1
XFILLER_6_769 VPWR VGND sg13cmos5l_decap_8
XFILLER_2_975 VPWR VGND sg13cmos5l_decap_8
XFILLER_39_82 VPWR VGND sg13cmos5l_fill_1
XFILLER_49_478 VPWR VGND sg13cmos5l_decap_8
XFILLER_29_191 VPWR VGND sg13cmos5l_decap_8
XFILLER_17_375 VPWR VGND sg13cmos5l_fill_1
XFILLER_18_898 VPWR VGND sg13cmos5l_decap_8
XFILLER_32_323 VPWR VGND sg13cmos5l_fill_1
X_3760_ _3760_/Y _3480_/B _3755_/A _3759_/Y VPWR VGND sg13cmos5l_o21ai_1
X_2711_ _2711_/Y _2711_/A _2711_/B VPWR VGND sg13cmos5l_nand2_1
XFILLER_41_890 VPWR VGND sg13cmos5l_fill_1
X_3691_ _3693_/A _3685_/X _3688_/Y _3689_/Y _3702_/B _3690_/Y VPWR VGND sg13cmos5l_a221oi_1
X_2642_ _2649_/A _2676_/A _2642_/B _2642_/C VPWR VGND sg13cmos5l_nor3_1
X_2573_ _2574_/B _3942_/Q _3925_/Q _3908_/Q _3891_/Q _2552_/A _2641_/B2 VPWR VGND
+ sg13cmos5l_mux4_1
XFILLER_5_780 VPWR VGND sg13cmos5l_decap_8
X_4243_ _4243_/Q _4265_/CLK _4243_/D _4243_/RESET_B VPWR VGND sg13cmos5l_dfrbpq_1
X_4174_ _4174_/Q _4205_/CLK _4174_/D _4174_/RESET_B VPWR VGND sg13cmos5l_dfrbpq_1
X_3125_ _3125_/Y _3112_/B _3108_/B _3122_/S VPWR VGND sg13cmos5l_a21oi_1
XFILLER_27_128 VPWR VGND sg13cmos5l_decap_8
XFILLER_27_139 VPWR VGND sg13cmos5l_fill_1
X_3056_ _3056_/Y _4129_/Q _4102_/Q VPWR VGND sg13cmos5l_xnor2_1
XFILLER_24_835 VPWR VGND sg13cmos5l_decap_8
X_3890__246 _3890_/RESET_B VPWR VGND sg13cmos5l_tiehi
XFILLER_36_695 VPWR VGND sg13cmos5l_decap_8
XFILLER_35_194 VPWR VGND sg13cmos5l_decap_8
XFILLER_11_529 VPWR VGND sg13cmos5l_decap_8
XFILLER_23_367 VPWR VGND sg13cmos5l_decap_8
X_3958_ _3958_/Q clkload5/A _3958_/D _3958_/RESET_B VPWR VGND sg13cmos5l_dfrbpq_1
X_3889_ _3889_/Q _4280_/CLK _3889_/D _3889_/RESET_B VPWR VGND sg13cmos5l_dfrbpq_1
X_2909_ _2910_/B _2909_/A _2917_/A _2909_/C VPWR VGND sg13cmos5l_or3_1
XFILLER_3_706 VPWR VGND sg13cmos5l_fill_1
XFILLER_47_938 VPWR VGND sg13cmos5l_decap_8
XFILLER_18_106 VPWR VGND sg13cmos5l_fill_2
XFILLER_46_426 VPWR VGND sg13cmos5l_fill_2
XFILLER_18_117 VPWR VGND sg13cmos5l_fill_1
XFILLER_18_128 VPWR VGND sg13cmos5l_decap_8
XFILLER_27_640 VPWR VGND sg13cmos5l_fill_1
XFILLER_15_813 VPWR VGND sg13cmos5l_fill_1
XFILLER_15_846 VPWR VGND sg13cmos5l_fill_2
XFILLER_14_334 VPWR VGND sg13cmos5l_decap_8
XFILLER_15_868 VPWR VGND sg13cmos5l_fill_1
XFILLER_42_698 VPWR VGND sg13cmos5l_decap_4
XFILLER_42_676 VPWR VGND sg13cmos5l_decap_8
XFILLER_41_153 VPWR VGND sg13cmos5l_decap_8
XFILLER_25_84 VPWR VGND sg13cmos5l_decap_4
XFILLER_6_533 VPWR VGND sg13cmos5l_decap_8
X_3880__415 _3880_/RESET_B VPWR VGND sg13cmos5l_tiehi
XFILLER_29_1014 VPWR VGND sg13cmos5l_decap_8
XFILLER_2_772 VPWR VGND sg13cmos5l_decap_8
XFILLER_1_260 VPWR VGND sg13cmos5l_fill_2
XFILLER_49_297 VPWR VGND sg13cmos5l_fill_2
XFILLER_38_949 VPWR VGND sg13cmos5l_decap_8
XFILLER_37_459 VPWR VGND sg13cmos5l_fill_2
XFILLER_18_662 VPWR VGND sg13cmos5l_fill_1
XFILLER_46_982 VPWR VGND sg13cmos5l_decap_8
XFILLER_45_481 VPWR VGND sg13cmos5l_decap_8
XFILLER_18_695 VPWR VGND sg13cmos5l_fill_1
X_3812_ _3812_/Y _3803_/A _3814_/S _3711_/B VPWR VGND sg13cmos5l_o21ai_1
XFILLER_20_326 VPWR VGND sg13cmos5l_decap_8
XFILLER_32_175 VPWR VGND sg13cmos5l_decap_4
X_3743_ _3743_/X _3769_/A _4212_/Q VPWR VGND sg13cmos5l_or2_1
X_3674_ _3674_/Y _3674_/A _4265_/Q VPWR VGND sg13cmos5l_nor2_1
XFILLER_9_371 VPWR VGND sg13cmos5l_decap_4
X_2625_ _2625_/Y _2624_/A _3888_/Q _2624_/Y VPWR VGND sg13cmos5l_a21oi_1
X_2556_ _2556_/Y _2643_/S1 _2553_/Y _2554_/Y _2555_/Y _2646_/A VPWR VGND sg13cmos5l_a221oi_1
X_2487_ _2487_/Y _2488_/A2 hold790/X _2487_/B1 VPWR VGND sg13cmos5l_o21ai_1
X_4226_ _4226_/Q _4277_/CLK _4226_/D _4226_/RESET_B VPWR VGND sg13cmos5l_dfrbpq_1
X_4157_ _4157_/Q _4227_/CLK _4157_/D _4157_/RESET_B VPWR VGND sg13cmos5l_dfrbpq_1
XFILLER_28_415 VPWR VGND sg13cmos5l_fill_1
XFILLER_29_927 VPWR VGND sg13cmos5l_fill_2
X_3108_ _3108_/X _3112_/B _3108_/B _3124_/A VPWR VGND sg13cmos5l_and3_1
X_4088_ _4088_/Q _4137_/CLK _4088_/D _4088_/RESET_B VPWR VGND sg13cmos5l_dfrbpq_1
X_3039_ _3039_/Y _4130_/Q _3553_/A2 _3555_/A VPWR VGND sg13cmos5l_o21ai_1
XFILLER_24_654 VPWR VGND sg13cmos5l_decap_4
XFILLER_36_492 VPWR VGND sg13cmos5l_decap_8
XFILLER_23_164 VPWR VGND sg13cmos5l_decap_8
XFILLER_7_319 VPWR VGND sg13cmos5l_fill_1
XFILLER_7_308 VPWR VGND sg13cmos5l_decap_4
XFILLER_3_536 VPWR VGND sg13cmos5l_decap_8
XFILLER_3_514 VPWR VGND sg13cmos5l_decap_8
XFILLER_3_569 VPWR VGND sg13cmos5l_decap_4
XFILLER_2_4 VPWR VGND sg13cmos5l_fill_1
XFILLER_47_702 VPWR VGND sg13cmos5l_decap_8
XFILLER_28_960 VPWR VGND sg13cmos5l_decap_4
XFILLER_43_996 VPWR VGND sg13cmos5l_decap_8
XFILLER_42_451 VPWR VGND sg13cmos5l_fill_1
XFILLER_42_495 VPWR VGND sg13cmos5l_fill_1
XFILLER_42_484 VPWR VGND sg13cmos5l_decap_8
XFILLER_14_186 VPWR VGND sg13cmos5l_fill_2
XFILLER_30_624 VPWR VGND sg13cmos5l_decap_4
XFILLER_6_330 VPWR VGND sg13cmos5l_decap_8
XFILLER_10_381 VPWR VGND sg13cmos5l_fill_1
Xhold809 hold809/X _3892_/Q VPWR VGND sg13cmos5l_dlygate4sd3_1
X_2410_ _4002_/D _2419_/A0 hold771/X _2411_/S VPWR VGND sg13cmos5l_mux2_1
X_3390_ _4197_/D _3390_/A _3390_/B VPWR VGND sg13cmos5l_and2_1
X_2341_ _3944_/D input5/X hold796/X _2341_/S VPWR VGND sg13cmos5l_mux2_1
X_2272_ _2497_/C _2272_/A hold1016/X VPWR VGND sg13cmos5l_nor2b_1
XFILLER_38_713 VPWR VGND sg13cmos5l_decap_4
X_4011_ _4011_/Q _4011_/CLK _4011_/D _4011_/RESET_B VPWR VGND sg13cmos5l_dfrbpq_1
X_4052__208 _4052_/RESET_B VPWR VGND sg13cmos5l_tiehi
XFILLER_37_289 VPWR VGND sg13cmos5l_decap_8
XFILLER_34_941 VPWR VGND sg13cmos5l_decap_8
XFILLER_33_495 VPWR VGND sg13cmos5l_decap_4
X_3726_ _3800_/A _4258_/Q _3733_/B VPWR VGND sg13cmos5l_or2_1
X_3657_ _4241_/D _3815_/A _3657_/B VPWR VGND sg13cmos5l_nor2_1
X_2608_ _2609_/A _4002_/Q _3985_/Q _3968_/Q _3951_/Q _2668_/A _2678_/S1 VPWR VGND
+ sg13cmos5l_mux4_1
X_3588_ _3588_/Y _3595_/B _3588_/B VPWR VGND sg13cmos5l_nor2_1
X_2539_ _2539_/Y _4048_/Q _2539_/B VPWR VGND sg13cmos5l_nand2b_1
X_4209_ _4209_/Q _4237_/CLK _4209_/D _4209_/RESET_B VPWR VGND sg13cmos5l_dfrbpq_1
XFILLER_16_418 VPWR VGND sg13cmos5l_fill_1
XFILLER_11_156 VPWR VGND sg13cmos5l_decap_4
XFILLER_7_138 VPWR VGND sg13cmos5l_fill_1
XFILLER_22_96 VPWR VGND sg13cmos5l_decap_4
XFILLER_3_377 VPWR VGND sg13cmos5l_fill_1
XFILLER_3_366 VPWR VGND sg13cmos5l_decap_8
XFILLER_47_532 VPWR VGND sg13cmos5l_decap_8
XFILLER_47_598 VPWR VGND sg13cmos5l_fill_2
XFILLER_35_727 VPWR VGND sg13cmos5l_decap_8
XFILLER_34_226 VPWR VGND sg13cmos5l_fill_1
XFILLER_35_749 VPWR VGND sg13cmos5l_decap_4
XFILLER_16_985 VPWR VGND sg13cmos5l_decap_8
XFILLER_31_900 VPWR VGND sg13cmos5l_fill_2
X_2890_ _2890_/Y _2890_/A _2890_/B VPWR VGND sg13cmos5l_nor2_1
XFILLER_30_454 VPWR VGND sg13cmos5l_decap_4
XFILLER_31_966 VPWR VGND sg13cmos5l_fill_1
XFILLER_31_999 VPWR VGND sg13cmos5l_decap_8
XFILLER_7_661 VPWR VGND sg13cmos5l_decap_8
X_3511_ _4214_/D _3561_/B _3511_/B VPWR VGND sg13cmos5l_nor2_1
Xhold606 _2184_/A _4098_/Q VPWR VGND sg13cmos5l_dlygate4sd3_1
Xhold617 _4080_/D _2761_/X VPWR VGND sg13cmos5l_dlygate4sd3_1
X_3442_ _3442_/Y _3403_/X _3440_/Y _3347_/A VPWR VGND sg13cmos5l_a21oi_1
Xhold639 _2170_/A _4193_/Q VPWR VGND sg13cmos5l_dlygate4sd3_1
Xhold628 _2896_/A _4100_/Q VPWR VGND sg13cmos5l_dlygate4sd3_1
X_4140__501 _4140_/RESET_B VPWR VGND sg13cmos5l_tiehi
X_3373_ _4185_/D _3373_/A _3373_/B VPWR VGND sg13cmos5l_nor2_1
X_2324_ _3928_/D _3865_/A0 hold705/X _2331_/S VPWR VGND sg13cmos5l_mux2_1
X_2255_ _2255_/X _3910_/Q _3893_/Q _2552_/A VPWR VGND sg13cmos5l_mux2_1
X_2186_ _2186_/Y _2186_/A VPWR VGND sg13cmos5l_inv_1
XFILLER_25_248 VPWR VGND sg13cmos5l_fill_1
XFILLER_41_719 VPWR VGND sg13cmos5l_decap_8
XFILLER_21_410 VPWR VGND sg13cmos5l_fill_2
XFILLER_22_944 VPWR VGND sg13cmos5l_fill_2
XFILLER_33_270 VPWR VGND sg13cmos5l_fill_1
XFILLER_21_498 VPWR VGND sg13cmos5l_fill_1
X_3709_ _3709_/Y hold849/X _3710_/A2 _3556_/A VPWR VGND sg13cmos5l_o21ai_1
XFILLER_49_1028 VPWR VGND sg13cmos5l_fill_1
XFILLER_49_1017 VPWR VGND sg13cmos5l_decap_8
XFILLER_1_848 VPWR VGND sg13cmos5l_decap_8
XFILLER_29_543 VPWR VGND sg13cmos5l_decap_8
XFILLER_44_535 VPWR VGND sg13cmos5l_decap_8
XFILLER_16_226 VPWR VGND sg13cmos5l_decap_4
XFILLER_16_248 VPWR VGND sg13cmos5l_decap_8
XFILLER_17_74 VPWR VGND sg13cmos5l_fill_2
XFILLER_32_708 VPWR VGND sg13cmos5l_decap_8
XFILLER_32_719 VPWR VGND sg13cmos5l_fill_2
XFILLER_13_977 VPWR VGND sg13cmos5l_decap_8
XFILLER_24_292 VPWR VGND sg13cmos5l_fill_2
XFILLER_33_51 VPWR VGND sg13cmos5l_decap_8
XFILLER_9_937 VPWR VGND sg13cmos5l_decap_8
XFILLER_9_948 VPWR VGND sg13cmos5l_decap_8
XFILLER_12_465 VPWR VGND sg13cmos5l_decap_8
X_4011__280 _4011_/RESET_B VPWR VGND sg13cmos5l_tiehi
XFILLER_3_130 VPWR VGND sg13cmos5l_fill_1
XFILLER_48_874 VPWR VGND sg13cmos5l_decap_8
XFILLER_22_207 VPWR VGND sg13cmos5l_decap_8
X_3991_ _3991_/Q clkload5/A _3991_/D _3991_/RESET_B VPWR VGND sg13cmos5l_dfrbpq_1
X_2942_ _2945_/C _4112_/Q _4113_/Q _4114_/Q VPWR VGND sg13cmos5l_o21ai_1
XFILLER_16_793 VPWR VGND sg13cmos5l_decap_8
XFILLER_43_590 VPWR VGND sg13cmos5l_fill_1
XFILLER_30_240 VPWR VGND sg13cmos5l_decap_4
X_2873_ _2873_/Y _2184_/A _3035_/A2 _2792_/B VPWR VGND sg13cmos5l_o21ai_1
XFILLER_31_796 VPWR VGND sg13cmos5l_decap_8
X_3425_ _3425_/Y _3420_/Y _3422_/Y _3424_/Y _3426_/A _3403_/X VPWR VGND sg13cmos5l_a221oi_1
X_3356_ _3358_/B _4157_/Q _3353_/Y _3355_/Y VPWR VGND sg13cmos5l_o21ai_1
X_2307_ _3914_/D hold702/X _3859_/A0 _2311_/S VPWR VGND sg13cmos5l_mux2_1
X_3287_ _3312_/A _4178_/Q _3289_/A VPWR VGND sg13cmos5l_xor2_1
XFILLER_39_863 VPWR VGND sg13cmos5l_decap_8
X_2238_ _3201_/A _4157_/Q VPWR VGND sg13cmos5l_inv_1
X_2169_ _3680_/A _2169_/A VPWR VGND sg13cmos5l_inv_1
X_4249__244 _4249_/RESET_B VPWR VGND sg13cmos5l_tiehi
XFILLER_10_936 VPWR VGND sg13cmos5l_fill_2
XFILLER_16_1027 VPWR VGND sg13cmos5l_fill_2
XFILLER_22_774 VPWR VGND sg13cmos5l_decap_8
Xhold970 _2824_/B _2894_/A VPWR VGND sg13cmos5l_dlygate4sd3_1
Xhold981 _3419_/A _4198_/Q VPWR VGND sg13cmos5l_dlygate4sd3_1
Xhold992 hold992/X _4109_/Q VPWR VGND sg13cmos5l_dlygate4sd3_1
XFILLER_49_627 VPWR VGND sg13cmos5l_decap_4
XFILLER_0_155 VPWR VGND sg13cmos5l_decap_8
XFILLER_45_811 VPWR VGND sg13cmos5l_fill_2
XFILLER_29_351 VPWR VGND sg13cmos5l_decap_4
XFILLER_44_332 VPWR VGND sg13cmos5l_decap_8
XFILLER_29_384 VPWR VGND sg13cmos5l_decap_8
XFILLER_45_866 VPWR VGND sg13cmos5l_decap_8
XFILLER_32_549 VPWR VGND sg13cmos5l_decap_4
XFILLER_8_233 VPWR VGND sg13cmos5l_fill_1
XFILLER_9_778 VPWR VGND sg13cmos5l_decap_8
XFILLER_8_299 VPWR VGND sg13cmos5l_decap_8
XFILLER_5_995 VPWR VGND sg13cmos5l_decap_8
X_4190_ _4190_/Q _4277_/CLK _4190_/D _4190_/RESET_B VPWR VGND sg13cmos5l_dfrbpq_1
X_3210_ _4162_/D _3273_/B _3210_/B VPWR VGND sg13cmos5l_and2_1
X_3141_ _3159_/A _4117_/Q _4118_/Q VPWR VGND sg13cmos5l_xnor2_1
X_3072_ _3089_/A _2963_/B _3071_/B _3071_/Y VPWR VGND sg13cmos5l_o21ai_1
XFILLER_36_855 VPWR VGND sg13cmos5l_decap_8
XFILLER_35_398 VPWR VGND sg13cmos5l_fill_1
XFILLER_16_590 VPWR VGND sg13cmos5l_decap_8
X_3974_ _3974_/Q clkload5/A _3974_/D _3974_/RESET_B VPWR VGND sg13cmos5l_dfrbpq_1
X_2925_ _2925_/Y _2918_/B _2921_/Y _2884_/B VPWR VGND sg13cmos5l_o21ai_1
X_2856_ _2860_/B _2852_/Y _2853_/Y _2854_/Y _2855_/Y VPWR VGND sg13cmos5l_a22oi_1
X_2787_ _2789_/B _2787_/A _2788_/A VPWR VGND sg13cmos5l_nor2b_1
XFILLER_2_409 VPWR VGND sg13cmos5l_decap_8
X_4025__257 _4025_/RESET_B VPWR VGND sg13cmos5l_tiehi
XFILLER_49_39 VPWR VGND sg13cmos5l_decap_8
X_3408_ _3417_/A _4201_/Q _3438_/B VPWR VGND sg13cmos5l_nor2_1
X_3339_ _3396_/D _3343_/B _3343_/C _3121_/Y VPWR VGND sg13cmos5l_o21ai_1
X_4001__290 _4001_/RESET_B VPWR VGND sg13cmos5l_tiehi
XFILLER_27_833 VPWR VGND sg13cmos5l_decap_4
XFILLER_27_855 VPWR VGND sg13cmos5l_decap_8
XFILLER_27_888 VPWR VGND sg13cmos5l_decap_8
XFILLER_10_711 VPWR VGND sg13cmos5l_fill_1
XFILLER_10_733 VPWR VGND sg13cmos5l_decap_8
XFILLER_10_744 VPWR VGND sg13cmos5l_fill_1
XFILLER_6_748 VPWR VGND sg13cmos5l_decap_8
XFILLER_30_85 VPWR VGND sg13cmos5l_fill_2
XFILLER_2_954 VPWR VGND sg13cmos5l_decap_8
XFILLER_7_1014 VPWR VGND sg13cmos5l_decap_8
XFILLER_17_321 VPWR VGND sg13cmos5l_decap_8
XFILLER_17_343 VPWR VGND sg13cmos5l_fill_2
XFILLER_18_877 VPWR VGND sg13cmos5l_decap_8
XFILLER_17_387 VPWR VGND sg13cmos5l_fill_1
XFILLER_32_357 VPWR VGND sg13cmos5l_fill_2
X_2710_ _2711_/B _4059_/Q _4060_/Q VPWR VGND sg13cmos5l_xnor2_1
XFILLER_9_520 VPWR VGND sg13cmos5l_decap_8
X_3690_ _3690_/Y _3690_/A _3690_/B VPWR VGND sg13cmos5l_nor2_1
XFILLER_9_564 VPWR VGND sg13cmos5l_fill_1
X_2641_ _2642_/C _2637_/Y _2638_/Y _2640_/Y _2641_/B2 _2675_/C1 VPWR VGND sg13cmos5l_a221oi_1
X_2572_ _2579_/A _2572_/A _2572_/B _2676_/A VPWR VGND sg13cmos5l_nor3_1
XFILLER_45_1020 VPWR VGND sg13cmos5l_decap_8
X_4242_ _4242_/Q _4265_/CLK _4242_/D _4242_/RESET_B VPWR VGND sg13cmos5l_dfrbpq_1
X_4173_ _4173_/Q _4173_/CLK _4173_/D _4173_/RESET_B VPWR VGND sg13cmos5l_dfrbpq_1
X_3124_ _3124_/X _3124_/A _3124_/B VPWR VGND sg13cmos5l_and2_1
XFILLER_48_490 VPWR VGND sg13cmos5l_fill_2
X_3055_ _3055_/Y _4128_/Q _4101_/Q VPWR VGND sg13cmos5l_xnor2_1
XFILLER_24_814 VPWR VGND sg13cmos5l_decap_8
XFILLER_23_324 VPWR VGND sg13cmos5l_decap_8
XFILLER_23_335 VPWR VGND sg13cmos5l_fill_2
XFILLER_23_346 VPWR VGND sg13cmos5l_decap_8
XFILLER_11_508 VPWR VGND sg13cmos5l_decap_8
X_3957_ _3957_/Q clkload5/A _3957_/D _3957_/RESET_B VPWR VGND sg13cmos5l_dfrbpq_1
X_2908_ _2909_/C _2908_/A _2908_/B _2908_/C VPWR VGND sg13cmos5l_and3_1
XFILLER_13_1019 VPWR VGND sg13cmos5l_decap_8
X_3888_ _3888_/Q clkload2/A _3888_/D _3888_/RESET_B VPWR VGND sg13cmos5l_dfrbpq_1
X_2839_ _2839_/Y _2839_/A _2845_/B VPWR VGND sg13cmos5l_nor2_1
XFILLER_2_228 VPWR VGND sg13cmos5l_fill_2
XFILLER_4_8 VPWR VGND sg13cmos5l_fill_1
XFILLER_47_917 VPWR VGND sg13cmos5l_decap_8
XFILLER_19_619 VPWR VGND sg13cmos5l_decap_8
XFILLER_42_655 VPWR VGND sg13cmos5l_decap_8
XFILLER_41_110 VPWR VGND sg13cmos5l_fill_1
XFILLER_26_195 VPWR VGND sg13cmos5l_decap_4
XFILLER_14_357 VPWR VGND sg13cmos5l_fill_1
XFILLER_30_839 VPWR VGND sg13cmos5l_fill_2
XFILLER_6_501 VPWR VGND sg13cmos5l_fill_2
XFILLER_6_512 VPWR VGND sg13cmos5l_decap_8
XFILLER_6_567 VPWR VGND sg13cmos5l_decap_8
XFILLER_2_751 VPWR VGND sg13cmos5l_decap_8
XFILLER_49_265 VPWR VGND sg13cmos5l_decap_4
XFILLER_38_928 VPWR VGND sg13cmos5l_decap_8
XFILLER_2_67 VPWR VGND sg13cmos5l_fill_1
XFILLER_46_961 VPWR VGND sg13cmos5l_decap_8
X_3811_ _4261_/D _3787_/X _3814_/S _3811_/B1 VPWR VGND sg13cmos5l_a21oi_1
XFILLER_20_338 VPWR VGND sg13cmos5l_decap_8
X_3742_ _3761_/A _4212_/Q _4213_/Q VPWR VGND sg13cmos5l_xor2_1
X_3673_ _3673_/Y _4221_/Q _3673_/B _3686_/B VPWR VGND sg13cmos5l_nor3_1
X_2624_ _2624_/Y _2624_/A _3905_/Q VPWR VGND sg13cmos5l_nor2b_1
X_2555_ _2555_/Y _2552_/A _3921_/Q _2643_/S1 VPWR VGND sg13cmos5l_a21oi_1
X_2486_ _2486_/Y _3690_/A _2488_/A2 _2485_/Y VPWR VGND sg13cmos5l_a21oi_1
X_4225_ _4225_/Q _4227_/CLK _4225_/D _4225_/RESET_B VPWR VGND sg13cmos5l_dfrbpq_1
X_4156_ _4156_/Q _4205_/CLK _4156_/D _4156_/RESET_B VPWR VGND sg13cmos5l_dfrbpq_1
X_3107_ _3107_/Y _3103_/Y _3105_/Y _3106_/Y _4171_/Q VPWR VGND sg13cmos5l_a22oi_1
X_4087_ _4087_/Q _4137_/CLK _4087_/D _4087_/RESET_B VPWR VGND sg13cmos5l_dfrbpq_1
XFILLER_37_994 VPWR VGND sg13cmos5l_decap_8
X_3038_ _4129_/D _2183_/Y _3040_/A2 _3037_/Y VPWR VGND sg13cmos5l_a21oi_1
XFILLER_23_143 VPWR VGND sg13cmos5l_fill_1
XFILLER_20_872 VPWR VGND sg13cmos5l_decap_8
XFILLER_20_883 VPWR VGND sg13cmos5l_fill_2
X_4194__441 _4194_/RESET_B VPWR VGND sg13cmos5l_tiehi
XFILLER_46_213 VPWR VGND sg13cmos5l_decap_8
XFILLER_46_202 VPWR VGND sg13cmos5l_fill_1
XFILLER_19_416 VPWR VGND sg13cmos5l_fill_2
XFILLER_19_427 VPWR VGND sg13cmos5l_fill_1
XFILLER_19_438 VPWR VGND sg13cmos5l_decap_8
XFILLER_35_909 VPWR VGND sg13cmos5l_fill_1
XFILLER_15_611 VPWR VGND sg13cmos5l_decap_4
XFILLER_27_471 VPWR VGND sg13cmos5l_fill_1
XFILLER_28_983 VPWR VGND sg13cmos5l_decap_8
XFILLER_36_62 VPWR VGND sg13cmos5l_decap_8
XFILLER_43_975 VPWR VGND sg13cmos5l_decap_8
XFILLER_42_463 VPWR VGND sg13cmos5l_decap_8
XFILLER_11_894 VPWR VGND sg13cmos5l_decap_8
XFILLER_10_393 VPWR VGND sg13cmos5l_fill_2
XFILLER_6_397 VPWR VGND sg13cmos5l_decap_4
X_2340_ _3943_/D _3863_/A0 hold706/X _2341_/S VPWR VGND sg13cmos5l_mux2_1
X_2271_ _2272_/A _2271_/A _3825_/A _2271_/C VPWR VGND sg13cmos5l_nor3_1
X_4010_ _4010_/Q _4011_/CLK _4010_/D _4010_/RESET_B VPWR VGND sg13cmos5l_dfrbpq_1
XFILLER_28_4 VPWR VGND sg13cmos5l_fill_2
XFILLER_37_224 VPWR VGND sg13cmos5l_decap_8
XFILLER_34_920 VPWR VGND sg13cmos5l_decap_8
XFILLER_34_997 VPWR VGND sg13cmos5l_decap_8
XFILLER_33_474 VPWR VGND sg13cmos5l_decap_8
XFILLER_33_485 VPWR VGND sg13cmos5l_fill_1
XFILLER_20_124 VPWR VGND sg13cmos5l_fill_2
X_3725_ _3801_/A _4257_/Q _3733_/B _3794_/A VPWR VGND sg13cmos5l_a21o_1
XFILLER_20_179 VPWR VGND sg13cmos5l_decap_4
Xclkbuf_leaf_9_clk clkload8/A clkload0/A VPWR VGND sg13cmos5l_buf_8
X_3656_ _3657_/B _3623_/Y _3655_/Y _3659_/A VPWR VGND sg13cmos5l_mux2_1
X_2607_ _2607_/X _3934_/Q _3917_/Q _3900_/Q _3883_/Q _2603_/A _2675_/B2 VPWR VGND
+ sg13cmos5l_mux4_1
X_3587_ _3587_/Y _3587_/A _3587_/B VPWR VGND sg13cmos5l_xnor2_1
X_2538_ _2538_/Y _2539_/B _2727_/A hold894/X VPWR VGND sg13cmos5l_o21ai_1
XFILLER_0_529 VPWR VGND sg13cmos5l_decap_4
X_2469_ _2469_/Y _2278_/A _2468_/Y _2487_/B1 VPWR VGND sg13cmos5l_o21ai_1
X_4208_ _4208_/Q _4237_/CLK _4208_/D _4208_/RESET_B VPWR VGND sg13cmos5l_dfrbpq_1
XFILLER_28_213 VPWR VGND sg13cmos5l_fill_2
X_4139_ _4139_/Q _4168_/CLK _4139_/D _4139_/RESET_B VPWR VGND sg13cmos5l_dfrbpq_1
XFILLER_28_257 VPWR VGND sg13cmos5l_fill_2
XFILLER_44_739 VPWR VGND sg13cmos5l_decap_8
XFILLER_43_205 VPWR VGND sg13cmos5l_fill_2
XFILLER_16_408 VPWR VGND sg13cmos5l_fill_1
XFILLER_40_912 VPWR VGND sg13cmos5l_decap_4
XFILLER_12_603 VPWR VGND sg13cmos5l_decap_8
XFILLER_11_113 VPWR VGND sg13cmos5l_decap_4
XFILLER_24_485 VPWR VGND sg13cmos5l_fill_1
XFILLER_40_989 VPWR VGND sg13cmos5l_decap_8
XFILLER_11_179 VPWR VGND sg13cmos5l_decap_4
XFILLER_3_301 VPWR VGND sg13cmos5l_decap_8
XFILLER_4_868 VPWR VGND sg13cmos5l_decap_8
XFILLER_35_706 VPWR VGND sg13cmos5l_decap_4
XFILLER_47_577 VPWR VGND sg13cmos5l_decap_8
XFILLER_16_953 VPWR VGND sg13cmos5l_fill_1
XFILLER_43_794 VPWR VGND sg13cmos5l_decap_8
XFILLER_8_22 VPWR VGND sg13cmos5l_decap_8
XFILLER_31_978 VPWR VGND sg13cmos5l_decap_8
X_3510_ _3511_/B _3494_/Y _3509_/S _3508_/Y VPWR VGND sg13cmos5l_o21ai_1
XFILLER_6_161 VPWR VGND sg13cmos5l_fill_2
Xhold618 _2178_/A _4159_/Q VPWR VGND sg13cmos5l_dlygate4sd3_1
Xhold607 _4128_/D _3036_/Y VPWR VGND sg13cmos5l_dlygate4sd3_1
XFILLER_7_695 VPWR VGND sg13cmos5l_decap_8
XFILLER_6_172 VPWR VGND sg13cmos5l_decap_4
X_3441_ _3443_/A _3426_/A _3424_/Y _3440_/Y VPWR VGND sg13cmos5l_a21oi_1
Xhold629 _4130_/D _3040_/Y VPWR VGND sg13cmos5l_dlygate4sd3_1
X_3372_ _3372_/X _3530_/B _3364_/Y _3372_/S VPWR VGND sg13cmos5l_mux2_1
X_2323_ _2331_/S _3846_/D _2332_/B VPWR VGND sg13cmos5l_nand2_1
XFILLER_38_511 VPWR VGND sg13cmos5l_decap_4
X_2254_ _2254_/Y _2552_/A _3944_/Q _2253_/Y VPWR VGND sg13cmos5l_o21ai_1
X_2185_ _2185_/Y _2768_/A VPWR VGND sg13cmos5l_inv_1
XFILLER_26_739 VPWR VGND sg13cmos5l_decap_8
XFILLER_19_791 VPWR VGND sg13cmos5l_decap_4
XFILLER_40_208 VPWR VGND sg13cmos5l_decap_4
XFILLER_22_912 VPWR VGND sg13cmos5l_decap_8
XFILLER_22_934 VPWR VGND sg13cmos5l_fill_2
XFILLER_33_282 VPWR VGND sg13cmos5l_decap_4
XFILLER_33_293 VPWR VGND sg13cmos5l_fill_2
X_3708_ _3708_/Y _2162_/Y _3708_/A2 _3707_/Y VPWR VGND sg13cmos5l_a21oi_1
X_3639_ _3647_/B _4243_/Q _3640_/B VPWR VGND sg13cmos5l_nor2b_1
XFILLER_1_827 VPWR VGND sg13cmos5l_decap_8
XFILLER_1_1009 VPWR VGND sg13cmos5l_decap_8
XFILLER_29_566 VPWR VGND sg13cmos5l_fill_1
X_4035__237 _4035_/RESET_B VPWR VGND sg13cmos5l_tiehi
XFILLER_8_404 VPWR VGND sg13cmos5l_fill_1
X_4267__548 _4267_/RESET_B VPWR VGND sg13cmos5l_tiehi
XFILLER_9_905 VPWR VGND sg13cmos5l_fill_1
XFILLER_13_956 VPWR VGND sg13cmos5l_decap_8
XFILLER_24_282 VPWR VGND sg13cmos5l_fill_1
XFILLER_33_41 VPWR VGND sg13cmos5l_fill_1
XFILLER_32_1022 VPWR VGND sg13cmos5l_decap_8
XFILLER_33_96 VPWR VGND sg13cmos5l_fill_1
XFILLER_4_654 VPWR VGND sg13cmos5l_decap_8
XFILLER_3_142 VPWR VGND sg13cmos5l_decap_8
XFILLER_4_698 VPWR VGND sg13cmos5l_decap_8
XFILLER_3_164 VPWR VGND sg13cmos5l_fill_2
XFILLER_0_893 VPWR VGND sg13cmos5l_decap_8
XFILLER_48_853 VPWR VGND sg13cmos5l_decap_8
XFILLER_16_750 VPWR VGND sg13cmos5l_decap_8
X_3990_ _3990_/Q clkload5/A _3990_/D _3990_/RESET_B VPWR VGND sg13cmos5l_dfrbpq_1
XFILLER_15_260 VPWR VGND sg13cmos5l_fill_2
XFILLER_22_219 VPWR VGND sg13cmos5l_fill_1
X_2941_ _3137_/A _4139_/Q _4140_/Q VPWR VGND sg13cmos5l_xnor2_1
X_2872_ _4097_/D _3547_/A _2872_/B VPWR VGND sg13cmos5l_and2_1
XFILLER_30_274 VPWR VGND sg13cmos5l_fill_2
XFILLER_30_285 VPWR VGND sg13cmos5l_decap_8
XFILLER_7_470 VPWR VGND sg13cmos5l_decap_4
X_3424_ _3424_/Y _3435_/A _3424_/B VPWR VGND sg13cmos5l_nor2_1
X_3355_ _3355_/Y _4204_/Q _3561_/A _3355_/C VPWR VGND sg13cmos5l_nand3_1
X_3286_ _3297_/B _4178_/Q _3289_/A VPWR VGND sg13cmos5l_nor2_1
X_2306_ _3913_/D hold776/X _3867_/A _2311_/S VPWR VGND sg13cmos5l_mux2_1
X_2237_ _3781_/A _4215_/Q VPWR VGND sg13cmos5l_inv_1
X_2168_ _2168_/Y _2168_/A VPWR VGND sg13cmos5l_inv_1
XFILLER_41_528 VPWR VGND sg13cmos5l_fill_1
XFILLER_13_219 VPWR VGND sg13cmos5l_decap_8
XFILLER_16_1006 VPWR VGND sg13cmos5l_decap_8
XFILLER_22_786 VPWR VGND sg13cmos5l_fill_1
XFILLER_6_919 VPWR VGND sg13cmos5l_decap_8
XFILLER_22_797 VPWR VGND sg13cmos5l_decap_8
X_4223__407 _4223_/RESET_B VPWR VGND sg13cmos5l_tiehi
Xhold982 _3420_/B _3419_/Y VPWR VGND sg13cmos5l_dlygate4sd3_1
Xhold971 _2219_/A _4171_/Q VPWR VGND sg13cmos5l_dlygate4sd3_1
Xhold960 _2215_/A _4139_/Q VPWR VGND sg13cmos5l_dlygate4sd3_1
X_4256__216 _4256_/RESET_B VPWR VGND sg13cmos5l_tiehi
Xhold993 _3334_/A _4148_/Q VPWR VGND sg13cmos5l_dlygate4sd3_1
Xheichips26_dna_sequencer uio_oe[0] VPWR VGND sg13cmos5l_tielo
XFILLER_28_52 VPWR VGND sg13cmos5l_fill_2
XFILLER_45_845 VPWR VGND sg13cmos5l_decap_8
XFILLER_17_536 VPWR VGND sg13cmos5l_fill_1
XFILLER_28_96 VPWR VGND sg13cmos5l_decap_4
X_4130__512 _4130_/RESET_B VPWR VGND sg13cmos5l_tiehi
XFILLER_13_742 VPWR VGND sg13cmos5l_fill_2
XFILLER_9_713 VPWR VGND sg13cmos5l_fill_1
XFILLER_13_764 VPWR VGND sg13cmos5l_fill_1
XFILLER_5_974 VPWR VGND sg13cmos5l_decap_8
XFILLER_4_440 VPWR VGND sg13cmos5l_fill_1
XFILLER_4_495 VPWR VGND sg13cmos5l_decap_8
XFILLER_39_116 VPWR VGND sg13cmos5l_fill_1
X_3140_ _3140_/Y _4139_/Q _4118_/Q VPWR VGND sg13cmos5l_nand2b_1
XFILLER_0_690 VPWR VGND sg13cmos5l_decap_8
X_3071_ _3071_/Y _2998_/B _3071_/B VPWR VGND sg13cmos5l_nand2b_1
XFILLER_10_4 VPWR VGND sg13cmos5l_fill_2
XFILLER_39_1028 VPWR VGND sg13cmos5l_fill_1
X_3973_ _3973_/Q clkload5/A _3973_/D _3973_/RESET_B VPWR VGND sg13cmos5l_dfrbpq_1
X_2924_ _2924_/Y _2924_/A hold956/X VPWR VGND sg13cmos5l_nor2b_1
X_2855_ _2855_/Y _4070_/Q _2855_/B VPWR VGND sg13cmos5l_nor2_1
X_4244__153 _4244_/D VPWR VGND sg13cmos5l_tielo
X_2786_ _4081_/D _2786_/A _2786_/B VPWR VGND sg13cmos5l_nor2_1
XFILLER_49_18 VPWR VGND sg13cmos5l_decap_8
X_3407_ _3433_/B _3405_/Y _3406_/Y _3404_/Y VPWR VGND sg13cmos5l_a21oi_1
X_3338_ _3396_/C _3338_/A _3338_/B _3338_/C VPWR VGND sg13cmos5l_nand3_1
XFILLER_22_1021 VPWR VGND sg13cmos5l_decap_8
X_3269_ _4172_/D _3252_/B _3262_/X _3268_/Y VPWR VGND sg13cmos5l_a21oi_1
XFILLER_27_867 VPWR VGND sg13cmos5l_decap_4
XFILLER_14_506 VPWR VGND sg13cmos5l_decap_8
XFILLER_14_539 VPWR VGND sg13cmos5l_decap_4
XFILLER_41_336 VPWR VGND sg13cmos5l_fill_2
XFILLER_41_325 VPWR VGND sg13cmos5l_decap_8
XFILLER_41_369 VPWR VGND sg13cmos5l_decap_8
XFILLER_5_226 VPWR VGND sg13cmos5l_fill_1
XFILLER_2_933 VPWR VGND sg13cmos5l_decap_8
Xhold790 hold790/X _4036_/Q VPWR VGND sg13cmos5l_dlygate4sd3_1
XFILLER_49_447 VPWR VGND sg13cmos5l_decap_8
XFILLER_39_73 VPWR VGND sg13cmos5l_fill_1
XFILLER_1_487 VPWR VGND sg13cmos5l_fill_2
XFILLER_36_108 VPWR VGND sg13cmos5l_fill_2
XFILLER_17_311 VPWR VGND sg13cmos5l_fill_1
XFILLER_29_171 VPWR VGND sg13cmos5l_fill_2
XFILLER_44_130 VPWR VGND sg13cmos5l_fill_2
XFILLER_41_870 VPWR VGND sg13cmos5l_fill_1
XFILLER_9_587 VPWR VGND sg13cmos5l_decap_8
X_2640_ _2640_/Y _2673_/A _3890_/Q _2639_/Y VPWR VGND sg13cmos5l_a21oi_1
X_2571_ _2676_/A _2665_/A1 _4040_/Q VPWR VGND sg13cmos5l_nand2b_1
XFILLER_4_270 VPWR VGND sg13cmos5l_decap_8
X_4241_ _4241_/Q _4265_/CLK _4241_/D _4241_/RESET_B VPWR VGND sg13cmos5l_dfrbpq_1
X_4172_ _4172_/Q _4173_/CLK _4172_/D _4172_/RESET_B VPWR VGND sg13cmos5l_dfrbpq_1
X_3123_ _4144_/D _3215_/B _3218_/A VPWR VGND sg13cmos5l_nor2_1
X_3054_ _3054_/Y _4130_/Q _4103_/Q VPWR VGND sg13cmos5l_nand2_1
XFILLER_36_664 VPWR VGND sg13cmos5l_decap_8
XFILLER_35_163 VPWR VGND sg13cmos5l_decap_8
X_3956_ _3956_/Q clkload5/A _3956_/D _3956_/RESET_B VPWR VGND sg13cmos5l_dfrbpq_1
X_2907_ _2917_/A _2909_/A _2906_/X _2900_/Y VPWR VGND sg13cmos5l_o21ai_1
XFILLER_32_881 VPWR VGND sg13cmos5l_decap_8
X_3887_ _3887_/Q clkload3/A _3887_/D _3887_/RESET_B VPWR VGND sg13cmos5l_dfrbpq_1
X_2838_ _2838_/X _2835_/A _2835_/B _2837_/Y VPWR VGND sg13cmos5l_a21o_1
X_2769_ _2770_/B _2773_/A _2773_/B _2766_/Y _2773_/C VPWR VGND sg13cmos5l_a22oi_1
XFILLER_27_631 VPWR VGND sg13cmos5l_fill_1
XFILLER_27_653 VPWR VGND sg13cmos5l_decap_8
XFILLER_26_152 VPWR VGND sg13cmos5l_fill_2
XFILLER_42_623 VPWR VGND sg13cmos5l_fill_2
XFILLER_15_848 VPWR VGND sg13cmos5l_fill_1
XFILLER_23_870 VPWR VGND sg13cmos5l_fill_1
XFILLER_30_818 VPWR VGND sg13cmos5l_decap_8
X_4088__572 _4088_/RESET_B VPWR VGND sg13cmos5l_tiehi
XFILLER_10_531 VPWR VGND sg13cmos5l_fill_2
XFILLER_10_586 VPWR VGND sg13cmos5l_decap_4
XFILLER_41_85 VPWR VGND sg13cmos5l_decap_8
XFILLER_2_730 VPWR VGND sg13cmos5l_decap_8
XFILLER_49_244 VPWR VGND sg13cmos5l_decap_8
XFILLER_38_907 VPWR VGND sg13cmos5l_decap_8
XFILLER_2_46 VPWR VGND sg13cmos5l_fill_2
X_4095__554 _4095_/RESET_B VPWR VGND sg13cmos5l_tiehi
XFILLER_49_299 VPWR VGND sg13cmos5l_fill_1
XFILLER_46_940 VPWR VGND sg13cmos5l_decap_8
XFILLER_18_631 VPWR VGND sg13cmos5l_decap_4
X_3810_ _3810_/Y _3740_/Y _3814_/S _3711_/B VPWR VGND sg13cmos5l_o21ai_1
XFILLER_32_144 VPWR VGND sg13cmos5l_decap_4
X_3741_ _3748_/B _4212_/Q _4213_/Q VPWR VGND sg13cmos5l_nor2_1
XFILLER_14_892 VPWR VGND sg13cmos5l_fill_2
X_3672_ _3686_/B _4265_/Q _3671_/Y _3670_/Y VPWR VGND sg13cmos5l_o21ai_1
X_2623_ _2623_/Y _2657_/S _3939_/Q VPWR VGND sg13cmos5l_nand2b_1
X_2554_ _2554_/Y _2552_/A _3938_/Q VPWR VGND sg13cmos5l_nand2b_1
X_2485_ _2485_/Y _2488_/A2 hold720/X _2487_/B1 VPWR VGND sg13cmos5l_o21ai_1
X_4224_ _4224_/Q _4227_/CLK _4224_/D _4224_/RESET_B VPWR VGND sg13cmos5l_dfrbpq_1
X_4155_ _4155_/Q _4205_/CLK _4155_/D _4155_/RESET_B VPWR VGND sg13cmos5l_dfrbpq_1
XFILLER_29_907 VPWR VGND sg13cmos5l_decap_8
X_3106_ _3106_/Y _4144_/Q _4143_/Q _4170_/Q VPWR VGND sg13cmos5l_nand3b_1
X_4086_ _4086_/Q _4137_/CLK _4086_/D _4086_/RESET_B VPWR VGND sg13cmos5l_dfrbpq_1
XFILLER_37_973 VPWR VGND sg13cmos5l_decap_8
X_3037_ _3037_/Y _2180_/A _3040_/A2 _3041_/A VPWR VGND sg13cmos5l_o21ai_1
XFILLER_23_111 VPWR VGND sg13cmos5l_decap_8
XFILLER_24_667 VPWR VGND sg13cmos5l_fill_1
X_3939_ _3939_/Q clkload2/A _3939_/D _3939_/RESET_B VPWR VGND sg13cmos5l_dfrbpq_1
XFILLER_20_895 VPWR VGND sg13cmos5l_decap_8
X_4066__177 _4066_/D VPWR VGND sg13cmos5l_tielo
XFILLER_46_258 VPWR VGND sg13cmos5l_fill_2
XFILLER_28_951 VPWR VGND sg13cmos5l_fill_1
XFILLER_46_269 VPWR VGND sg13cmos5l_decap_8
XFILLER_27_461 VPWR VGND sg13cmos5l_fill_2
XFILLER_43_954 VPWR VGND sg13cmos5l_decap_8
XFILLER_42_420 VPWR VGND sg13cmos5l_fill_1
XFILLER_7_800 VPWR VGND sg13cmos5l_decap_8
XFILLER_30_659 VPWR VGND sg13cmos5l_decap_4
XFILLER_11_862 VPWR VGND sg13cmos5l_fill_1
X_4127__517 _4127_/RESET_B VPWR VGND sg13cmos5l_tiehi
XFILLER_6_365 VPWR VGND sg13cmos5l_decap_4
X_2270_ _4277_/D _2282_/B VPWR VGND sg13cmos5l_inv_1
XFILLER_42_1024 VPWR VGND sg13cmos5l_decap_4
XFILLER_38_737 VPWR VGND sg13cmos5l_fill_1
XFILLER_37_247 VPWR VGND sg13cmos5l_fill_2
XFILLER_37_269 VPWR VGND sg13cmos5l_decap_4
XFILLER_19_984 VPWR VGND sg13cmos5l_decap_8
XFILLER_33_431 VPWR VGND sg13cmos5l_decap_8
XFILLER_34_976 VPWR VGND sg13cmos5l_decap_8
XFILLER_9_170 VPWR VGND sg13cmos5l_fill_1
X_3724_ _3794_/A _3793_/A _3793_/B _3793_/C VPWR VGND sg13cmos5l_a21oi_1
X_3889__250 _3889_/RESET_B VPWR VGND sg13cmos5l_tiehi
X_3655_ _3655_/Y _3619_/X _3658_/B VPWR VGND sg13cmos5l_nand2b_1
X_2606_ _2612_/B _2676_/A _2606_/B _2606_/C VPWR VGND sg13cmos5l_nor3_1
X_3586_ _3587_/B _3591_/A _3591_/B _3571_/Y VPWR VGND sg13cmos5l_a21oi_1
X_2537_ _2737_/A _2537_/A _4046_/Q VPWR VGND sg13cmos5l_nor2b_1
XFILLER_0_508 VPWR VGND sg13cmos5l_decap_8
X_2468_ _2468_/Y _2278_/C _2461_/B _2464_/B _2467_/Y VPWR VGND sg13cmos5l_a22oi_1
X_4207_ _4207_/Q _4237_/CLK _4207_/D _4207_/RESET_B VPWR VGND sg13cmos5l_dfrbpq_1
X_4078__582 _4078_/RESET_B VPWR VGND sg13cmos5l_tiehi
X_2399_ _3993_/D _2419_/A0 hold754/X _2401_/S VPWR VGND sg13cmos5l_mux2_1
XFILLER_29_715 VPWR VGND sg13cmos5l_decap_8
XFILLER_29_737 VPWR VGND sg13cmos5l_decap_8
X_4138_ _4138_/Q _4168_/CLK _4138_/D _4138_/RESET_B VPWR VGND sg13cmos5l_dfrbpq_1
XFILLER_28_247 VPWR VGND sg13cmos5l_fill_1
XFILLER_44_718 VPWR VGND sg13cmos5l_decap_8
X_4069_ _4069_/Q _4136_/CLK _4069_/D _4069_/RESET_B VPWR VGND sg13cmos5l_dfrbpq_1
XFILLER_28_269 VPWR VGND sg13cmos5l_decap_8
XFILLER_25_921 VPWR VGND sg13cmos5l_decap_4
XFILLER_19_1026 VPWR VGND sg13cmos5l_fill_2
XFILLER_24_453 VPWR VGND sg13cmos5l_decap_4
XFILLER_25_987 VPWR VGND sg13cmos5l_decap_8
XFILLER_11_103 VPWR VGND sg13cmos5l_decap_4
XFILLER_24_464 VPWR VGND sg13cmos5l_decap_4
XFILLER_40_968 VPWR VGND sg13cmos5l_decap_8
XFILLER_22_43 VPWR VGND sg13cmos5l_fill_2
X_4085__575 _4085_/RESET_B VPWR VGND sg13cmos5l_tiehi
XFILLER_4_825 VPWR VGND sg13cmos5l_fill_1
XFILLER_3_346 VPWR VGND sg13cmos5l_fill_2
XFILLER_26_1008 VPWR VGND sg13cmos5l_decap_8
X_4276__561 _4276_/RESET_B VPWR VGND sg13cmos5l_tiehi
X_4092__568 _4092_/RESET_B VPWR VGND sg13cmos5l_tiehi
XFILLER_47_567 VPWR VGND sg13cmos5l_decap_4
XFILLER_47_84 VPWR VGND sg13cmos5l_fill_2
X_4051__210 _4051_/RESET_B VPWR VGND sg13cmos5l_tiehi
XFILLER_28_781 VPWR VGND sg13cmos5l_decap_8
XFILLER_42_250 VPWR VGND sg13cmos5l_decap_8
XFILLER_15_464 VPWR VGND sg13cmos5l_decap_8
XFILLER_30_412 VPWR VGND sg13cmos5l_fill_1
XFILLER_8_67 VPWR VGND sg13cmos5l_fill_2
Xhold608 _2768_/B _4055_/Q VPWR VGND sg13cmos5l_dlygate4sd3_1
X_3440_ _3440_/Y _3439_/Y _3440_/B VPWR VGND sg13cmos5l_nand2b_1
Xhold619 _4191_/D _3382_/Y VPWR VGND sg13cmos5l_dlygate4sd3_1
X_3371_ _3372_/S _3370_/Y _3371_/B VPWR VGND sg13cmos5l_nand2b_1
X_2322_ _2332_/B _2322_/A _3846_/B _3855_/C VPWR VGND sg13cmos5l_nor3_1
X_2253_ _2253_/Y _3927_/Q _2552_/A VPWR VGND sg13cmos5l_nand2b_1
XFILLER_38_556 VPWR VGND sg13cmos5l_fill_2
X_2184_ _2184_/Y _2184_/A VPWR VGND sg13cmos5l_inv_1
XFILLER_26_729 VPWR VGND sg13cmos5l_fill_1
XFILLER_25_228 VPWR VGND sg13cmos5l_fill_1
XFILLER_18_280 VPWR VGND sg13cmos5l_decap_8
XFILLER_18_291 VPWR VGND sg13cmos5l_fill_1
XFILLER_21_412 VPWR VGND sg13cmos5l_fill_1
XFILLER_33_261 VPWR VGND sg13cmos5l_fill_1
XFILLER_21_434 VPWR VGND sg13cmos5l_decap_8
XFILLER_22_957 VPWR VGND sg13cmos5l_fill_2
XFILLER_21_489 VPWR VGND sg13cmos5l_decap_8
XFILLER_30_990 VPWR VGND sg13cmos5l_decap_8
X_3707_ _3707_/Y _4253_/Q _3708_/A2 _3389_/A VPWR VGND sg13cmos5l_o21ai_1
X_3638_ _3645_/A _4264_/Q _3638_/B VPWR VGND sg13cmos5l_xnor2_1
X_3569_ _3569_/Y _3569_/A _3596_/S VPWR VGND sg13cmos5l_nand2_1
XFILLER_1_806 VPWR VGND sg13cmos5l_decap_8
X_4117__527 _4117_/RESET_B VPWR VGND sg13cmos5l_tiehi
XFILLER_17_21 VPWR VGND sg13cmos5l_decap_8
XFILLER_17_32 VPWR VGND sg13cmos5l_fill_2
XFILLER_44_526 VPWR VGND sg13cmos5l_decap_4
XFILLER_17_87 VPWR VGND sg13cmos5l_decap_4
XFILLER_25_773 VPWR VGND sg13cmos5l_decap_8
XFILLER_25_795 VPWR VGND sg13cmos5l_decap_4
XFILLER_40_732 VPWR VGND sg13cmos5l_decap_8
XFILLER_8_416 VPWR VGND sg13cmos5l_decap_8
XFILLER_32_1001 VPWR VGND sg13cmos5l_decap_8
XFILLER_40_798 VPWR VGND sg13cmos5l_decap_4
XFILLER_4_622 VPWR VGND sg13cmos5l_decap_8
XFILLER_3_176 VPWR VGND sg13cmos5l_decap_4
XFILLER_3_198 VPWR VGND sg13cmos5l_decap_4
XFILLER_0_872 VPWR VGND sg13cmos5l_decap_8
XFILLER_48_832 VPWR VGND sg13cmos5l_decap_8
XFILLER_35_548 VPWR VGND sg13cmos5l_decap_8
XFILLER_31_721 VPWR VGND sg13cmos5l_fill_2
X_2940_ _2940_/Y _2952_/B VPWR VGND sg13cmos5l_inv_1
XFILLER_43_581 VPWR VGND sg13cmos5l_decap_8
X_2871_ _2871_/Y _2861_/Y hold906/X _2792_/Y VPWR VGND sg13cmos5l_a21oi_1
XFILLER_31_754 VPWR VGND sg13cmos5l_decap_8
XFILLER_8_983 VPWR VGND sg13cmos5l_decap_8
XFILLER_7_493 VPWR VGND sg13cmos5l_decap_4
X_3423_ _3424_/B _3423_/A _3433_/B VPWR VGND sg13cmos5l_nor2_1
X_4062__180 _4062_/D VPWR VGND sg13cmos5l_tielo
X_3354_ _3355_/C _4206_/Q _3201_/A _3353_/B VPWR VGND sg13cmos5l_o21ai_1
XFILLER_39_821 VPWR VGND sg13cmos5l_decap_8
X_3285_ _3292_/A _3291_/B _3285_/B VPWR VGND sg13cmos5l_nand2b_1
X_2305_ _3912_/D hold740/X _3866_/A0 _2311_/S VPWR VGND sg13cmos5l_mux2_1
XFILLER_39_832 VPWR VGND sg13cmos5l_fill_1
X_2236_ _3530_/B _2236_/A VPWR VGND sg13cmos5l_inv_1
X_2167_ _2167_/Y _2167_/A VPWR VGND sg13cmos5l_inv_1
X_4075__585 _4075_/RESET_B VPWR VGND sg13cmos5l_tiehi
XFILLER_0_90 VPWR VGND sg13cmos5l_fill_2
XFILLER_13_209 VPWR VGND sg13cmos5l_fill_1
XFILLER_21_242 VPWR VGND sg13cmos5l_fill_2
XFILLER_10_938 VPWR VGND sg13cmos5l_fill_1
X_4082__578 _4082_/RESET_B VPWR VGND sg13cmos5l_tiehi
Xhold972 _3468_/B _4207_/Q VPWR VGND sg13cmos5l_dlygate4sd3_1
XFILLER_0_102 VPWR VGND sg13cmos5l_decap_8
Xhold950 _3246_/A _4165_/Q VPWR VGND sg13cmos5l_dlygate4sd3_1
Xhold961 _2778_/A _4079_/Q VPWR VGND sg13cmos5l_dlygate4sd3_1
XFILLER_1_658 VPWR VGND sg13cmos5l_decap_4
Xhold994 _3337_/B _3336_/Y VPWR VGND sg13cmos5l_dlygate4sd3_1
Xhold983 _3433_/A _4200_/Q VPWR VGND sg13cmos5l_dlygate4sd3_1
XFILLER_0_179 VPWR VGND sg13cmos5l_decap_8
XFILLER_29_320 VPWR VGND sg13cmos5l_fill_1
XFILLER_28_64 VPWR VGND sg13cmos5l_fill_2
XFILLER_29_331 VPWR VGND sg13cmos5l_decap_4
XFILLER_45_824 VPWR VGND sg13cmos5l_decap_8
XFILLER_44_301 VPWR VGND sg13cmos5l_decap_4
XFILLER_29_397 VPWR VGND sg13cmos5l_fill_1
XFILLER_8_202 VPWR VGND sg13cmos5l_decap_8
XFILLER_9_747 VPWR VGND sg13cmos5l_decap_4
XFILLER_12_286 VPWR VGND sg13cmos5l_fill_1
XFILLER_5_953 VPWR VGND sg13cmos5l_decap_8
XFILLER_4_452 VPWR VGND sg13cmos5l_decap_8
X_3070_ _3070_/Y _3069_/Y _3078_/A VPWR VGND sg13cmos5l_nand2b_1
X_4092__173 _4092_/D VPWR VGND sg13cmos5l_tielo
XFILLER_39_1007 VPWR VGND sg13cmos5l_decap_8
XFILLER_44_890 VPWR VGND sg13cmos5l_decap_8
X_3972_ _3972_/Q _4011_/CLK _3972_/D _3972_/RESET_B VPWR VGND sg13cmos5l_dfrbpq_1
X_2923_ _2924_/A _2893_/Y _2921_/Y _2884_/B VPWR VGND sg13cmos5l_o21ai_1
X_2854_ _2854_/Y _3047_/A _4070_/Q _2852_/Y VPWR VGND sg13cmos5l_o21ai_1
X_2785_ _2786_/B _2776_/Y _2788_/A _2761_/B VPWR VGND sg13cmos5l_o21ai_1
X_4107__537 _4107_/RESET_B VPWR VGND sg13cmos5l_tiehi
X_3406_ _3406_/Y _4192_/Q _4163_/Q VPWR VGND sg13cmos5l_xnor2_1
X_3337_ _4180_/D _3394_/B _3337_/B VPWR VGND sg13cmos5l_nor2_1
XFILLER_22_1000 VPWR VGND sg13cmos5l_decap_8
XFILLER_27_802 VPWR VGND sg13cmos5l_decap_8
X_3268_ _3268_/Y _3252_/A _3262_/X _3217_/B VPWR VGND sg13cmos5l_o21ai_1
XFILLER_45_109 VPWR VGND sg13cmos5l_fill_2
XFILLER_39_673 VPWR VGND sg13cmos5l_decap_4
X_3199_ _3199_/Y hold901/X _3197_/S _3217_/B VPWR VGND sg13cmos5l_o21ai_1
X_2219_ _3391_/A _2219_/A VPWR VGND sg13cmos5l_inv_1
XFILLER_22_573 VPWR VGND sg13cmos5l_fill_1
XFILLER_5_216 VPWR VGND sg13cmos5l_fill_1
XFILLER_2_912 VPWR VGND sg13cmos5l_decap_8
Xhold791 _2447_/B _2446_/Y VPWR VGND sg13cmos5l_dlygate4sd3_1
Xhold780 hold780/X _3961_/Q VPWR VGND sg13cmos5l_dlygate4sd3_1
XFILLER_2_989 VPWR VGND sg13cmos5l_decap_8
XFILLER_49_426 VPWR VGND sg13cmos5l_decap_8
XFILLER_39_52 VPWR VGND sg13cmos5l_fill_2
XFILLER_18_824 VPWR VGND sg13cmos5l_decap_8
XFILLER_18_835 VPWR VGND sg13cmos5l_fill_2
XFILLER_45_654 VPWR VGND sg13cmos5l_decap_8
XFILLER_17_345 VPWR VGND sg13cmos5l_fill_1
XFILLER_33_805 VPWR VGND sg13cmos5l_decap_8
XFILLER_44_175 VPWR VGND sg13cmos5l_decap_8
XFILLER_9_500 VPWR VGND sg13cmos5l_fill_2
XFILLER_13_551 VPWR VGND sg13cmos5l_decap_8
XFILLER_32_359 VPWR VGND sg13cmos5l_fill_1
XFILLER_41_882 VPWR VGND sg13cmos5l_decap_4
X_4048__215 _4048_/RESET_B VPWR VGND sg13cmos5l_tiehi
XFILLER_13_584 VPWR VGND sg13cmos5l_fill_1
XFILLER_40_392 VPWR VGND sg13cmos5l_decap_8
X_2570_ _2572_/B _2566_/Y _2567_/Y _2569_/Y _2641_/B2 _2646_/A VPWR VGND sg13cmos5l_a221oi_1
XFILLER_5_794 VPWR VGND sg13cmos5l_fill_1
X_4240_ _4240_/Q _4265_/CLK _4240_/D _4240_/RESET_B VPWR VGND sg13cmos5l_dfrbpq_1
X_4171_ _4171_/Q _4173_/CLK _4171_/D _4171_/RESET_B VPWR VGND sg13cmos5l_dfrbpq_1
X_3122_ _3218_/A _3104_/X _3121_/Y _3122_/S VPWR VGND sg13cmos5l_mux2_1
XFILLER_49_982 VPWR VGND sg13cmos5l_decap_8
X_3053_ _3053_/X _3049_/A _2993_/B _3071_/B VPWR VGND sg13cmos5l_mux2_1
XFILLER_48_492 VPWR VGND sg13cmos5l_fill_1
X_3955_ _3955_/Q _4011_/CLK _3955_/D _3955_/RESET_B VPWR VGND sg13cmos5l_dfrbpq_1
XFILLER_32_860 VPWR VGND sg13cmos5l_fill_1
X_2906_ _2906_/X _4106_/Q _2916_/B _2905_/Y VPWR VGND sg13cmos5l_a21o_1
X_3886_ _3886_/Q _4280_/CLK _3886_/D _3886_/RESET_B VPWR VGND sg13cmos5l_dfrbpq_1
X_2837_ _2837_/Y _2837_/A _2845_/B VPWR VGND sg13cmos5l_nor2_1
X_2768_ _2773_/C _2768_/A _2768_/B _4079_/Q VPWR VGND sg13cmos5l_nand3_1
XFILLER_2_208 VPWR VGND sg13cmos5l_fill_1
X_2699_ _2761_/B _4272_/D _2872_/B VPWR VGND sg13cmos5l_nor2_1
XFILLER_39_481 VPWR VGND sg13cmos5l_decap_8
XFILLER_15_827 VPWR VGND sg13cmos5l_fill_2
XFILLER_27_676 VPWR VGND sg13cmos5l_decap_8
XFILLER_14_348 VPWR VGND sg13cmos5l_fill_1
XFILLER_41_189 VPWR VGND sg13cmos5l_decap_8
XFILLER_41_167 VPWR VGND sg13cmos5l_decap_4
XFILLER_23_882 VPWR VGND sg13cmos5l_decap_8
XFILLER_6_547 VPWR VGND sg13cmos5l_decap_8
XFILLER_29_1028 VPWR VGND sg13cmos5l_fill_1
XFILLER_2_786 VPWR VGND sg13cmos5l_decap_8
XFILLER_2_58 VPWR VGND sg13cmos5l_decap_8
XFILLER_46_996 VPWR VGND sg13cmos5l_decap_8
XFILLER_45_495 VPWR VGND sg13cmos5l_decap_8
XFILLER_17_175 VPWR VGND sg13cmos5l_fill_1
XFILLER_32_112 VPWR VGND sg13cmos5l_decap_8
XFILLER_32_134 VPWR VGND sg13cmos5l_fill_1
XFILLER_33_679 VPWR VGND sg13cmos5l_fill_2
X_3740_ _3740_/Y _3794_/B _3740_/B VPWR VGND sg13cmos5l_nor2_1
XFILLER_14_871 VPWR VGND sg13cmos5l_decap_8
X_3671_ _3671_/Y _4221_/Q _4264_/Q VPWR VGND sg13cmos5l_nor2_1
X_4245__260 _4245_/RESET_B VPWR VGND sg13cmos5l_tiehi
XFILLER_12_1021 VPWR VGND sg13cmos5l_decap_8
X_2622_ _2622_/Y _2675_/C1 _2621_/X _2620_/Y VPWR VGND sg13cmos5l_a21oi_1
X_2553_ _2553_/Y _2552_/A _3887_/Q _2552_/Y VPWR VGND sg13cmos5l_a21oi_1
X_2484_ _2484_/Y _2167_/Y _2194_/A _2483_/Y VPWR VGND sg13cmos5l_a21oi_1
X_4223_ _4223_/Q _4277_/CLK _4223_/D _4223_/RESET_B VPWR VGND sg13cmos5l_dfrbpq_1
X_4154_ _4154_/Q _4227_/CLK _4154_/D _4154_/RESET_B VPWR VGND sg13cmos5l_dfrbpq_1
X_4085_ _4085_/Q _4137_/CLK _4085_/D _4085_/RESET_B VPWR VGND sg13cmos5l_dfrbpq_1
X_3105_ _3105_/Y _4170_/Q _4143_/Q VPWR VGND sg13cmos5l_nand2_1
XFILLER_37_952 VPWR VGND sg13cmos5l_decap_8
X_3036_ _3036_/Y _2184_/Y _3710_/A2 _3035_/Y VPWR VGND sg13cmos5l_a21oi_1
XFILLER_11_318 VPWR VGND sg13cmos5l_decap_4
XFILLER_23_178 VPWR VGND sg13cmos5l_decap_8
XFILLER_23_189 VPWR VGND sg13cmos5l_fill_1
X_3938_ _3938_/Q _4278_/CLK _3938_/D _3938_/RESET_B VPWR VGND sg13cmos5l_dfrbpq_1
X_3869_ _3869_/Y input9/X _3873_/S VPWR VGND sg13cmos5l_nor2_1
XFILLER_11_45 VPWR VGND sg13cmos5l_decap_8
XFILLER_11_56 VPWR VGND sg13cmos5l_fill_1
XFILLER_11_89 VPWR VGND sg13cmos5l_decap_8
XFILLER_47_716 VPWR VGND sg13cmos5l_fill_2
XFILLER_4_1008 VPWR VGND sg13cmos5l_decap_8
XFILLER_19_418 VPWR VGND sg13cmos5l_fill_1
XFILLER_47_749 VPWR VGND sg13cmos5l_decap_8
XFILLER_43_933 VPWR VGND sg13cmos5l_decap_8
XFILLER_14_112 VPWR VGND sg13cmos5l_decap_8
XFILLER_27_484 VPWR VGND sg13cmos5l_decap_8
XFILLER_36_97 VPWR VGND sg13cmos5l_fill_2
XFILLER_10_362 VPWR VGND sg13cmos5l_decap_4
XFILLER_42_1003 VPWR VGND sg13cmos5l_decap_8
XFILLER_28_6 VPWR VGND sg13cmos5l_fill_1
XFILLER_46_793 VPWR VGND sg13cmos5l_decap_8
XFILLER_34_955 VPWR VGND sg13cmos5l_decap_8
XFILLER_21_605 VPWR VGND sg13cmos5l_decap_4
XFILLER_20_137 VPWR VGND sg13cmos5l_decap_8
XFILLER_9_160 VPWR VGND sg13cmos5l_fill_2
X_3723_ _3793_/C _4257_/Q _3733_/B VPWR VGND sg13cmos5l_xnor2_1
X_3654_ _4240_/D _3815_/A _3779_/A VPWR VGND sg13cmos5l_nor2_1
X_2605_ _2606_/C _2601_/Y _2602_/Y _2604_/Y _2675_/B2 _2662_/A VPWR VGND sg13cmos5l_a221oi_1
X_3585_ _3595_/B _3583_/X _3584_/X _3576_/Y VPWR VGND sg13cmos5l_o21ai_1
X_2536_ _4044_/D _2698_/A _2536_/B VPWR VGND sg13cmos5l_nor2_1
X_2467_ _2467_/Y _4024_/Q _2461_/B _2451_/Y VPWR VGND sg13cmos5l_a21oi_1
X_4206_ _4206_/Q _4231_/CLK _4206_/D _4206_/RESET_B VPWR VGND sg13cmos5l_dfrbpq_1
X_2398_ _3992_/D _2418_/A0 hold714/X _2401_/S VPWR VGND sg13cmos5l_mux2_1
X_4137_ _4137_/Q _4137_/CLK _4137_/D _4137_/RESET_B VPWR VGND sg13cmos5l_dfrbpq_1
X_4068_ _4068_/Q _4137_/CLK _4068_/D _4068_/RESET_B VPWR VGND sg13cmos5l_dfrbpq_1
XFILLER_43_207 VPWR VGND sg13cmos5l_fill_1
XFILLER_43_229 VPWR VGND sg13cmos5l_decap_8
XFILLER_24_410 VPWR VGND sg13cmos5l_decap_4
X_3019_ _3019_/Y hold897/X _3015_/Y _3018_/Y _2245_/A VPWR VGND sg13cmos5l_a22oi_1
XFILLER_19_1005 VPWR VGND sg13cmos5l_decap_8
XFILLER_36_281 VPWR VGND sg13cmos5l_decap_8
XFILLER_40_947 VPWR VGND sg13cmos5l_decap_8
XFILLER_11_137 VPWR VGND sg13cmos5l_decap_8
XFILLER_7_108 VPWR VGND sg13cmos5l_fill_1
XFILLER_4_848 VPWR VGND sg13cmos5l_fill_2
XFILLER_4_837 VPWR VGND sg13cmos5l_decap_8
XFILLER_47_502 VPWR VGND sg13cmos5l_fill_1
XFILLER_47_546 VPWR VGND sg13cmos5l_fill_2
XFILLER_19_226 VPWR VGND sg13cmos5l_decap_8
XFILLER_34_207 VPWR VGND sg13cmos5l_fill_2
XFILLER_15_432 VPWR VGND sg13cmos5l_fill_1
XFILLER_27_281 VPWR VGND sg13cmos5l_decap_8
XFILLER_16_999 VPWR VGND sg13cmos5l_decap_8
XFILLER_31_936 VPWR VGND sg13cmos5l_fill_2
XFILLER_42_295 VPWR VGND sg13cmos5l_fill_1
XFILLER_42_284 VPWR VGND sg13cmos5l_decap_8
XFILLER_15_498 VPWR VGND sg13cmos5l_fill_2
X_3886__402 _3886_/RESET_B VPWR VGND sg13cmos5l_tiehi
XFILLER_7_631 VPWR VGND sg13cmos5l_decap_4
XFILLER_7_675 VPWR VGND sg13cmos5l_decap_8
Xhold609 _3212_/B _4133_/Q VPWR VGND sg13cmos5l_dlygate4sd3_1
X_3370_ _3370_/Y _3378_/B _3367_/Y _3378_/A VPWR VGND sg13cmos5l_o21ai_1
XFILLER_3_881 VPWR VGND sg13cmos5l_decap_8
X_2321_ _3927_/D input5/X hold656/X _2321_/S VPWR VGND sg13cmos5l_mux2_1
X_2252_ _4280_/D _2252_/A VPWR VGND sg13cmos5l_inv_1
XFILLER_38_535 VPWR VGND sg13cmos5l_decap_8
X_2183_ _2183_/Y _2183_/A VPWR VGND sg13cmos5l_inv_1
XFILLER_19_771 VPWR VGND sg13cmos5l_fill_2
X_3706_ _3706_/Y _2163_/Y _3706_/A2 _3705_/Y VPWR VGND sg13cmos5l_a21oi_1
X_3637_ _3643_/B _4264_/Q _3638_/B VPWR VGND sg13cmos5l_nor2b_1
X_3568_ _3596_/S _3565_/X _3566_/Y _3567_/Y VPWR VGND sg13cmos5l_a21o_1
XFILLER_0_328 VPWR VGND sg13cmos5l_decap_8
XFILLER_0_306 VPWR VGND sg13cmos5l_decap_8
X_2519_ _2522_/A _2519_/A _2519_/B VPWR VGND sg13cmos5l_nand2_1
X_3499_ _3499_/Y _3496_/Y _3497_/Y _3498_/Y _4203_/Q VPWR VGND sg13cmos5l_a22oi_1
XFILLER_0_339 VPWR VGND sg13cmos5l_fill_2
XFILLER_44_505 VPWR VGND sg13cmos5l_fill_2
XFILLER_17_708 VPWR VGND sg13cmos5l_decap_8
XFILLER_29_557 VPWR VGND sg13cmos5l_decap_4
XFILLER_44_549 VPWR VGND sg13cmos5l_decap_4
XFILLER_37_590 VPWR VGND sg13cmos5l_fill_1
XFILLER_25_752 VPWR VGND sg13cmos5l_decap_8
XFILLER_40_711 VPWR VGND sg13cmos5l_decap_8
XFILLER_12_402 VPWR VGND sg13cmos5l_fill_2
XFILLER_24_262 VPWR VGND sg13cmos5l_decap_8
XFILLER_40_755 VPWR VGND sg13cmos5l_decap_8
XFILLER_9_918 VPWR VGND sg13cmos5l_fill_1
XFILLER_33_21 VPWR VGND sg13cmos5l_fill_2
XFILLER_33_32 VPWR VGND sg13cmos5l_decap_4
XFILLER_40_777 VPWR VGND sg13cmos5l_decap_8
XFILLER_40_766 VPWR VGND sg13cmos5l_fill_2
XFILLER_12_479 VPWR VGND sg13cmos5l_decap_8
XFILLER_33_65 VPWR VGND sg13cmos5l_decap_8
XFILLER_21_980 VPWR VGND sg13cmos5l_decap_8
XFILLER_4_601 VPWR VGND sg13cmos5l_decap_8
XFILLER_3_122 VPWR VGND sg13cmos5l_fill_2
XFILLER_48_811 VPWR VGND sg13cmos5l_decap_8
XFILLER_0_851 VPWR VGND sg13cmos5l_decap_8
XFILLER_48_888 VPWR VGND sg13cmos5l_decap_8
XFILLER_47_376 VPWR VGND sg13cmos5l_decap_8
XFILLER_43_560 VPWR VGND sg13cmos5l_decap_8
XFILLER_15_262 VPWR VGND sg13cmos5l_fill_1
XFILLER_16_763 VPWR VGND sg13cmos5l_decap_8
XFILLER_16_774 VPWR VGND sg13cmos5l_fill_1
XFILLER_31_733 VPWR VGND sg13cmos5l_decap_8
X_2870_ _2870_/Y _4096_/Q _2870_/B VPWR VGND sg13cmos5l_nand2b_1
XFILLER_8_962 VPWR VGND sg13cmos5l_decap_8
Xclkbuf_leaf_10_clk clkload9/A clkload0/A VPWR VGND sg13cmos5l_buf_8
X_3422_ _3422_/Y _3430_/B VPWR VGND sg13cmos5l_inv_1
X_3353_ _3353_/Y _4155_/Q _3353_/B VPWR VGND sg13cmos5l_nand2_1
X_2304_ _3911_/D hold799/X _3865_/A0 _2311_/S VPWR VGND sg13cmos5l_mux2_1
X_3284_ _3285_/B _3558_/A _4204_/Q _4205_/Q VPWR VGND sg13cmos5l_o21ai_1
X_2235_ _3526_/B _4186_/Q VPWR VGND sg13cmos5l_inv_1
XFILLER_39_877 VPWR VGND sg13cmos5l_decap_8
X_2166_ _3690_/A _2166_/A VPWR VGND sg13cmos5l_inv_1
XFILLER_38_398 VPWR VGND sg13cmos5l_decap_4
XFILLER_26_516 VPWR VGND sg13cmos5l_fill_2
XFILLER_41_508 VPWR VGND sg13cmos5l_decap_8
XFILLER_22_711 VPWR VGND sg13cmos5l_decap_8
X_2999_ _2999_/Y _2972_/A _2984_/C _2820_/Y VPWR VGND sg13cmos5l_o21ai_1
XFILLER_21_265 VPWR VGND sg13cmos5l_fill_2
XFILLER_21_276 VPWR VGND sg13cmos5l_fill_2
XFILLER_5_409 VPWR VGND sg13cmos5l_fill_2
XFILLER_21_298 VPWR VGND sg13cmos5l_decap_4
Xhold940 hold940/X _4280_/Q VPWR VGND sg13cmos5l_dlygate4sd3_1
X_4123__521 _4123_/RESET_B VPWR VGND sg13cmos5l_tiehi
Xhold973 _3062_/A _4137_/Q VPWR VGND sg13cmos5l_dlygate4sd3_1
X_4221__155 _4221_/D VPWR VGND sg13cmos5l_tielo
Xhold951 _2912_/A _4105_/Q VPWR VGND sg13cmos5l_dlygate4sd3_1
Xhold962 _2787_/A _2779_/Y VPWR VGND sg13cmos5l_dlygate4sd3_1
Xhold995 _3490_/A _4184_/Q VPWR VGND sg13cmos5l_dlygate4sd3_1
XFILLER_0_125 VPWR VGND sg13cmos5l_decap_8
XFILLER_1_637 VPWR VGND sg13cmos5l_decap_4
Xhold984 _3587_/A _4230_/Q VPWR VGND sg13cmos5l_dlygate4sd3_1
XFILLER_49_608 VPWR VGND sg13cmos5l_fill_1
XFILLER_0_169 VPWR VGND sg13cmos5l_fill_1
XFILLER_44_346 VPWR VGND sg13cmos5l_decap_8
XFILLER_44_368 VPWR VGND sg13cmos5l_decap_8
XFILLER_13_700 VPWR VGND sg13cmos5l_decap_8
XFILLER_25_560 VPWR VGND sg13cmos5l_fill_1
XFILLER_13_733 VPWR VGND sg13cmos5l_decap_4
XFILLER_13_744 VPWR VGND sg13cmos5l_fill_1
XFILLER_13_755 VPWR VGND sg13cmos5l_decap_8
XFILLER_13_788 VPWR VGND sg13cmos5l_decap_8
XFILLER_12_298 VPWR VGND sg13cmos5l_decap_8
XFILLER_5_932 VPWR VGND sg13cmos5l_decap_8
XFILLER_4_431 VPWR VGND sg13cmos5l_decap_8
XFILLER_0_681 VPWR VGND sg13cmos5l_decap_4
XFILLER_10_6 VPWR VGND sg13cmos5l_fill_1
XFILLER_47_173 VPWR VGND sg13cmos5l_decap_8
XFILLER_36_825 VPWR VGND sg13cmos5l_decap_8
XFILLER_36_869 VPWR VGND sg13cmos5l_decap_8
X_3971_ _3971_/Q clkload5/A _3971_/D _3971_/RESET_B VPWR VGND sg13cmos5l_dfrbpq_1
X_2922_ _2922_/Y _2917_/A _2917_/B _2921_/Y VPWR VGND sg13cmos5l_o21ai_1
X_2853_ _2853_/Y _3044_/A _4111_/Q VPWR VGND sg13cmos5l_nor2_1
XFILLER_31_585 VPWR VGND sg13cmos5l_decap_4
X_2784_ _2786_/A _2784_/A _2788_/A VPWR VGND sg13cmos5l_nor2b_1
XFILLER_8_770 VPWR VGND sg13cmos5l_decap_8
X_3405_ _3405_/Y _4191_/Q _4162_/Q VPWR VGND sg13cmos5l_xnor2_1
X_3336_ _3336_/Y _3397_/C _3397_/D VPWR VGND sg13cmos5l_nand2_1
XFILLER_39_630 VPWR VGND sg13cmos5l_decap_8
X_3267_ _4171_/D _3253_/B _3262_/X _3266_/Y VPWR VGND sg13cmos5l_a21oi_1
XFILLER_38_173 VPWR VGND sg13cmos5l_decap_8
XFILLER_38_140 VPWR VGND sg13cmos5l_fill_1
X_3198_ _4154_/D _3215_/B _3198_/B VPWR VGND sg13cmos5l_nor2_1
X_2218_ _3392_/A _3181_/A VPWR VGND sg13cmos5l_inv_1
XFILLER_35_891 VPWR VGND sg13cmos5l_decap_8
XFILLER_14_45 VPWR VGND sg13cmos5l_decap_8
XFILLER_6_707 VPWR VGND sg13cmos5l_decap_4
Xhold770 hold770/X _3901_/Q VPWR VGND sg13cmos5l_dlygate4sd3_1
XFILLER_1_423 VPWR VGND sg13cmos5l_fill_2
Xhold781 hold781/X _3956_/Q VPWR VGND sg13cmos5l_dlygate4sd3_1
XFILLER_2_968 VPWR VGND sg13cmos5l_decap_8
XFILLER_1_456 VPWR VGND sg13cmos5l_fill_1
Xhold792 _2768_/A _4074_/Q VPWR VGND sg13cmos5l_dlygate4sd3_1
XFILLER_7_1028 VPWR VGND sg13cmos5l_fill_1
XFILLER_17_302 VPWR VGND sg13cmos5l_decap_4
XFILLER_29_151 VPWR VGND sg13cmos5l_fill_1
XFILLER_17_335 VPWR VGND sg13cmos5l_fill_1
XFILLER_29_184 VPWR VGND sg13cmos5l_decap_8
XFILLER_44_143 VPWR VGND sg13cmos5l_decap_4
XFILLER_44_132 VPWR VGND sg13cmos5l_fill_1
XFILLER_17_357 VPWR VGND sg13cmos5l_fill_2
XFILLER_17_368 VPWR VGND sg13cmos5l_decap_8
XFILLER_32_338 VPWR VGND sg13cmos5l_fill_2
XFILLER_41_861 VPWR VGND sg13cmos5l_decap_8
XFILLER_9_545 VPWR VGND sg13cmos5l_decap_4
XFILLER_5_773 VPWR VGND sg13cmos5l_decap_8
X_4170_ _4170_/Q _4173_/CLK _4170_/D _4170_/RESET_B VPWR VGND sg13cmos5l_dfrbpq_1
X_3121_ _3121_/Y _3391_/A _3124_/B VPWR VGND sg13cmos5l_nand2_1
XFILLER_49_961 VPWR VGND sg13cmos5l_decap_8
X_3052_ _3071_/B _3049_/Y _3050_/Y _3051_/Y VPWR VGND sg13cmos5l_a21oi_1
XFILLER_36_600 VPWR VGND sg13cmos5l_decap_8
XFILLER_48_482 VPWR VGND sg13cmos5l_fill_2
XFILLER_35_110 VPWR VGND sg13cmos5l_decap_8
XFILLER_35_121 VPWR VGND sg13cmos5l_fill_1
XFILLER_36_644 VPWR VGND sg13cmos5l_fill_2
XFILLER_24_828 VPWR VGND sg13cmos5l_decap_8
XFILLER_35_154 VPWR VGND sg13cmos5l_decap_4
X_4113__531 _4113_/RESET_B VPWR VGND sg13cmos5l_tiehi
X_3954_ _3954_/Q _4011_/CLK _3954_/D _3954_/RESET_B VPWR VGND sg13cmos5l_dfrbpq_1
X_2905_ _2905_/Y _4107_/Q _2916_/B VPWR VGND sg13cmos5l_nor2_1
X_3885_ _3885_/Q _4278_/CLK _3885_/D _3885_/RESET_B VPWR VGND sg13cmos5l_dfrbpq_1
XFILLER_31_360 VPWR VGND sg13cmos5l_decap_8
XFILLER_32_872 VPWR VGND sg13cmos5l_decap_4
X_2836_ _2836_/Y _2835_/A _2835_/B _2717_/Y VPWR VGND sg13cmos5l_a21oi_1
X_4263__586 _4263_/RESET_B VPWR VGND sg13cmos5l_tiehi
X_2767_ _2770_/A _2773_/A _2773_/B VPWR VGND sg13cmos5l_nor2_1
X_2698_ _4057_/D _2698_/A _2698_/B VPWR VGND sg13cmos5l_nor2_1
X_4120__524 _4120_/RESET_B VPWR VGND sg13cmos5l_tiehi
X_3319_ _3320_/B _4149_/Q _4148_/Q _4150_/Q VPWR VGND sg13cmos5l_o21ai_1
XFILLER_46_408 VPWR VGND sg13cmos5l_fill_1
XFILLER_27_600 VPWR VGND sg13cmos5l_decap_4
XFILLER_27_622 VPWR VGND sg13cmos5l_decap_8
XFILLER_25_11 VPWR VGND sg13cmos5l_fill_2
XFILLER_14_327 VPWR VGND sg13cmos5l_decap_8
XFILLER_42_669 VPWR VGND sg13cmos5l_decap_8
XFILLER_25_88 VPWR VGND sg13cmos5l_fill_1
XFILLER_41_32 VPWR VGND sg13cmos5l_decap_8
XFILLER_41_21 VPWR VGND sg13cmos5l_fill_2
XFILLER_6_526 VPWR VGND sg13cmos5l_decap_8
XFILLER_29_1007 VPWR VGND sg13cmos5l_decap_8
XFILLER_2_765 VPWR VGND sg13cmos5l_decap_8
XFILLER_49_202 VPWR VGND sg13cmos5l_decap_8
XFILLER_37_419 VPWR VGND sg13cmos5l_fill_1
XFILLER_46_975 VPWR VGND sg13cmos5l_decap_8
XFILLER_33_614 VPWR VGND sg13cmos5l_decap_4
XFILLER_14_861 VPWR VGND sg13cmos5l_fill_2
XFILLER_32_168 VPWR VGND sg13cmos5l_decap_8
X_3670_ _3670_/Y _3665_/Y _3667_/Y _3669_/Y VPWR VGND sg13cmos5l_o21ai_1
XFILLER_9_364 VPWR VGND sg13cmos5l_decap_8
XFILLER_9_386 VPWR VGND sg13cmos5l_fill_1
XFILLER_12_1000 VPWR VGND sg13cmos5l_decap_8
X_2621_ _2621_/X _4005_/Q _3988_/Q _3971_/Q _3954_/Q _2643_/S0 _2621_/S1 VPWR VGND
+ sg13cmos5l_mux4_1
X_2552_ _2552_/Y _2552_/A _3904_/Q VPWR VGND sg13cmos5l_nor2b_1
X_2483_ _2483_/Y _2194_/A _4034_/Q _2466_/A VPWR VGND sg13cmos5l_o21ai_1
X_4222_ _4222_/Q _4277_/CLK _4222_/D _4222_/RESET_B VPWR VGND sg13cmos5l_dfrbpq_1
X_4153_ _4153_/Q _4227_/CLK _4153_/D _4153_/RESET_B VPWR VGND sg13cmos5l_dfrbpq_1
X_4084_ _4084_/Q clkload8/A _4084_/D _4084_/RESET_B VPWR VGND sg13cmos5l_dfrbpq_1
X_3104_ _3104_/X _3104_/A _3104_/B VPWR VGND sg13cmos5l_xor2_1
XFILLER_37_931 VPWR VGND sg13cmos5l_decap_8
X_3035_ _3035_/Y _4128_/Q _3035_/A2 _3273_/B VPWR VGND sg13cmos5l_o21ai_1
XFILLER_24_647 VPWR VGND sg13cmos5l_decap_8
X_4187__451 _4187_/RESET_B VPWR VGND sg13cmos5l_tiehi
XFILLER_23_157 VPWR VGND sg13cmos5l_decap_8
X_3937_ _3937_/Q _4278_/CLK _3937_/D _3937_/RESET_B VPWR VGND sg13cmos5l_dfrbpq_1
X_3868_ _3896_/D _2226_/Y _3873_/S _3867_/Y VPWR VGND sg13cmos5l_a21oi_1
X_2819_ _4086_/D _2884_/B _2914_/A VPWR VGND sg13cmos5l_and2_1
X_3799_ _3799_/Y _3799_/A VPWR VGND sg13cmos5l_inv_1
XFILLER_3_507 VPWR VGND sg13cmos5l_decap_8
XFILLER_3_529 VPWR VGND sg13cmos5l_decap_8
XFILLER_28_931 VPWR VGND sg13cmos5l_fill_1
XFILLER_28_942 VPWR VGND sg13cmos5l_decap_8
XFILLER_43_912 VPWR VGND sg13cmos5l_decap_8
XFILLER_27_430 VPWR VGND sg13cmos5l_decap_4
XFILLER_28_997 VPWR VGND sg13cmos5l_decap_8
XFILLER_36_76 VPWR VGND sg13cmos5l_decap_8
XFILLER_43_989 VPWR VGND sg13cmos5l_decap_8
XFILLER_42_477 VPWR VGND sg13cmos5l_decap_8
XFILLER_30_617 VPWR VGND sg13cmos5l_decap_8
XFILLER_30_628 VPWR VGND sg13cmos5l_fill_1
XFILLER_7_846 VPWR VGND sg13cmos5l_decap_4
XFILLER_2_540 VPWR VGND sg13cmos5l_decap_4
X_4103__541 _4103_/RESET_B VPWR VGND sg13cmos5l_tiehi
XFILLER_38_717 VPWR VGND sg13cmos5l_fill_1
XFILLER_38_706 VPWR VGND sg13cmos5l_decap_8
XFILLER_19_931 VPWR VGND sg13cmos5l_decap_4
XFILLER_37_249 VPWR VGND sg13cmos5l_fill_1
XFILLER_46_772 VPWR VGND sg13cmos5l_decap_8
XFILLER_18_463 VPWR VGND sg13cmos5l_fill_2
XFILLER_33_411 VPWR VGND sg13cmos5l_decap_4
XFILLER_34_934 VPWR VGND sg13cmos5l_decap_8
X_4110__534 _4110_/RESET_B VPWR VGND sg13cmos5l_tiehi
XFILLER_33_499 VPWR VGND sg13cmos5l_fill_1
X_3722_ _3793_/B _4254_/Q _4228_/Q _4256_/Q VPWR VGND sg13cmos5l_nand3_1
X_3653_ _3779_/A _3625_/X _3652_/Y _3659_/A VPWR VGND sg13cmos5l_mux2_1
X_2604_ _2604_/Y _2603_/A _3881_/Q _2603_/Y VPWR VGND sg13cmos5l_a21oi_1
X_3584_ _3584_/X _4232_/Q _3601_/B _3575_/Y VPWR VGND sg13cmos5l_a21o_1
X_2535_ _2536_/B _2535_/A _2535_/B _2535_/C VPWR VGND sg13cmos5l_nor3_1
X_2466_ _4024_/D _2466_/A _2466_/B VPWR VGND sg13cmos5l_and2_1
X_4219__414 _4219_/RESET_B VPWR VGND sg13cmos5l_tiehi
X_4205_ _4205_/Q _4205_/CLK _4205_/D _4205_/RESET_B VPWR VGND sg13cmos5l_dfrbpq_1
X_4136_ _4136_/Q _4136_/CLK _4136_/D _4136_/RESET_B VPWR VGND sg13cmos5l_dfrbpq_1
X_2397_ _3991_/D _2417_/A0 hold787/X _2401_/S VPWR VGND sg13cmos5l_mux2_1
XFILLER_28_227 VPWR VGND sg13cmos5l_decap_4
XFILLER_44_709 VPWR VGND sg13cmos5l_fill_2
X_4067_ _4067_/Q _4136_/CLK _4067_/D _4067_/RESET_B VPWR VGND sg13cmos5l_dfrbpq_1
XFILLER_37_794 VPWR VGND sg13cmos5l_decap_8
X_3018_ _3018_/Y _3016_/C _3017_/Y _3016_/Y VPWR VGND sg13cmos5l_a21oi_1
XFILLER_25_945 VPWR VGND sg13cmos5l_decap_8
XFILLER_19_1028 VPWR VGND sg13cmos5l_fill_1
XFILLER_24_499 VPWR VGND sg13cmos5l_decap_8
XFILLER_11_149 VPWR VGND sg13cmos5l_decap_8
XFILLER_22_89 VPWR VGND sg13cmos5l_decap_8
XFILLER_3_326 VPWR VGND sg13cmos5l_fill_2
XFILLER_3_315 VPWR VGND sg13cmos5l_fill_2
XFILLER_47_525 VPWR VGND sg13cmos5l_decap_8
XFILLER_47_42 VPWR VGND sg13cmos5l_fill_2
XFILLER_43_742 VPWR VGND sg13cmos5l_decap_8
XFILLER_27_293 VPWR VGND sg13cmos5l_decap_8
XFILLER_42_274 VPWR VGND sg13cmos5l_fill_1
XFILLER_30_447 VPWR VGND sg13cmos5l_decap_8
XFILLER_8_36 VPWR VGND sg13cmos5l_decap_4
XFILLER_30_458 VPWR VGND sg13cmos5l_fill_1
XFILLER_8_69 VPWR VGND sg13cmos5l_fill_1
XFILLER_11_694 VPWR VGND sg13cmos5l_decap_8
XFILLER_7_654 VPWR VGND sg13cmos5l_decap_8
XFILLER_3_860 VPWR VGND sg13cmos5l_decap_8
X_2320_ _3926_/D _3863_/A0 hold713/X _2321_/S VPWR VGND sg13cmos5l_mux2_1
XFILLER_2_381 VPWR VGND sg13cmos5l_decap_8
X_2251_ _2252_/A _4276_/D _4273_/D VPWR VGND sg13cmos5l_nor2_1
X_4177__461 _4177_/RESET_B VPWR VGND sg13cmos5l_tiehi
XFILLER_26_4 VPWR VGND sg13cmos5l_decap_8
X_2182_ _2182_/Y _2896_/A VPWR VGND sg13cmos5l_inv_1
XFILLER_38_558 VPWR VGND sg13cmos5l_fill_1
X_4184__454 _4184_/RESET_B VPWR VGND sg13cmos5l_tiehi
X_3705_ _3705_/Y _4252_/Q _3706_/A2 _3556_/A VPWR VGND sg13cmos5l_o21ai_1
X_3636_ _3636_/Y _3619_/X _3623_/A _3632_/A _3635_/X VPWR VGND sg13cmos5l_a22oi_1
X_3567_ _3567_/Y _3600_/A _3567_/B VPWR VGND sg13cmos5l_nor2_1
X_2518_ _4040_/D _3617_/B _2518_/B _2521_/A _2518_/D VPWR VGND sg13cmos5l_nor4_1
X_3498_ _3498_/Y _4181_/Q _4180_/Q VPWR VGND sg13cmos5l_xnor2_1
X_2449_ _4021_/D _3874_/A _2449_/B VPWR VGND sg13cmos5l_nor2_1
X_4119_ _4119_/Q _4168_/CLK _4119_/D _4119_/RESET_B VPWR VGND sg13cmos5l_dfrbpq_1
X_4191__447 _4191_/RESET_B VPWR VGND sg13cmos5l_tiehi
XFILLER_16_219 VPWR VGND sg13cmos5l_decap_8
XFILLER_33_11 VPWR VGND sg13cmos5l_fill_2
XFILLER_12_458 VPWR VGND sg13cmos5l_decap_8
XFILLER_4_668 VPWR VGND sg13cmos5l_fill_2
XFILLER_0_830 VPWR VGND sg13cmos5l_decap_8
XFILLER_47_322 VPWR VGND sg13cmos5l_decap_8
XFILLER_48_867 VPWR VGND sg13cmos5l_decap_8
XFILLER_47_355 VPWR VGND sg13cmos5l_decap_4
XFILLER_15_230 VPWR VGND sg13cmos5l_fill_2
XFILLER_16_786 VPWR VGND sg13cmos5l_decap_8
XFILLER_30_233 VPWR VGND sg13cmos5l_fill_2
XFILLER_8_941 VPWR VGND sg13cmos5l_decap_8
XFILLER_31_789 VPWR VGND sg13cmos5l_decap_8
X_3421_ _3430_/B _3341_/Y _3307_/Y _3428_/B VPWR VGND sg13cmos5l_mux2_1
XFILLER_48_1021 VPWR VGND sg13cmos5l_decap_8
X_3352_ _3353_/B _4205_/Q _2239_/Y _3351_/Y VPWR VGND sg13cmos5l_o21ai_1
X_2303_ _2311_/S _3855_/C _3846_/D _2312_/C VPWR VGND sg13cmos5l_and3_1
X_3283_ _3291_/B _3558_/A _4204_/Q _4205_/Q VPWR VGND sg13cmos5l_nor3_1
XFILLER_38_322 VPWR VGND sg13cmos5l_fill_1
X_2234_ _3522_/B _4187_/Q VPWR VGND sg13cmos5l_inv_1
X_2165_ _2165_/Y _3702_/B VPWR VGND sg13cmos5l_inv_1
XFILLER_17_0 VPWR VGND sg13cmos5l_decap_8
XFILLER_38_366 VPWR VGND sg13cmos5l_decap_4
XFILLER_0_1012 VPWR VGND sg13cmos5l_decap_8
XFILLER_0_92 VPWR VGND sg13cmos5l_fill_1
XFILLER_21_200 VPWR VGND sg13cmos5l_fill_1
XFILLER_34_572 VPWR VGND sg13cmos5l_decap_8
XFILLER_21_244 VPWR VGND sg13cmos5l_fill_1
XFILLER_22_767 VPWR VGND sg13cmos5l_decap_8
X_2998_ _4118_/D _3090_/A _2998_/B VPWR VGND sg13cmos5l_nor2_1
X_3619_ _3619_/X _4262_/Q _4261_/Q VPWR VGND sg13cmos5l_xor2_1
Xhold930 _2241_/A _4154_/Q VPWR VGND sg13cmos5l_dlygate4sd3_1
Xhold952 _2913_/B _2912_/Y VPWR VGND sg13cmos5l_dlygate4sd3_1
Xhold941 _2503_/A _2501_/Y VPWR VGND sg13cmos5l_dlygate4sd3_1
Xhold963 _4082_/D _2789_/Y VPWR VGND sg13cmos5l_dlygate4sd3_1
Xhold974 hold974/X _4234_/Q VPWR VGND sg13cmos5l_dlygate4sd3_1
Xhold996 hold996/X _3490_/Y VPWR VGND sg13cmos5l_dlygate4sd3_1
Xhold985 _3588_/B _3587_/Y VPWR VGND sg13cmos5l_dlygate4sd3_1
XFILLER_45_804 VPWR VGND sg13cmos5l_decap_8
XFILLER_29_355 VPWR VGND sg13cmos5l_fill_2
XFILLER_29_377 VPWR VGND sg13cmos5l_decap_8
XFILLER_45_859 VPWR VGND sg13cmos5l_decap_8
XFILLER_44_325 VPWR VGND sg13cmos5l_decap_8
XFILLER_25_572 VPWR VGND sg13cmos5l_decap_8
XFILLER_44_98 VPWR VGND sg13cmos5l_fill_1
XFILLER_40_531 VPWR VGND sg13cmos5l_fill_1
XFILLER_40_575 VPWR VGND sg13cmos5l_decap_4
XFILLER_8_215 VPWR VGND sg13cmos5l_decap_8
X_4167__471 _4167_/RESET_B VPWR VGND sg13cmos5l_tiehi
XFILLER_5_911 VPWR VGND sg13cmos5l_decap_8
XFILLER_5_988 VPWR VGND sg13cmos5l_decap_8
XFILLER_0_660 VPWR VGND sg13cmos5l_decap_8
X_4174__464 _4174_/RESET_B VPWR VGND sg13cmos5l_tiehi
XFILLER_16_550 VPWR VGND sg13cmos5l_decap_8
X_3970_ _3970_/Q _4011_/CLK _3970_/D _3970_/RESET_B VPWR VGND sg13cmos5l_dfrbpq_1
XFILLER_35_369 VPWR VGND sg13cmos5l_fill_1
X_2921_ _2921_/Y _2909_/A _2905_/Y _2910_/B _2910_/A _2920_/Y VPWR VGND sg13cmos5l_a221oi_1
XFILLER_31_520 VPWR VGND sg13cmos5l_fill_2
XFILLER_43_391 VPWR VGND sg13cmos5l_decap_4
X_2852_ _2852_/Y _2849_/Y _2850_/Y _2851_/Y VPWR VGND sg13cmos5l_o21ai_1
XFILLER_31_575 VPWR VGND sg13cmos5l_fill_1
X_2783_ _2788_/A _2775_/D _2774_/B _2782_/Y VPWR VGND sg13cmos5l_a21o_1
X_4181__457 _4181_/RESET_B VPWR VGND sg13cmos5l_tiehi
X_3404_ _3404_/Y _4193_/Q _4164_/Q VPWR VGND sg13cmos5l_nand2_1
X_3335_ _3397_/D _3343_/B _3343_/C _3118_/Y VPWR VGND sg13cmos5l_o21ai_1
XFILLER_39_620 VPWR VGND sg13cmos5l_fill_2
X_3266_ _3266_/Y _3253_/A _3262_/X _3217_/B VPWR VGND sg13cmos5l_o21ai_1
X_2217_ _3047_/A _2217_/A VPWR VGND sg13cmos5l_inv_1
XFILLER_38_152 VPWR VGND sg13cmos5l_decap_8
X_3197_ _3198_/B _3359_/B _3187_/Y _3197_/S VPWR VGND sg13cmos5l_mux2_1
XFILLER_27_837 VPWR VGND sg13cmos5l_fill_1
XFILLER_27_848 VPWR VGND sg13cmos5l_decap_8
XFILLER_35_870 VPWR VGND sg13cmos5l_fill_1
XFILLER_10_704 VPWR VGND sg13cmos5l_decap_8
XFILLER_14_79 VPWR VGND sg13cmos5l_fill_2
Xhold771 hold771/X _4002_/Q VPWR VGND sg13cmos5l_dlygate4sd3_1
XFILLER_2_947 VPWR VGND sg13cmos5l_decap_8
Xhold782 _3380_/B _4158_/Q VPWR VGND sg13cmos5l_dlygate4sd3_1
Xhold760 hold760/X _4009_/Q VPWR VGND sg13cmos5l_dlygate4sd3_1
Xhold793 hold793/X _3884_/Q VPWR VGND sg13cmos5l_dlygate4sd3_1
XFILLER_7_1007 VPWR VGND sg13cmos5l_decap_8
XFILLER_39_54 VPWR VGND sg13cmos5l_fill_1
XFILLER_45_601 VPWR VGND sg13cmos5l_fill_1
XFILLER_45_645 VPWR VGND sg13cmos5l_fill_2
XFILLER_26_881 VPWR VGND sg13cmos5l_decap_8
XFILLER_41_895 VPWR VGND sg13cmos5l_decap_8
XFILLER_9_502 VPWR VGND sg13cmos5l_fill_1
XFILLER_45_1013 VPWR VGND sg13cmos5l_decap_8
X_3120_ _4143_/D _3215_/B _3120_/B VPWR VGND sg13cmos5l_nor2_1
XFILLER_49_940 VPWR VGND sg13cmos5l_decap_8
X_3051_ _3051_/Y _2967_/B _2999_/Y _3064_/A VPWR VGND sg13cmos5l_o21ai_1
XFILLER_35_100 VPWR VGND sg13cmos5l_decap_4
XFILLER_24_807 VPWR VGND sg13cmos5l_decap_8
XFILLER_35_133 VPWR VGND sg13cmos5l_decap_4
XFILLER_23_317 VPWR VGND sg13cmos5l_decap_8
XFILLER_35_177 VPWR VGND sg13cmos5l_decap_8
X_3953_ _3953_/Q _4278_/CLK _3953_/D _3953_/RESET_B VPWR VGND sg13cmos5l_dfrbpq_1
X_3884_ _3884_/Q clkload7/A _3884_/D _3884_/RESET_B VPWR VGND sg13cmos5l_dfrbpq_1
X_2904_ _2909_/A _2908_/B _2908_/C _2908_/A VPWR VGND sg13cmos5l_a21oi_1
XFILLER_32_895 VPWR VGND sg13cmos5l_decap_4
X_2835_ _2835_/Y _2835_/A _2835_/B VPWR VGND sg13cmos5l_nand2_1
X_2766_ _2766_/Y _4078_/Q _2773_/B VPWR VGND sg13cmos5l_nand2_1
X_2697_ _2698_/B _2697_/A _2536_/B VPWR VGND sg13cmos5l_nor2b_1
X_4179__161 _4179_/D VPWR VGND sg13cmos5l_tielo
X_3318_ _3318_/Y _3318_/A _3320_/A VPWR VGND sg13cmos5l_xnor2_1
X_3249_ _3250_/C _3249_/A _3249_/B _3249_/C VPWR VGND sg13cmos5l_and3_1
XFILLER_26_111 VPWR VGND sg13cmos5l_fill_1
XFILLER_26_188 VPWR VGND sg13cmos5l_decap_8
XFILLER_42_648 VPWR VGND sg13cmos5l_decap_8
XFILLER_26_199 VPWR VGND sg13cmos5l_fill_1
XFILLER_41_11 VPWR VGND sg13cmos5l_decap_4
XFILLER_10_567 VPWR VGND sg13cmos5l_fill_2
XFILLER_41_99 VPWR VGND sg13cmos5l_fill_2
XFILLER_41_77 VPWR VGND sg13cmos5l_fill_2
X_4164__474 _4164_/RESET_B VPWR VGND sg13cmos5l_tiehi
XFILLER_2_744 VPWR VGND sg13cmos5l_decap_8
Xhold590 _3042_/B _4102_/Q VPWR VGND sg13cmos5l_dlygate4sd3_1
XFILLER_49_258 VPWR VGND sg13cmos5l_decap_8
XFILLER_46_954 VPWR VGND sg13cmos5l_decap_8
XFILLER_17_133 VPWR VGND sg13cmos5l_fill_1
X_4171__467 _4171_/RESET_B VPWR VGND sg13cmos5l_tiehi
XFILLER_14_840 VPWR VGND sg13cmos5l_decap_8
XFILLER_9_343 VPWR VGND sg13cmos5l_fill_1
XFILLER_13_372 VPWR VGND sg13cmos5l_decap_8
X_2620_ _2620_/Y _2641_/B2 _2617_/Y _2618_/Y _2619_/Y _2646_/A VPWR VGND sg13cmos5l_a221oi_1
XFILLER_9_398 VPWR VGND sg13cmos5l_fill_2
X_2551_ _2551_/Y _2646_/A _2550_/X _2549_/Y VPWR VGND sg13cmos5l_a21oi_1
X_2482_ _2482_/Y _2168_/Y _3617_/A _2481_/Y VPWR VGND sg13cmos5l_a21oi_1
XFILLER_5_593 VPWR VGND sg13cmos5l_fill_2
X_4221_ _4221_/Q _4265_/CLK _4221_/D _4221_/RESET_B VPWR VGND sg13cmos5l_dfrbpq_1
X_4152_ _4152_/Q _4231_/CLK _4152_/D _4152_/RESET_B VPWR VGND sg13cmos5l_dfrbpq_1
X_4083_ _4083_/Q clkload8/A _4083_/D _4083_/RESET_B VPWR VGND sg13cmos5l_dfrbpq_1
X_3103_ _3103_/Y _4143_/Q _4144_/Q VPWR VGND sg13cmos5l_xnor2_1
X_3034_ _4127_/D _3547_/A _3034_/B VPWR VGND sg13cmos5l_and2_1
XFILLER_36_420 VPWR VGND sg13cmos5l_fill_1
XFILLER_48_291 VPWR VGND sg13cmos5l_decap_4
XFILLER_37_987 VPWR VGND sg13cmos5l_decap_8
XFILLER_36_475 VPWR VGND sg13cmos5l_fill_2
X_3936_ _3936_/Q _4278_/CLK _3936_/D _3936_/RESET_B VPWR VGND sg13cmos5l_dfrbpq_1
XFILLER_20_843 VPWR VGND sg13cmos5l_decap_8
X_3867_ _3867_/Y _3867_/A _3873_/S VPWR VGND sg13cmos5l_nor2_1
X_2818_ _2914_/A _2810_/B _2817_/Y _2818_/S VPWR VGND sg13cmos5l_mux2_1
X_3798_ _3799_/A _3798_/A _3798_/B VPWR VGND sg13cmos5l_nand2_1
X_2749_ _4069_/D _2713_/Y hold890/X _2789_/A VPWR VGND sg13cmos5l_a21oi_1
XFILLER_47_729 VPWR VGND sg13cmos5l_decap_4
XFILLER_47_718 VPWR VGND sg13cmos5l_fill_1
XFILLER_28_976 VPWR VGND sg13cmos5l_decap_8
XFILLER_15_604 VPWR VGND sg13cmos5l_decap_8
XFILLER_15_615 VPWR VGND sg13cmos5l_fill_2
XFILLER_43_968 VPWR VGND sg13cmos5l_decap_8
XFILLER_42_456 VPWR VGND sg13cmos5l_decap_8
XFILLER_14_169 VPWR VGND sg13cmos5l_fill_2
XFILLER_35_1012 VPWR VGND sg13cmos5l_decap_8
XFILLER_23_670 VPWR VGND sg13cmos5l_fill_2
XFILLER_7_814 VPWR VGND sg13cmos5l_decap_8
XFILLER_11_887 VPWR VGND sg13cmos5l_decap_8
XFILLER_2_574 VPWR VGND sg13cmos5l_decap_4
XFILLER_2_596 VPWR VGND sg13cmos5l_decap_4
XFILLER_37_206 VPWR VGND sg13cmos5l_fill_2
XFILLER_37_217 VPWR VGND sg13cmos5l_decap_8
XFILLER_19_921 VPWR VGND sg13cmos5l_fill_2
XFILLER_46_751 VPWR VGND sg13cmos5l_decap_8
XFILLER_18_431 VPWR VGND sg13cmos5l_fill_1
XFILLER_19_998 VPWR VGND sg13cmos5l_decap_8
XFILLER_33_445 VPWR VGND sg13cmos5l_fill_2
XFILLER_21_618 VPWR VGND sg13cmos5l_decap_4
XFILLER_33_467 VPWR VGND sg13cmos5l_decap_8
XFILLER_9_140 VPWR VGND sg13cmos5l_fill_2
X_3721_ _3793_/A _4255_/Q _3733_/B VPWR VGND sg13cmos5l_nand2_1
X_3652_ _3652_/Y _3674_/A _3658_/B VPWR VGND sg13cmos5l_nand2_1
XFILLER_9_162 VPWR VGND sg13cmos5l_fill_1
X_2603_ _2603_/Y _2603_/A _3898_/Q VPWR VGND sg13cmos5l_nor2b_1
X_3583_ _3583_/X _3602_/A _3583_/B VPWR VGND sg13cmos5l_and2_1
XFILLER_6_891 VPWR VGND sg13cmos5l_decap_4
X_2534_ _2534_/Y _2529_/Y hold843/X _2698_/A VPWR VGND sg13cmos5l_a21oi_1
XFILLER_47_0 VPWR VGND sg13cmos5l_decap_8
X_2465_ _2466_/B _2461_/A _2464_/A _2464_/Y VPWR VGND sg13cmos5l_o21ai_1
X_4204_ _4204_/Q _4231_/CLK _4204_/D _4204_/RESET_B VPWR VGND sg13cmos5l_dfrbpq_1
X_2396_ _3990_/D _2416_/A0 hold683/X _2401_/S VPWR VGND sg13cmos5l_mux2_1
XFILLER_29_729 VPWR VGND sg13cmos5l_decap_4
X_4135_ _4135_/Q _4136_/CLK _4135_/D _4135_/RESET_B VPWR VGND sg13cmos5l_dfrbpq_1
XFILLER_3_1021 VPWR VGND sg13cmos5l_decap_8
XFILLER_28_206 VPWR VGND sg13cmos5l_decap_8
X_4066_ _4066_/Q _4137_/CLK _4066_/D _4066_/RESET_B VPWR VGND sg13cmos5l_dfrbpq_1
X_3017_ _3017_/Y _4142_/Q _4138_/Q VPWR VGND sg13cmos5l_nor2b_1
XFILLER_11_117 VPWR VGND sg13cmos5l_fill_1
XFILLER_33_990 VPWR VGND sg13cmos5l_decap_8
X_3919_ _3919_/Q _4278_/CLK _3919_/D _3919_/RESET_B VPWR VGND sg13cmos5l_dfrbpq_1
Xfanout130 _3389_/A _3555_/A VPWR VGND sg13cmos5l_buf_1
XFILLER_47_21 VPWR VGND sg13cmos5l_fill_1
XFILLER_47_548 VPWR VGND sg13cmos5l_fill_1
XFILLER_16_902 VPWR VGND sg13cmos5l_decap_8
XFILLER_28_762 VPWR VGND sg13cmos5l_fill_1
XFILLER_28_795 VPWR VGND sg13cmos5l_decap_4
XFILLER_43_787 VPWR VGND sg13cmos5l_decap_8
XFILLER_43_776 VPWR VGND sg13cmos5l_decap_8
XFILLER_15_478 VPWR VGND sg13cmos5l_decap_8
XFILLER_31_927 VPWR VGND sg13cmos5l_fill_1
XFILLER_8_15 VPWR VGND sg13cmos5l_decap_8
XFILLER_31_938 VPWR VGND sg13cmos5l_fill_1
XFILLER_6_132 VPWR VGND sg13cmos5l_decap_8
XFILLER_7_688 VPWR VGND sg13cmos5l_decap_8
XFILLER_6_176 VPWR VGND sg13cmos5l_fill_1
X_2250_ _4273_/D _4272_/D _2510_/A _2504_/A VPWR VGND sg13cmos5l_nor3_1
X_3999__292 _3999_/RESET_B VPWR VGND sg13cmos5l_tiehi
XFILLER_38_526 VPWR VGND sg13cmos5l_decap_4
X_2181_ _2181_/Y _2181_/A VPWR VGND sg13cmos5l_inv_1
XFILLER_19_784 VPWR VGND sg13cmos5l_decap_8
XFILLER_19_795 VPWR VGND sg13cmos5l_fill_1
XFILLER_34_732 VPWR VGND sg13cmos5l_decap_8
XFILLER_33_275 VPWR VGND sg13cmos5l_decap_8
XFILLER_33_286 VPWR VGND sg13cmos5l_fill_2
X_3704_ _4251_/D _3704_/A _3704_/B VPWR VGND sg13cmos5l_and2_1
X_3635_ _3635_/X _4242_/Q _3635_/B VPWR VGND sg13cmos5l_xor2_1
X_3566_ _3566_/Y _3563_/A _3563_/B _3567_/B _3600_/A VPWR VGND sg13cmos5l_a22oi_1
X_3497_ _3497_/Y _4202_/Q _4180_/Q VPWR VGND sg13cmos5l_nor2_1
X_2517_ _2517_/Y _2422_/B _2516_/A _2422_/A VPWR VGND sg13cmos5l_a21oi_1
X_2448_ _2448_/Y _4021_/Q _2434_/A _2435_/B hold663/X VPWR VGND sg13cmos5l_a22oi_1
XFILLER_25_1022 VPWR VGND sg13cmos5l_decap_8
X_2379_ _3976_/D _2419_/A0 hold734/X _2381_/S VPWR VGND sg13cmos5l_mux2_1
X_4118_ _4118_/Q _4168_/CLK _4118_/D _4118_/RESET_B VPWR VGND sg13cmos5l_dfrbpq_1
XFILLER_44_507 VPWR VGND sg13cmos5l_fill_1
XFILLER_37_570 VPWR VGND sg13cmos5l_fill_2
X_4049_ _4049_/Q _4280_/CLK _4049_/D _4049_/RESET_B VPWR VGND sg13cmos5l_dfrbpq_1
XFILLER_37_581 VPWR VGND sg13cmos5l_fill_1
XFILLER_13_916 VPWR VGND sg13cmos5l_fill_2
XFILLER_24_231 VPWR VGND sg13cmos5l_fill_2
XFILLER_24_242 VPWR VGND sg13cmos5l_fill_2
XFILLER_40_746 VPWR VGND sg13cmos5l_fill_1
XFILLER_12_404 VPWR VGND sg13cmos5l_fill_1
XFILLER_13_949 VPWR VGND sg13cmos5l_decap_8
XFILLER_12_448 VPWR VGND sg13cmos5l_decap_4
XFILLER_32_1015 VPWR VGND sg13cmos5l_decap_8
XFILLER_33_89 VPWR VGND sg13cmos5l_decap_8
XFILLER_4_647 VPWR VGND sg13cmos5l_decap_8
XFILLER_4_636 VPWR VGND sg13cmos5l_decap_8
XFILLER_3_135 VPWR VGND sg13cmos5l_decap_8
XFILLER_3_124 VPWR VGND sg13cmos5l_fill_1
X_4100__545 _4100_/RESET_B VPWR VGND sg13cmos5l_tiehi
XFILLER_48_846 VPWR VGND sg13cmos5l_decap_8
XFILLER_0_886 VPWR VGND sg13cmos5l_decap_8
XFILLER_16_743 VPWR VGND sg13cmos5l_decap_8
XFILLER_28_581 VPWR VGND sg13cmos5l_decap_8
XFILLER_28_592 VPWR VGND sg13cmos5l_fill_1
XFILLER_15_253 VPWR VGND sg13cmos5l_decap_8
XFILLER_31_768 VPWR VGND sg13cmos5l_fill_2
XFILLER_12_993 VPWR VGND sg13cmos5l_decap_8
XFILLER_8_997 VPWR VGND sg13cmos5l_decap_8
XFILLER_7_474 VPWR VGND sg13cmos5l_fill_1
XFILLER_7_463 VPWR VGND sg13cmos5l_decap_8
XFILLER_48_1000 VPWR VGND sg13cmos5l_decap_8
X_3420_ _3420_/Y _3435_/A _3420_/B VPWR VGND sg13cmos5l_nor2_1
X_3351_ _3351_/Y _4206_/Q _3201_/A _3350_/Y VPWR VGND sg13cmos5l_a21oi_1
X_2302_ _2312_/C _2322_/A _3846_/B VPWR VGND sg13cmos5l_nor2_1
X_3282_ _3282_/Y _3305_/A _3280_/Y _3281_/Y _3558_/A VPWR VGND sg13cmos5l_a22oi_1
X_2233_ _3378_/A _4189_/Q VPWR VGND sg13cmos5l_inv_1
X_2164_ _3702_/A _2164_/A VPWR VGND sg13cmos5l_inv_1
XFILLER_19_592 VPWR VGND sg13cmos5l_fill_2
XFILLER_34_562 VPWR VGND sg13cmos5l_fill_1
X_2997_ _2997_/Y _3048_/C _3048_/D VPWR VGND sg13cmos5l_nand2_1
Xhold931 _2814_/A _4085_/Q VPWR VGND sg13cmos5l_dlygate4sd3_1
X_3618_ _3618_/Y _3617_/A _3704_/A VPWR VGND sg13cmos5l_nand2b_1
Xhold920 _2773_/A _4080_/Q VPWR VGND sg13cmos5l_dlygate4sd3_1
Xhold964 _2217_/A _4111_/Q VPWR VGND sg13cmos5l_dlygate4sd3_1
Xhold953 hold953/X _2918_/A VPWR VGND sg13cmos5l_dlygate4sd3_1
Xhold942 _2543_/B _2511_/B VPWR VGND sg13cmos5l_dlygate4sd3_1
Xhold975 _4255_/D _3711_/X VPWR VGND sg13cmos5l_dlygate4sd3_1
Xhold986 _4235_/D _3613_/Y VPWR VGND sg13cmos5l_dlygate4sd3_1
Xhold997 hold997/X _4203_/Q VPWR VGND sg13cmos5l_dlygate4sd3_1
X_3549_ _3549_/Y _2172_/Y _3706_/A2 _3548_/Y VPWR VGND sg13cmos5l_a21oi_1
XFILLER_45_838 VPWR VGND sg13cmos5l_decap_8
XFILLER_9_706 VPWR VGND sg13cmos5l_decap_8
XFILLER_12_245 VPWR VGND sg13cmos5l_decap_8
XFILLER_5_901 VPWR VGND sg13cmos5l_fill_1
XFILLER_5_967 VPWR VGND sg13cmos5l_decap_8
XFILLER_4_466 VPWR VGND sg13cmos5l_decap_8
XFILLER_4_488 VPWR VGND sg13cmos5l_decap_8
Xclkbuf_2_3__f_clk clkload1/A clkbuf_0_clk/X VPWR VGND sg13cmos5l_buf_8
X_3996__295 _3996_/RESET_B VPWR VGND sg13cmos5l_tiehi
XFILLER_48_698 VPWR VGND sg13cmos5l_decap_8
X_2920_ _2920_/Y _2920_/A _2920_/B _2920_/C VPWR VGND sg13cmos5l_nor3_1
X_2851_ _2851_/Y _3047_/A _4070_/Q _2230_/Y _4110_/Q VPWR VGND sg13cmos5l_a22oi_1
X_2782_ _2782_/Y _2776_/Y _2780_/Y _2781_/Y VPWR VGND sg13cmos5l_a21oi_1
X_3403_ _3403_/X _3336_/Y _3303_/B _3428_/B VPWR VGND sg13cmos5l_mux2_1
X_3334_ _3397_/C _3334_/A _3338_/B _3338_/C VPWR VGND sg13cmos5l_nand3_1
X_3265_ _4170_/D _3265_/A _3264_/Y VPWR VGND sg13cmos5l_nor2b_1
XFILLER_38_120 VPWR VGND sg13cmos5l_decap_8
XFILLER_22_1014 VPWR VGND sg13cmos5l_decap_8
X_2216_ _3215_/A _3009_/C VPWR VGND sg13cmos5l_inv_1
X_3196_ _3196_/Y _3179_/Y _3197_/S _3195_/Y VPWR VGND sg13cmos5l_a21oi_1
XFILLER_27_816 VPWR VGND sg13cmos5l_fill_2
XFILLER_30_46 VPWR VGND sg13cmos5l_decap_4
Xhold772 hold772/X _3932_/Q VPWR VGND sg13cmos5l_dlygate4sd3_1
Xhold750 hold750/X _3877_/Q VPWR VGND sg13cmos5l_dlygate4sd3_1
XFILLER_2_926 VPWR VGND sg13cmos5l_decap_8
Xhold761 _4009_/D _2418_/X VPWR VGND sg13cmos5l_dlygate4sd3_1
Xhold783 _2195_/A _4033_/Q VPWR VGND sg13cmos5l_dlygate4sd3_1
Xhold794 hold794/X _3887_/Q VPWR VGND sg13cmos5l_dlygate4sd3_1
XFILLER_49_407 VPWR VGND sg13cmos5l_decap_4
XFILLER_39_66 VPWR VGND sg13cmos5l_decap_8
XFILLER_39_99 VPWR VGND sg13cmos5l_fill_2
XFILLER_45_613 VPWR VGND sg13cmos5l_fill_2
XFILLER_29_142 VPWR VGND sg13cmos5l_decap_8
XFILLER_44_112 VPWR VGND sg13cmos5l_fill_1
XFILLER_29_164 VPWR VGND sg13cmos5l_decap_8
XFILLER_45_668 VPWR VGND sg13cmos5l_decap_4
XFILLER_44_123 VPWR VGND sg13cmos5l_decap_8
XFILLER_44_189 VPWR VGND sg13cmos5l_fill_2
XFILLER_41_830 VPWR VGND sg13cmos5l_decap_4
XFILLER_1_981 VPWR VGND sg13cmos5l_decap_8
X_3050_ _3050_/Y _2963_/B _2997_/Y _2999_/Y _2967_/B VPWR VGND sg13cmos5l_a22oi_1
XFILLER_0_480 VPWR VGND sg13cmos5l_decap_8
XFILLER_49_996 VPWR VGND sg13cmos5l_decap_8
XFILLER_48_484 VPWR VGND sg13cmos5l_fill_1
X_3952_ _3952_/Q clkload6/A _3952_/D _3952_/RESET_B VPWR VGND sg13cmos5l_dfrbpq_1
X_3883_ _3883_/Q clkload8/A _3883_/D _3883_/RESET_B VPWR VGND sg13cmos5l_dfrbpq_1
X_2903_ _2908_/C _4100_/Q _4077_/Q _2912_/A VPWR VGND sg13cmos5l_nand3_1
X_2834_ _2835_/B _2704_/Y _2845_/A _2845_/B _2837_/A VPWR VGND sg13cmos5l_a22oi_1
X_2765_ _2773_/B _2763_/Y _2764_/Y _2762_/Y VPWR VGND sg13cmos5l_a21oi_1
X_2696_ _4056_/D _2529_/Y hold843/X _2536_/B _2697_/A _2698_/A VPWR VGND sg13cmos5l_a221oi_1
X_3317_ _3317_/X _4151_/Q _3320_/A VPWR VGND sg13cmos5l_xor2_1
XFILLER_39_451 VPWR VGND sg13cmos5l_decap_4
X_3248_ _3254_/A _3253_/A _3253_/B _3247_/Y _3249_/A _3226_/X VPWR VGND sg13cmos5l_a221oi_1
X_3179_ _3179_/Y _3180_/B _3176_/Y _3181_/C _3178_/Y VPWR VGND sg13cmos5l_a22oi_1
XFILLER_27_646 VPWR VGND sg13cmos5l_decap_8
XFILLER_14_307 VPWR VGND sg13cmos5l_decap_4
XFILLER_25_24 VPWR VGND sg13cmos5l_decap_4
XFILLER_25_57 VPWR VGND sg13cmos5l_fill_1
XFILLER_25_68 VPWR VGND sg13cmos5l_decap_8
XFILLER_22_362 VPWR VGND sg13cmos5l_decap_8
XFILLER_23_896 VPWR VGND sg13cmos5l_fill_1
XFILLER_1_200 VPWR VGND sg13cmos5l_fill_1
XFILLER_1_255 VPWR VGND sg13cmos5l_fill_1
Xhold591 _3387_/B _4162_/Q VPWR VGND sg13cmos5l_dlygate4sd3_1
XFILLER_49_237 VPWR VGND sg13cmos5l_decap_8
XFILLER_18_602 VPWR VGND sg13cmos5l_fill_1
XFILLER_46_933 VPWR VGND sg13cmos5l_decap_8
XFILLER_45_465 VPWR VGND sg13cmos5l_decap_8
X_3993__298 _3993_/RESET_B VPWR VGND sg13cmos5l_tiehi
XFILLER_14_863 VPWR VGND sg13cmos5l_fill_1
XFILLER_14_885 VPWR VGND sg13cmos5l_decap_8
XFILLER_32_148 VPWR VGND sg13cmos5l_fill_1
XFILLER_41_682 VPWR VGND sg13cmos5l_fill_2
XFILLER_9_311 VPWR VGND sg13cmos5l_fill_1
X_2550_ _2550_/X _4004_/Q _3987_/Q _3970_/Q _3953_/Q _2563_/A _2645_/S1 VPWR VGND
+ sg13cmos5l_mux4_1
X_2481_ _2481_/Y _2194_/A _2195_/A _2487_/B1 VPWR VGND sg13cmos5l_o21ai_1
XFILLER_49_4 VPWR VGND sg13cmos5l_decap_8
X_4220_ _4220_/Q _4265_/CLK _4220_/D _4220_/RESET_B VPWR VGND sg13cmos5l_dfrbpq_1
X_4151_ _4151_/Q _4205_/CLK _4151_/D _4151_/RESET_B VPWR VGND sg13cmos5l_dfrbpq_1
X_3102_ _3102_/X _3112_/B _3108_/B _3124_/A VPWR VGND sg13cmos5l_a21o_1
X_4082_ _4082_/Q _4129_/CLK _4082_/D _4082_/RESET_B VPWR VGND sg13cmos5l_dfrbpq_1
XFILLER_49_793 VPWR VGND sg13cmos5l_decap_8
X_4252__234 _4252_/RESET_B VPWR VGND sg13cmos5l_tiehi
X_3033_ _4125_/D _3021_/Y hold872/X _3090_/A VPWR VGND sg13cmos5l_a21oi_1
XFILLER_37_966 VPWR VGND sg13cmos5l_decap_8
XFILLER_36_487 VPWR VGND sg13cmos5l_fill_1
X_3935_ _3935_/Q clkload6/A _3935_/D _3935_/RESET_B VPWR VGND sg13cmos5l_dfrbpq_1
XFILLER_31_192 VPWR VGND sg13cmos5l_decap_8
X_3866_ _3895_/D _3866_/A0 hold687/X _3873_/S VPWR VGND sg13cmos5l_mux2_1
X_2817_ _2817_/Y _2817_/A _2976_/A VPWR VGND sg13cmos5l_nor2_1
X_3797_ _3798_/B _3805_/A _3797_/B VPWR VGND sg13cmos5l_nand2_1
X_2748_ _2748_/Y _2748_/A _2748_/B VPWR VGND sg13cmos5l_nand2_1
X_2679_ _2679_/Y _2679_/A VPWR VGND sg13cmos5l_inv_1
XFILLER_28_900 VPWR VGND sg13cmos5l_fill_2
XFILLER_28_922 VPWR VGND sg13cmos5l_decap_8
XFILLER_36_23 VPWR VGND sg13cmos5l_fill_2
XFILLER_43_947 VPWR VGND sg13cmos5l_decap_8
XFILLER_42_435 VPWR VGND sg13cmos5l_decap_8
XFILLER_14_126 VPWR VGND sg13cmos5l_fill_2
XFILLER_15_649 VPWR VGND sg13cmos5l_decap_4
XFILLER_14_159 VPWR VGND sg13cmos5l_decap_4
XFILLER_23_682 VPWR VGND sg13cmos5l_fill_2
XFILLER_23_693 VPWR VGND sg13cmos5l_decap_8
XFILLER_11_855 VPWR VGND sg13cmos5l_decap_8
XFILLER_6_369 VPWR VGND sg13cmos5l_fill_1
XFILLER_7_0 VPWR VGND sg13cmos5l_decap_4
XFILLER_42_1017 VPWR VGND sg13cmos5l_decap_8
X_4021__265 _4021_/RESET_B VPWR VGND sg13cmos5l_tiehi
XFILLER_42_1028 VPWR VGND sg13cmos5l_fill_1
XFILLER_19_955 VPWR VGND sg13cmos5l_decap_4
XFILLER_18_454 VPWR VGND sg13cmos5l_fill_2
XFILLER_34_969 VPWR VGND sg13cmos5l_decap_8
X_3720_ _3805_/B _3720_/A _3733_/B VPWR VGND sg13cmos5l_nor2_1
XFILLER_9_130 VPWR VGND sg13cmos5l_fill_2
XFILLER_13_170 VPWR VGND sg13cmos5l_fill_1
X_3651_ _4239_/D _3815_/A _3651_/B VPWR VGND sg13cmos5l_nor2_1
X_2602_ _2602_/Y _2603_/A _3915_/Q _2654_/A1 VPWR VGND sg13cmos5l_a21oi_1
X_3582_ _3583_/B _4232_/Q _3591_/B VPWR VGND sg13cmos5l_or2_1
X_2533_ _2775_/B _2761_/A _2726_/A VPWR VGND sg13cmos5l_nor2b_1
X_2464_ _2464_/Y _2464_/A _2464_/B _2464_/C VPWR VGND sg13cmos5l_nand3_1
X_2395_ _3989_/D _2415_/A0 hold797/X _2401_/S VPWR VGND sg13cmos5l_mux2_1
X_4203_ _4203_/Q _4231_/CLK _4203_/D _4203_/RESET_B VPWR VGND sg13cmos5l_dfrbpq_1
X_4134_ _4134_/Q _4136_/CLK _4134_/D _4134_/RESET_B VPWR VGND sg13cmos5l_dfrbpq_1
XFILLER_29_708 VPWR VGND sg13cmos5l_decap_8
XFILLER_3_1000 VPWR VGND sg13cmos5l_decap_8
X_4065_ _4065_/Q clkload8/A _4065_/D _4065_/RESET_B VPWR VGND sg13cmos5l_dfrbpq_1
XFILLER_37_752 VPWR VGND sg13cmos5l_decap_8
XFILLER_37_741 VPWR VGND sg13cmos5l_fill_2
XFILLER_37_730 VPWR VGND sg13cmos5l_decap_8
XFILLER_25_914 VPWR VGND sg13cmos5l_decap_8
XFILLER_25_925 VPWR VGND sg13cmos5l_fill_2
X_3016_ _3016_/Y _4096_/Q _3016_/B _3016_/C VPWR VGND sg13cmos5l_nor3_1
XFILLER_36_262 VPWR VGND sg13cmos5l_decap_4
XFILLER_36_295 VPWR VGND sg13cmos5l_fill_2
XFILLER_19_1019 VPWR VGND sg13cmos5l_decap_8
XFILLER_24_457 VPWR VGND sg13cmos5l_fill_2
XFILLER_24_468 VPWR VGND sg13cmos5l_fill_2
XFILLER_11_107 VPWR VGND sg13cmos5l_fill_2
X_3918_ _3918_/Q clkload6/A _3918_/D _3918_/RESET_B VPWR VGND sg13cmos5l_dfrbpq_1
X_3849_ _3879_/D hold753/X _3867_/A _3854_/S VPWR VGND sg13cmos5l_mux2_1
X_4044__221 _4044_/RESET_B VPWR VGND sg13cmos5l_tiehi
XFILLER_3_339 VPWR VGND sg13cmos5l_decap_8
X_4161__478 _4161_/RESET_B VPWR VGND sg13cmos5l_tiehi
XFILLER_0_7 VPWR VGND sg13cmos5l_decap_8
Xfanout120 _2466_/A _2519_/A VPWR VGND sg13cmos5l_buf_1
Xfanout131 _3555_/A _3212_/A VPWR VGND sg13cmos5l_buf_1
XFILLER_47_44 VPWR VGND sg13cmos5l_fill_1
XFILLER_28_752 VPWR VGND sg13cmos5l_fill_2
XFILLER_43_711 VPWR VGND sg13cmos5l_decap_8
XFILLER_43_722 VPWR VGND sg13cmos5l_fill_2
XFILLER_42_210 VPWR VGND sg13cmos5l_decap_8
XFILLER_30_405 VPWR VGND sg13cmos5l_decap_8
Xclkbuf_leaf_22_clk _4277_/CLK clkbuf_leaf_3_clk/A VPWR VGND sg13cmos5l_buf_8
XFILLER_10_162 VPWR VGND sg13cmos5l_fill_1
X_4242__266 _4242_/RESET_B VPWR VGND sg13cmos5l_tiehi
XFILLER_40_8 VPWR VGND sg13cmos5l_decap_4
XFILLER_3_895 VPWR VGND sg13cmos5l_decap_8
XFILLER_33_7 VPWR VGND sg13cmos5l_decap_4
X_2180_ _2180_/Y _2180_/A VPWR VGND sg13cmos5l_inv_1
XFILLER_38_549 VPWR VGND sg13cmos5l_decap_8
XFILLER_19_730 VPWR VGND sg13cmos5l_decap_4
XFILLER_33_254 VPWR VGND sg13cmos5l_decap_8
XFILLER_21_427 VPWR VGND sg13cmos5l_fill_2
Xclkbuf_leaf_13_clk _4137_/CLK clkload1/A VPWR VGND sg13cmos5l_buf_8
X_3703_ _4249_/D hold831/X _3702_/Y _3715_/B VPWR VGND sg13cmos5l_a21oi_1
XFILLER_30_983 VPWR VGND sg13cmos5l_decap_8
X_3634_ _3634_/Y _4242_/Q _3635_/B VPWR VGND sg13cmos5l_xnor2_1
X_3565_ _3565_/X _3565_/A _3565_/B _3565_/C VPWR VGND sg13cmos5l_or3_1
X_3496_ _3496_/Y _4203_/Q _4181_/Q VPWR VGND sg13cmos5l_nand2b_1
X_2516_ _2521_/A _2516_/A _2516_/B VPWR VGND sg13cmos5l_nor2_1
X_2447_ _4020_/D _3874_/A _2447_/B VPWR VGND sg13cmos5l_nor2_1
XFILLER_25_1001 VPWR VGND sg13cmos5l_decap_8
X_2378_ _3975_/D _2418_/A0 hold661/X _2378_/S VPWR VGND sg13cmos5l_mux2_1
X_4117_ _4117_/Q _4168_/CLK _4117_/D _4117_/RESET_B VPWR VGND sg13cmos5l_dfrbpq_1
XFILLER_17_14 VPWR VGND sg13cmos5l_fill_2
XFILLER_44_519 VPWR VGND sg13cmos5l_decap_8
X_4048_ _4048_/Q clkload8/A _4048_/D _4048_/RESET_B VPWR VGND sg13cmos5l_dfrbpq_1
XFILLER_24_210 VPWR VGND sg13cmos5l_decap_8
XFILLER_25_766 VPWR VGND sg13cmos5l_decap_8
XFILLER_40_725 VPWR VGND sg13cmos5l_decap_8
XFILLER_24_276 VPWR VGND sg13cmos5l_fill_2
XFILLER_25_799 VPWR VGND sg13cmos5l_fill_1
XFILLER_8_409 VPWR VGND sg13cmos5l_decap_8
XFILLER_33_79 VPWR VGND sg13cmos5l_fill_1
XFILLER_21_994 VPWR VGND sg13cmos5l_decap_8
XFILLER_4_615 VPWR VGND sg13cmos5l_decap_8
XFILLER_3_169 VPWR VGND sg13cmos5l_decap_8
XFILLER_0_865 VPWR VGND sg13cmos5l_decap_8
XFILLER_48_825 VPWR VGND sg13cmos5l_decap_8
XFILLER_47_302 VPWR VGND sg13cmos5l_decap_4
XFILLER_28_560 VPWR VGND sg13cmos5l_decap_4
XFILLER_43_574 VPWR VGND sg13cmos5l_decap_8
XFILLER_15_287 VPWR VGND sg13cmos5l_decap_8
XFILLER_31_714 VPWR VGND sg13cmos5l_decap_8
XFILLER_30_235 VPWR VGND sg13cmos5l_fill_1
XFILLER_31_747 VPWR VGND sg13cmos5l_decap_8
X_4209__426 _4209_/RESET_B VPWR VGND sg13cmos5l_tiehi
XFILLER_12_972 VPWR VGND sg13cmos5l_decap_8
XFILLER_7_431 VPWR VGND sg13cmos5l_decap_8
XFILLER_8_976 VPWR VGND sg13cmos5l_decap_8
XFILLER_7_497 VPWR VGND sg13cmos5l_fill_1
XFILLER_7_486 VPWR VGND sg13cmos5l_decap_8
X_3350_ _3350_/Y _4205_/Q _2239_/Y _3184_/A _4204_/Q _3349_/Y VPWR VGND sg13cmos5l_a221oi_1
X_2301_ _3910_/D input5/X hold707/X _2301_/S VPWR VGND sg13cmos5l_mux2_1
X_3281_ _3281_/Y _4176_/Q _4175_/Q _4202_/Q VPWR VGND sg13cmos5l_nand3b_1
XFILLER_31_4 VPWR VGND sg13cmos5l_fill_2
X_2232_ _2855_/B _2232_/A VPWR VGND sg13cmos5l_inv_1
Xclkbuf_leaf_2_clk _4278_/CLK clkbuf_leaf_4_clk/A VPWR VGND sg13cmos5l_buf_8
X_4216__419 _4216_/RESET_B VPWR VGND sg13cmos5l_tiehi
X_2163_ _2163_/Y _2163_/A VPWR VGND sg13cmos5l_inv_1
XFILLER_0_83 VPWR VGND sg13cmos5l_decap_8
XFILLER_34_530 VPWR VGND sg13cmos5l_fill_1
XFILLER_22_725 VPWR VGND sg13cmos5l_decap_8
XFILLER_22_736 VPWR VGND sg13cmos5l_fill_2
XFILLER_21_235 VPWR VGND sg13cmos5l_decap_8
X_2996_ _2998_/B _3048_/C _3048_/D VPWR VGND sg13cmos5l_and2_1
X_4266__553 _4266_/RESET_B VPWR VGND sg13cmos5l_tiehi
Xhold921 hold921/X _2774_/B VPWR VGND sg13cmos5l_dlygate4sd3_1
X_3617_ _3711_/B _3617_/A _3617_/B VPWR VGND sg13cmos5l_nor2_1
Xhold910 _2221_/A _4174_/Q VPWR VGND sg13cmos5l_dlygate4sd3_1
Xhold932 hold932/X _2814_/Y VPWR VGND sg13cmos5l_dlygate4sd3_1
Xhold954 _4109_/D _2926_/Y VPWR VGND sg13cmos5l_dlygate4sd3_1
X_3548_ _3548_/Y _4223_/Q _3706_/A2 _3273_/B VPWR VGND sg13cmos5l_o21ai_1
Xhold943 _2188_/A _4094_/Q VPWR VGND sg13cmos5l_dlygate4sd3_1
Xhold987 _2210_/A _4235_/Q VPWR VGND sg13cmos5l_dlygate4sd3_1
Xhold998 _3733_/A _4255_/Q VPWR VGND sg13cmos5l_dlygate4sd3_1
Xhold976 _3104_/A _4143_/Q VPWR VGND sg13cmos5l_dlygate4sd3_1
Xhold965 hold965/X _4082_/Q VPWR VGND sg13cmos5l_dlygate4sd3_1
X_3479_ _4207_/D _3561_/B _3569_/A VPWR VGND sg13cmos5l_nor2_1
XFILLER_0_139 VPWR VGND sg13cmos5l_decap_8
XFILLER_29_335 VPWR VGND sg13cmos5l_fill_1
XFILLER_45_817 VPWR VGND sg13cmos5l_decap_8
XFILLER_44_305 VPWR VGND sg13cmos5l_fill_1
XFILLER_12_279 VPWR VGND sg13cmos5l_decap_8
XFILLER_21_780 VPWR VGND sg13cmos5l_decap_8
XFILLER_5_946 VPWR VGND sg13cmos5l_decap_8
XFILLER_4_445 VPWR VGND sg13cmos5l_decap_8
XFILLER_0_640 VPWR VGND sg13cmos5l_decap_8
XFILLER_47_121 VPWR VGND sg13cmos5l_fill_2
XFILLER_36_817 VPWR VGND sg13cmos5l_fill_1
XFILLER_47_187 VPWR VGND sg13cmos5l_fill_2
XFILLER_44_883 VPWR VGND sg13cmos5l_decap_8
X_2850_ _2850_/Y _2817_/A _2857_/B _2848_/Y VPWR VGND sg13cmos5l_o21ai_1
X_2781_ _2781_/Y _2775_/C _2779_/Y _2774_/X VPWR VGND sg13cmos5l_o21ai_1
XFILLER_7_250 VPWR VGND sg13cmos5l_decap_4
XFILLER_8_784 VPWR VGND sg13cmos5l_fill_2
X_3402_ _3428_/B _3399_/Y _3401_/Y _3395_/Y VPWR VGND sg13cmos5l_o21ai_1
X_3333_ _3333_/Y _3338_/B _3338_/C VPWR VGND sg13cmos5l_nand2_1
XFILLER_22_0 VPWR VGND sg13cmos5l_fill_2
X_3264_ _3264_/Y _3226_/X _3262_/X _3169_/A VPWR VGND sg13cmos5l_a21oi_1
XFILLER_39_644 VPWR VGND sg13cmos5l_fill_1
X_2215_ _3214_/A _2215_/A VPWR VGND sg13cmos5l_inv_1
X_3195_ _3195_/Y hold861/X _3197_/S _3217_/B VPWR VGND sg13cmos5l_o21ai_1
XFILLER_39_688 VPWR VGND sg13cmos5l_decap_8
XFILLER_19_390 VPWR VGND sg13cmos5l_fill_1
XFILLER_35_861 VPWR VGND sg13cmos5l_decap_8
XFILLER_22_533 VPWR VGND sg13cmos5l_fill_1
XFILLER_14_37 VPWR VGND sg13cmos5l_decap_4
XFILLER_14_59 VPWR VGND sg13cmos5l_decap_4
XFILLER_22_566 VPWR VGND sg13cmos5l_decap_8
X_2979_ _2979_/Y _4108_/Q _4089_/Q VPWR VGND sg13cmos5l_nor2_1
XFILLER_2_905 VPWR VGND sg13cmos5l_decap_8
Xhold773 hold773/X _3947_/Q VPWR VGND sg13cmos5l_dlygate4sd3_1
Xhold751 hold751/X _3891_/Q VPWR VGND sg13cmos5l_dlygate4sd3_1
Xhold762 hold762/X _4007_/Q VPWR VGND sg13cmos5l_dlygate4sd3_1
Xhold740 hold740/X _3912_/Q VPWR VGND sg13cmos5l_dlygate4sd3_1
Xhold784 _4017_/D _2440_/Y VPWR VGND sg13cmos5l_dlygate4sd3_1
Xhold795 hold795/X _3970_/Q VPWR VGND sg13cmos5l_dlygate4sd3_1
XFILLER_49_419 VPWR VGND sg13cmos5l_decap_8
XFILLER_39_45 VPWR VGND sg13cmos5l_decap_8
XFILLER_39_34 VPWR VGND sg13cmos5l_fill_1
XFILLER_45_647 VPWR VGND sg13cmos5l_fill_1
XFILLER_29_198 VPWR VGND sg13cmos5l_decap_4
XFILLER_44_168 VPWR VGND sg13cmos5l_decap_8
XFILLER_26_872 VPWR VGND sg13cmos5l_decap_4
XFILLER_13_544 VPWR VGND sg13cmos5l_decap_8
XFILLER_41_875 VPWR VGND sg13cmos5l_decap_8
XFILLER_40_363 VPWR VGND sg13cmos5l_decap_8
XFILLER_40_385 VPWR VGND sg13cmos5l_decap_8
X_4206__429 _4206_/RESET_B VPWR VGND sg13cmos5l_tiehi
XFILLER_5_787 VPWR VGND sg13cmos5l_decap_8
XFILLER_4_253 VPWR VGND sg13cmos5l_fill_2
XFILLER_1_960 VPWR VGND sg13cmos5l_decap_8
XFILLER_49_975 VPWR VGND sg13cmos5l_decap_8
XFILLER_36_614 VPWR VGND sg13cmos5l_fill_2
X_3951_ _3951_/Q clkload6/A _3951_/D _3951_/RESET_B VPWR VGND sg13cmos5l_dfrbpq_1
XFILLER_17_872 VPWR VGND sg13cmos5l_fill_2
XFILLER_17_883 VPWR VGND sg13cmos5l_fill_2
X_4211__157 _4211_/D VPWR VGND sg13cmos5l_tielo
X_4031__245 _4031_/RESET_B VPWR VGND sg13cmos5l_tiehi
X_2902_ _2908_/B _2916_/A _2916_/B VPWR VGND sg13cmos5l_nand2_1
X_3882_ _3882_/Q clkload8/A _3882_/D _3882_/RESET_B VPWR VGND sg13cmos5l_dfrbpq_1
XFILLER_32_853 VPWR VGND sg13cmos5l_decap_8
X_2833_ _2845_/B _4066_/Q _2833_/B VPWR VGND sg13cmos5l_xor2_1
XFILLER_31_374 VPWR VGND sg13cmos5l_decap_4
X_2764_ _2764_/Y _4073_/Q _4054_/Q VPWR VGND sg13cmos5l_xnor2_1
XFILLER_8_581 VPWR VGND sg13cmos5l_fill_1
X_2695_ _2697_/A _2695_/A _2695_/B _2695_/C _2695_/D VPWR VGND sg13cmos5l_nor4_1
X_3316_ _3332_/B _4151_/Q _3320_/A VPWR VGND sg13cmos5l_nor2_1
X_3247_ _3247_/Y _3258_/A _3247_/B VPWR VGND sg13cmos5l_nor2_1
XFILLER_39_474 VPWR VGND sg13cmos5l_decap_8
X_3178_ _3178_/Y _4174_/Q _4170_/Q VPWR VGND sg13cmos5l_nor2b_1
XFILLER_27_669 VPWR VGND sg13cmos5l_decap_8
XFILLER_41_116 VPWR VGND sg13cmos5l_fill_2
XFILLER_35_680 VPWR VGND sg13cmos5l_decap_8
XFILLER_23_875 VPWR VGND sg13cmos5l_decap_8
XFILLER_10_503 VPWR VGND sg13cmos5l_fill_1
XFILLER_10_569 VPWR VGND sg13cmos5l_fill_1
XFILLER_22_396 VPWR VGND sg13cmos5l_fill_1
XFILLER_41_79 VPWR VGND sg13cmos5l_fill_1
XFILLER_2_724 VPWR VGND sg13cmos5l_fill_2
XFILLER_9_4 VPWR VGND sg13cmos5l_decap_8
XFILLER_2_779 VPWR VGND sg13cmos5l_decap_8
Xhold592 _2879_/B _4075_/Q VPWR VGND sg13cmos5l_dlygate4sd3_1
XFILLER_46_912 VPWR VGND sg13cmos5l_decap_8
XFILLER_46_989 VPWR VGND sg13cmos5l_decap_8
XFILLER_45_488 VPWR VGND sg13cmos5l_decap_8
XFILLER_33_606 VPWR VGND sg13cmos5l_fill_2
XFILLER_32_127 VPWR VGND sg13cmos5l_decap_8
XFILLER_41_661 VPWR VGND sg13cmos5l_decap_8
XFILLER_13_330 VPWR VGND sg13cmos5l_fill_1
XFILLER_12_1014 VPWR VGND sg13cmos5l_decap_8
X_2480_ _4032_/D _3680_/A _2194_/A _2479_/Y VPWR VGND sg13cmos5l_a21oi_1
XFILLER_31_90 VPWR VGND sg13cmos5l_fill_1
X_4150_ _4150_/Q _4205_/CLK _4150_/D _4150_/RESET_B VPWR VGND sg13cmos5l_dfrbpq_1
X_3101_ _3124_/A _4172_/Q _4171_/Q VPWR VGND sg13cmos5l_xnor2_1
X_4081_ _4081_/Q clkload9/A _4081_/D _4081_/RESET_B VPWR VGND sg13cmos5l_dfrbpq_1
XFILLER_49_772 VPWR VGND sg13cmos5l_decap_8
X_3032_ _3032_/Y _3032_/A _3032_/B VPWR VGND sg13cmos5l_nand2_1
XFILLER_37_945 VPWR VGND sg13cmos5l_decap_8
XFILLER_36_477 VPWR VGND sg13cmos5l_fill_1
XFILLER_36_499 VPWR VGND sg13cmos5l_decap_8
X_3934_ _3934_/Q clkload7/A _3934_/D _3934_/RESET_B VPWR VGND sg13cmos5l_dfrbpq_1
X_3865_ _3894_/D _3865_/A0 hold670/X _3873_/S VPWR VGND sg13cmos5l_mux2_1
XFILLER_20_823 VPWR VGND sg13cmos5l_fill_2
X_2816_ _4085_/D _2885_/B _2887_/A VPWR VGND sg13cmos5l_nor2_1
XFILLER_31_182 VPWR VGND sg13cmos5l_decap_4
X_3796_ _3796_/Y _3740_/Y _3787_/X _3803_/A _3803_/B VPWR VGND sg13cmos5l_a22oi_1
XFILLER_20_889 VPWR VGND sg13cmos5l_fill_2
X_2747_ _2747_/Y _2857_/B _2743_/Y _2746_/Y VPWR VGND sg13cmos5l_a21oi_1
XFILLER_11_38 VPWR VGND sg13cmos5l_decap_8
X_2678_ _2679_/A _4003_/Q _3986_/Q _3969_/Q _3952_/Q _2668_/A _2678_/S1 VPWR VGND
+ sg13cmos5l_mux4_1
XFILLER_47_709 VPWR VGND sg13cmos5l_decap_8
X_4279_ _4279_/Q clkload3/A _4279_/D _4279_/RESET_B VPWR VGND sg13cmos5l_dfrbpq_1
XFILLER_27_400 VPWR VGND sg13cmos5l_decap_8
XFILLER_27_411 VPWR VGND sg13cmos5l_fill_1
XFILLER_39_293 VPWR VGND sg13cmos5l_decap_8
XFILLER_43_926 VPWR VGND sg13cmos5l_decap_8
XFILLER_27_477 VPWR VGND sg13cmos5l_decap_8
XFILLER_11_812 VPWR VGND sg13cmos5l_decap_8
XFILLER_23_672 VPWR VGND sg13cmos5l_fill_1
XFILLER_6_337 VPWR VGND sg13cmos5l_fill_1
XFILLER_37_208 VPWR VGND sg13cmos5l_fill_1
XFILLER_46_786 VPWR VGND sg13cmos5l_decap_8
XFILLER_34_948 VPWR VGND sg13cmos5l_decap_8
XFILLER_21_609 VPWR VGND sg13cmos5l_fill_1
XFILLER_33_447 VPWR VGND sg13cmos5l_fill_1
XFILLER_9_142 VPWR VGND sg13cmos5l_fill_1
XFILLER_13_182 VPWR VGND sg13cmos5l_decap_4
XFILLER_14_694 VPWR VGND sg13cmos5l_decap_8
X_3650_ _3651_/B hold967/X _3649_/Y _3659_/A VPWR VGND sg13cmos5l_mux2_1
XFILLER_9_153 VPWR VGND sg13cmos5l_decap_8
X_2601_ _2601_/Y _2603_/A _3932_/Q VPWR VGND sg13cmos5l_nand2b_1
X_3581_ _3602_/A _4231_/Q _3591_/B _3595_/A VPWR VGND sg13cmos5l_a21o_1
XFILLER_6_882 VPWR VGND sg13cmos5l_fill_1
XFILLER_6_871 VPWR VGND sg13cmos5l_decap_8
X_2532_ _2532_/Y _2526_/B _2531_/Y _2535_/C VPWR VGND sg13cmos5l_a21oi_1
XFILLER_5_381 VPWR VGND sg13cmos5l_decap_8
X_2463_ _2464_/C _2463_/A _2463_/B _2463_/C VPWR VGND sg13cmos5l_or3_1
X_4202_ _4202_/Q _4205_/CLK _4202_/D _4202_/RESET_B VPWR VGND sg13cmos5l_dfrbpq_1
X_2394_ _3988_/D _2414_/A0 hold685/X _2401_/S VPWR VGND sg13cmos5l_mux2_1
XFILLER_3_72 VPWR VGND sg13cmos5l_fill_1
X_4133_ _4133_/Q _4193_/CLK _4133_/D _4133_/RESET_B VPWR VGND sg13cmos5l_dfrbpq_1
X_4064_ _4064_/Q clkload8/A _4064_/D _4064_/RESET_B VPWR VGND sg13cmos5l_dfrbpq_1
X_3015_ _3015_/Y _3016_/C _3014_/Y _3013_/Y VPWR VGND sg13cmos5l_a21oi_1
XFILLER_24_403 VPWR VGND sg13cmos5l_decap_8
XFILLER_36_241 VPWR VGND sg13cmos5l_fill_1
XFILLER_24_414 VPWR VGND sg13cmos5l_fill_2
XFILLER_36_274 VPWR VGND sg13cmos5l_decap_8
XFILLER_24_447 VPWR VGND sg13cmos5l_fill_1
X_3917_ _3917_/Q clkload7/A _3917_/D _3917_/RESET_B VPWR VGND sg13cmos5l_dfrbpq_1
X_3848_ _3878_/D hold786/X _3866_/A0 _3854_/S VPWR VGND sg13cmos5l_mux2_1
X_3779_ _3780_/C _3779_/A _3779_/B VPWR VGND sg13cmos5l_or2_1
Xfanout121 _2487_/B1 _2519_/A VPWR VGND sg13cmos5l_buf_1
Xfanout110 _2413_/A0 input6/X VPWR VGND sg13cmos5l_buf_1
Xfanout132 _3212_/A _3556_/A VPWR VGND sg13cmos5l_buf_1
XFILLER_47_539 VPWR VGND sg13cmos5l_decap_8
XFILLER_28_731 VPWR VGND sg13cmos5l_decap_8
XFILLER_27_274 VPWR VGND sg13cmos5l_decap_8
XFILLER_24_970 VPWR VGND sg13cmos5l_fill_2
XFILLER_7_624 VPWR VGND sg13cmos5l_decap_8
XFILLER_7_613 VPWR VGND sg13cmos5l_decap_8
XFILLER_7_646 VPWR VGND sg13cmos5l_fill_2
XFILLER_7_635 VPWR VGND sg13cmos5l_fill_2
XFILLER_10_174 VPWR VGND sg13cmos5l_decap_4
XFILLER_7_668 VPWR VGND sg13cmos5l_decap_8
XFILLER_6_156 VPWR VGND sg13cmos5l_fill_1
XFILLER_3_874 VPWR VGND sg13cmos5l_decap_8
XFILLER_2_362 VPWR VGND sg13cmos5l_decap_8
XFILLER_2_395 VPWR VGND sg13cmos5l_decap_8
X_3897__546 _3897_/RESET_B VPWR VGND sg13cmos5l_tiehi
XFILLER_18_241 VPWR VGND sg13cmos5l_decap_8
XFILLER_34_723 VPWR VGND sg13cmos5l_decap_4
XFILLER_33_244 VPWR VGND sg13cmos5l_decap_4
XFILLER_15_981 VPWR VGND sg13cmos5l_decap_8
XFILLER_33_266 VPWR VGND sg13cmos5l_decap_4
X_3702_ _3702_/Y _3702_/A _3702_/B VPWR VGND sg13cmos5l_nand2_1
X_3633_ _3640_/B _4242_/Q _4241_/Q _4239_/Q _4240_/Q VPWR VGND sg13cmos5l_nor4_1
X_3564_ _3565_/C _3589_/A _3564_/B VPWR VGND sg13cmos5l_nor2_1
X_3495_ _3495_/X _3500_/B _3500_/C _3500_/A VPWR VGND sg13cmos5l_a21o_1
X_2515_ _2515_/Y _2422_/B _2516_/A _2514_/Y VPWR VGND sg13cmos5l_a21oi_1
X_2446_ _2446_/Y _2434_/A _4020_/Q _2435_/B hold790/X VPWR VGND sg13cmos5l_a22oi_1
X_4116_ _4116_/Q _4168_/CLK _4116_/D _4116_/RESET_B VPWR VGND sg13cmos5l_dfrbpq_1
X_2377_ _3974_/D _2417_/A0 hold662/X _2381_/S VPWR VGND sg13cmos5l_mux2_1
X_4047_ _4047_/Q clkload9/A _4047_/D _4047_/RESET_B VPWR VGND sg13cmos5l_dfrbpq_1
XFILLER_13_918 VPWR VGND sg13cmos5l_fill_1
XFILLER_24_233 VPWR VGND sg13cmos5l_fill_1
XFILLER_25_745 VPWR VGND sg13cmos5l_decap_8
XFILLER_40_704 VPWR VGND sg13cmos5l_decap_8
XFILLER_24_255 VPWR VGND sg13cmos5l_decap_8
XFILLER_33_36 VPWR VGND sg13cmos5l_fill_1
XFILLER_33_58 VPWR VGND sg13cmos5l_decap_8
XFILLER_21_973 VPWR VGND sg13cmos5l_decap_8
XFILLER_20_461 VPWR VGND sg13cmos5l_fill_2
XFILLER_20_472 VPWR VGND sg13cmos5l_decap_8
XFILLER_3_115 VPWR VGND sg13cmos5l_decap_8
XFILLER_0_844 VPWR VGND sg13cmos5l_decap_8
XFILLER_48_804 VPWR VGND sg13cmos5l_decap_8
XFILLER_47_336 VPWR VGND sg13cmos5l_decap_4
XFILLER_47_369 VPWR VGND sg13cmos5l_decap_8
XFILLER_16_723 VPWR VGND sg13cmos5l_fill_2
XFILLER_28_572 VPWR VGND sg13cmos5l_fill_1
XFILLER_15_277 VPWR VGND sg13cmos5l_fill_1
XFILLER_30_203 VPWR VGND sg13cmos5l_fill_1
XFILLER_8_911 VPWR VGND sg13cmos5l_decap_4
XFILLER_12_951 VPWR VGND sg13cmos5l_decap_8
XFILLER_8_955 VPWR VGND sg13cmos5l_decap_8
X_3280_ _3280_/Y _4202_/Q _4175_/Q VPWR VGND sg13cmos5l_nand2_1
X_2300_ _3909_/D _3863_/A0 hold696/X _2301_/S VPWR VGND sg13cmos5l_mux2_1
X_2231_ _2857_/B _2231_/A VPWR VGND sg13cmos5l_inv_1
X_2162_ _2162_/Y _2162_/A VPWR VGND sg13cmos5l_inv_1
XFILLER_0_1026 VPWR VGND sg13cmos5l_fill_2
XFILLER_22_704 VPWR VGND sg13cmos5l_decap_8
XFILLER_34_586 VPWR VGND sg13cmos5l_decap_4
X_2995_ _3048_/D _3045_/A _2995_/B _2995_/C _2995_/D VPWR VGND sg13cmos5l_nand4_1
X_3616_ _4237_/D _3599_/X _3604_/A _3540_/A VPWR VGND sg13cmos5l_a21oi_1
Xhold900 _4186_/D _3375_/Y VPWR VGND sg13cmos5l_dlygate4sd3_1
Xhold922 hold922/X _4272_/Q VPWR VGND sg13cmos5l_dlygate4sd3_1
Xhold911 _3390_/A _4170_/Q VPWR VGND sg13cmos5l_dlygate4sd3_1
Xhold933 hold933/X _4059_/Q VPWR VGND sg13cmos5l_dlygate4sd3_1
X_3547_ _4222_/D _3547_/A _3547_/B VPWR VGND sg13cmos5l_and2_1
X_4041__225 _4041_/RESET_B VPWR VGND sg13cmos5l_tiehi
Xhold944 _2869_/B _2868_/X VPWR VGND sg13cmos5l_dlygate4sd3_1
Xhold955 _2916_/A _4104_/Q VPWR VGND sg13cmos5l_dlygate4sd3_1
Xhold966 _2702_/A _4062_/Q VPWR VGND sg13cmos5l_dlygate4sd3_1
Xhold988 _3297_/A _4179_/Q VPWR VGND sg13cmos5l_dlygate4sd3_1
Xhold977 _3120_/B _3119_/X VPWR VGND sg13cmos5l_dlygate4sd3_1
X_3478_ _3569_/A _3468_/B _3477_/Y _3483_/S VPWR VGND sg13cmos5l_mux2_1
Xhold999 hold999/X _4238_/Q VPWR VGND sg13cmos5l_dlygate4sd3_1
X_2429_ _2430_/B _2429_/A _2429_/B _2452_/B VPWR VGND sg13cmos5l_nand3_1
X_4273__558 _4273_/RESET_B VPWR VGND sg13cmos5l_tiehi
XFILLER_44_339 VPWR VGND sg13cmos5l_decap_8
X_4236__391 _4236_/RESET_B VPWR VGND sg13cmos5l_tiehi
XFILLER_37_380 VPWR VGND sg13cmos5l_decap_4
XFILLER_25_520 VPWR VGND sg13cmos5l_fill_2
XFILLER_13_726 VPWR VGND sg13cmos5l_decap_8
XFILLER_25_586 VPWR VGND sg13cmos5l_decap_4
XFILLER_40_512 VPWR VGND sg13cmos5l_decap_8
XFILLER_13_748 VPWR VGND sg13cmos5l_decap_8
XFILLER_9_719 VPWR VGND sg13cmos5l_fill_2
X_3883__409 _3883_/RESET_B VPWR VGND sg13cmos5l_tiehi
XFILLER_5_925 VPWR VGND sg13cmos5l_decap_8
XFILLER_4_424 VPWR VGND sg13cmos5l_decap_8
XFILLER_0_674 VPWR VGND sg13cmos5l_decap_8
XFILLER_0_685 VPWR VGND sg13cmos5l_fill_1
X_4215__420 _4215_/RESET_B VPWR VGND sg13cmos5l_tiehi
XFILLER_47_166 VPWR VGND sg13cmos5l_decap_8
XFILLER_44_862 VPWR VGND sg13cmos5l_decap_8
XFILLER_16_564 VPWR VGND sg13cmos5l_decap_4
XFILLER_16_597 VPWR VGND sg13cmos5l_decap_8
X_2780_ _2780_/Y _2775_/C _2779_/Y _2772_/Y VPWR VGND sg13cmos5l_a21oi_1
XFILLER_15_1023 VPWR VGND sg13cmos5l_decap_4
XFILLER_8_796 VPWR VGND sg13cmos5l_decap_4
X_3401_ _3401_/Y _3311_/B _3428_/A _3400_/Y VPWR VGND sg13cmos5l_o21ai_1
XFILLER_4_980 VPWR VGND sg13cmos5l_decap_8
X_3332_ _3338_/C _4152_/Q _3332_/B VPWR VGND sg13cmos5l_xnor2_1
XFILLER_3_490 VPWR VGND sg13cmos5l_decap_8
X_3263_ _3265_/A _3249_/A _3247_/Y _3262_/X VPWR VGND sg13cmos5l_a21oi_1
X_3194_ _3197_/S _3193_/Y _3194_/B VPWR VGND sg13cmos5l_nand2b_1
X_2214_ _2530_/C _4045_/Q VPWR VGND sg13cmos5l_inv_1
XFILLER_38_166 VPWR VGND sg13cmos5l_decap_8
XFILLER_35_840 VPWR VGND sg13cmos5l_decap_8
XFILLER_41_309 VPWR VGND sg13cmos5l_decap_8
XFILLER_35_884 VPWR VGND sg13cmos5l_decap_8
X_2978_ _2994_/B _4089_/Q _4090_/Q VPWR VGND sg13cmos5l_xnor2_1
Xhold730 hold730/X _3917_/Q VPWR VGND sg13cmos5l_dlygate4sd3_1
Xhold741 hold741/X _3885_/Q VPWR VGND sg13cmos5l_dlygate4sd3_1
Xhold752 _3891_/D _3862_/X VPWR VGND sg13cmos5l_dlygate4sd3_1
Xhold763 hold763/X _3977_/Q VPWR VGND sg13cmos5l_dlygate4sd3_1
Xhold785 hold785/X _3998_/Q VPWR VGND sg13cmos5l_dlygate4sd3_1
Xhold774 hold774/X _3995_/Q VPWR VGND sg13cmos5l_dlygate4sd3_1
Xhold796 hold796/X _3944_/Q VPWR VGND sg13cmos5l_dlygate4sd3_1
XFILLER_45_615 VPWR VGND sg13cmos5l_fill_1
XFILLER_17_306 VPWR VGND sg13cmos5l_fill_1
XFILLER_17_328 VPWR VGND sg13cmos5l_decap_8
XFILLER_29_177 VPWR VGND sg13cmos5l_decap_8
XFILLER_38_1012 VPWR VGND sg13cmos5l_decap_8
XFILLER_13_501 VPWR VGND sg13cmos5l_fill_1
XFILLER_26_895 VPWR VGND sg13cmos5l_fill_2
XFILLER_41_854 VPWR VGND sg13cmos5l_decap_8
XFILLER_9_527 VPWR VGND sg13cmos5l_decap_8
XFILLER_9_549 VPWR VGND sg13cmos5l_fill_2
XFILLER_13_578 VPWR VGND sg13cmos5l_fill_1
XFILLER_5_766 VPWR VGND sg13cmos5l_decap_8
XFILLER_4_232 VPWR VGND sg13cmos5l_decap_8
XFILLER_45_1027 VPWR VGND sg13cmos5l_fill_2
XFILLER_49_954 VPWR VGND sg13cmos5l_decap_8
XFILLER_48_453 VPWR VGND sg13cmos5l_fill_2
XFILLER_35_147 VPWR VGND sg13cmos5l_decap_8
X_3950_ _3950_/Q clkload6/A _3950_/D _3950_/RESET_B VPWR VGND sg13cmos5l_dfrbpq_1
X_4250__152 _4250_/D VPWR VGND sg13cmos5l_tielo
XFILLER_35_158 VPWR VGND sg13cmos5l_fill_1
XFILLER_16_394 VPWR VGND sg13cmos5l_fill_1
XFILLER_32_821 VPWR VGND sg13cmos5l_decap_4
X_2901_ _2908_/A _4106_/Q _2916_/B VPWR VGND sg13cmos5l_xnor2_1
XFILLER_43_191 VPWR VGND sg13cmos5l_decap_8
XFILLER_43_180 VPWR VGND sg13cmos5l_decap_8
X_3881_ _3881_/Q clkload7/A _3881_/D _3881_/RESET_B VPWR VGND sg13cmos5l_dfrbpq_1
XFILLER_31_331 VPWR VGND sg13cmos5l_fill_1
XFILLER_31_353 VPWR VGND sg13cmos5l_decap_8
XFILLER_32_865 VPWR VGND sg13cmos5l_decap_8
XFILLER_32_876 VPWR VGND sg13cmos5l_fill_1
X_2832_ _2835_/A _2704_/Y _2845_/A _2831_/Y VPWR VGND sg13cmos5l_o21ai_1
X_2763_ _2763_/Y _4072_/Q _4053_/Q VPWR VGND sg13cmos5l_xnor2_1
X_4068__191 _4068_/RESET_B VPWR VGND sg13cmos5l_tiehi
X_2694_ _2695_/D _2692_/A _2692_/B _2190_/Y VPWR VGND sg13cmos5l_a21o_1
X_3315_ _3320_/A _4150_/Q _4149_/Q _4148_/Q VPWR VGND sg13cmos5l_or3_1
XFILLER_6_1010 VPWR VGND sg13cmos5l_decap_8
X_3246_ _3247_/B _3246_/A _3246_/B VPWR VGND sg13cmos5l_nor2_1
X_4157__484 _4157_/RESET_B VPWR VGND sg13cmos5l_tiehi
X_3177_ _3181_/C _4174_/Q _3032_/A _3180_/B VPWR VGND sg13cmos5l_o21ai_1
XFILLER_27_604 VPWR VGND sg13cmos5l_fill_2
XFILLER_27_615 VPWR VGND sg13cmos5l_decap_8
XFILLER_39_497 VPWR VGND sg13cmos5l_decap_8
X_4116__170 _4116_/D VPWR VGND sg13cmos5l_tielo
X_4233__394 _4233_/RESET_B VPWR VGND sg13cmos5l_tiehi
XFILLER_41_106 VPWR VGND sg13cmos5l_decap_4
XFILLER_35_692 VPWR VGND sg13cmos5l_decap_8
XFILLER_6_519 VPWR VGND sg13cmos5l_decap_8
X_4205__430 _4205_/RESET_B VPWR VGND sg13cmos5l_tiehi
XFILLER_2_758 VPWR VGND sg13cmos5l_decap_8
Xhold593 _3210_/B _4131_/Q VPWR VGND sg13cmos5l_dlygate4sd3_1
XFILLER_46_968 VPWR VGND sg13cmos5l_decap_8
X_4212__423 _4212_/RESET_B VPWR VGND sg13cmos5l_tiehi
XFILLER_14_854 VPWR VGND sg13cmos5l_decap_8
XFILLER_41_695 VPWR VGND sg13cmos5l_decap_4
XFILLER_41_684 VPWR VGND sg13cmos5l_fill_1
XFILLER_13_386 VPWR VGND sg13cmos5l_fill_2
XFILLER_9_357 VPWR VGND sg13cmos5l_decap_8
XFILLER_13_397 VPWR VGND sg13cmos5l_decap_4
XFILLER_9_379 VPWR VGND sg13cmos5l_decap_8
X_3100_ _3108_/B _4143_/Q _4144_/Q _3100_/B1 VPWR VGND sg13cmos5l_o21ai_1
XFILLER_49_751 VPWR VGND sg13cmos5l_decap_8
XFILLER_0_290 VPWR VGND sg13cmos5l_decap_4
X_4080_ _4080_/Q clkload9/A _4080_/D _4080_/RESET_B VPWR VGND sg13cmos5l_dfrbpq_1
XFILLER_37_924 VPWR VGND sg13cmos5l_decap_8
X_3031_ _3031_/Y _3011_/Y _3025_/Y _3030_/Y VPWR VGND sg13cmos5l_a21oi_1
XFILLER_17_681 VPWR VGND sg13cmos5l_decap_8
X_3933_ _3933_/Q clkload8/A _3933_/D _3933_/RESET_B VPWR VGND sg13cmos5l_dfrbpq_1
XFILLER_16_180 VPWR VGND sg13cmos5l_fill_1
XFILLER_16_191 VPWR VGND sg13cmos5l_fill_2
X_3864_ _3893_/D input5/X hold804/X _3864_/S VPWR VGND sg13cmos5l_mux2_1
XFILLER_32_662 VPWR VGND sg13cmos5l_fill_1
X_2815_ _2887_/A _2800_/Y _2818_/S hold932/X VPWR VGND sg13cmos5l_a21oi_1
X_3795_ _3803_/B _3778_/B _3657_/B _3795_/S VPWR VGND sg13cmos5l_mux2_1
XFILLER_20_879 VPWR VGND sg13cmos5l_decap_4
X_2746_ _2746_/Y _2740_/B _2743_/Y _2761_/B VPWR VGND sg13cmos5l_o21ai_1
XFILLER_9_891 VPWR VGND sg13cmos5l_decap_8
X_2677_ _2677_/X _3935_/Q _3918_/Q _3901_/Q _3884_/Q _2677_/S0 _2677_/S1 VPWR VGND
+ sg13cmos5l_mux4_1
XFILLER_28_1011 VPWR VGND sg13cmos5l_decap_8
X_4278_ _4278_/Q _4278_/CLK _4278_/D _4278_/RESET_B VPWR VGND sg13cmos5l_dfrbpq_1
X_3229_ _3229_/Y _4160_/Q _4132_/Q VPWR VGND sg13cmos5l_xnor2_1
XFILLER_39_272 VPWR VGND sg13cmos5l_decap_8
XFILLER_43_905 VPWR VGND sg13cmos5l_decap_8
XFILLER_36_69 VPWR VGND sg13cmos5l_decap_8
X_3988__303 _3988_/RESET_B VPWR VGND sg13cmos5l_tiehi
XFILLER_35_1026 VPWR VGND sg13cmos5l_fill_2
XFILLER_7_839 VPWR VGND sg13cmos5l_decap_8
XFILLER_10_356 VPWR VGND sg13cmos5l_fill_2
XFILLER_11_868 VPWR VGND sg13cmos5l_fill_2
XFILLER_2_533 VPWR VGND sg13cmos5l_decap_8
XFILLER_2_500 VPWR VGND sg13cmos5l_fill_1
XFILLER_19_935 VPWR VGND sg13cmos5l_fill_2
XFILLER_46_765 VPWR VGND sg13cmos5l_decap_8
XFILLER_18_456 VPWR VGND sg13cmos5l_fill_1
XFILLER_34_927 VPWR VGND sg13cmos5l_decap_8
XFILLER_33_415 VPWR VGND sg13cmos5l_fill_2
XFILLER_42_982 VPWR VGND sg13cmos5l_decap_8
XFILLER_14_651 VPWR VGND sg13cmos5l_fill_2
XFILLER_41_481 VPWR VGND sg13cmos5l_decap_4
XFILLER_42_90 VPWR VGND sg13cmos5l_fill_1
X_2600_ _2606_/B _2596_/Y _2597_/Y _2599_/Y _2678_/S1 _2680_/A1 VPWR VGND sg13cmos5l_a221oi_1
X_3580_ _3595_/A _3594_/A _3594_/B _3594_/C VPWR VGND sg13cmos5l_a21oi_1
X_4065__194 _4065_/RESET_B VPWR VGND sg13cmos5l_tiehi
X_4147__494 _4147_/RESET_B VPWR VGND sg13cmos5l_tiehi
X_2531_ _2531_/Y _4043_/Q _2535_/A VPWR VGND sg13cmos5l_nor2_1
X_2462_ _2464_/B _2463_/A _2463_/B _2463_/C VPWR VGND sg13cmos5l_o21ai_1
X_4201_ _4201_/Q _4205_/CLK _4201_/D _4201_/RESET_B VPWR VGND sg13cmos5l_dfrbpq_1
X_2393_ _3987_/D _2413_/A0 hold731/X _2401_/S VPWR VGND sg13cmos5l_mux2_1
X_4132_ _4132_/Q _4193_/CLK _4132_/D _4132_/RESET_B VPWR VGND sg13cmos5l_dfrbpq_1
X_4063_ _4063_/Q clkload8/A _4063_/D _4063_/RESET_B VPWR VGND sg13cmos5l_dfrbpq_1
X_3014_ _3014_/Y _3214_/A _3217_/A VPWR VGND sg13cmos5l_nor2_1
X_4154__487 _4154_/RESET_B VPWR VGND sg13cmos5l_tiehi
XFILLER_18_990 VPWR VGND sg13cmos5l_decap_8
X_4072__187 _4072_/RESET_B VPWR VGND sg13cmos5l_tiehi
XFILLER_36_297 VPWR VGND sg13cmos5l_fill_1
X_3916_ _3916_/Q clkload8/A _3916_/D _3916_/RESET_B VPWR VGND sg13cmos5l_dfrbpq_1
X_4230__397 _4230_/RESET_B VPWR VGND sg13cmos5l_tiehi
XFILLER_20_632 VPWR VGND sg13cmos5l_fill_1
XFILLER_32_481 VPWR VGND sg13cmos5l_fill_2
XFILLER_32_492 VPWR VGND sg13cmos5l_fill_2
X_3847_ _3877_/D hold750/X _3865_/A0 _3854_/S VPWR VGND sg13cmos5l_mux2_1
X_3778_ _3780_/B _3657_/B _3778_/B VPWR VGND sg13cmos5l_nand2b_1
X_2729_ _2729_/Y _4046_/Q _2729_/B VPWR VGND sg13cmos5l_nor2_1
XFILLER_3_308 VPWR VGND sg13cmos5l_decap_8
X_4259__209 _4259_/RESET_B VPWR VGND sg13cmos5l_tiehi
X_4202__433 _4202_/RESET_B VPWR VGND sg13cmos5l_tiehi
Xfanout111 _3865_/A0 input6/X VPWR VGND sg13cmos5l_buf_1
Xfanout100 _3874_/A _3617_/B VPWR VGND sg13cmos5l_buf_1
Xfanout122 _2519_/A _3704_/A VPWR VGND sg13cmos5l_buf_1
Xfanout133 _3556_/A input1/X VPWR VGND sg13cmos5l_buf_1
XFILLER_47_518 VPWR VGND sg13cmos5l_decap_8
XFILLER_47_35 VPWR VGND sg13cmos5l_decap_8
XFILLER_16_916 VPWR VGND sg13cmos5l_decap_8
XFILLER_27_242 VPWR VGND sg13cmos5l_decap_8
XFILLER_27_253 VPWR VGND sg13cmos5l_fill_1
XFILLER_28_754 VPWR VGND sg13cmos5l_fill_1
XFILLER_43_735 VPWR VGND sg13cmos5l_decap_8
XFILLER_16_949 VPWR VGND sg13cmos5l_decap_4
XFILLER_8_29 VPWR VGND sg13cmos5l_decap_8
XFILLER_23_470 VPWR VGND sg13cmos5l_decap_8
XFILLER_23_481 VPWR VGND sg13cmos5l_fill_1
XFILLER_10_131 VPWR VGND sg13cmos5l_fill_2
XFILLER_6_113 VPWR VGND sg13cmos5l_decap_8
XFILLER_12_71 VPWR VGND sg13cmos5l_decap_8
XFILLER_3_853 VPWR VGND sg13cmos5l_decap_8
XFILLER_2_352 VPWR VGND sg13cmos5l_fill_1
XFILLER_19_754 VPWR VGND sg13cmos5l_fill_1
XFILLER_46_595 VPWR VGND sg13cmos5l_fill_2
XFILLER_34_746 VPWR VGND sg13cmos5l_decap_4
XFILLER_22_919 VPWR VGND sg13cmos5l_decap_8
XFILLER_21_429 VPWR VGND sg13cmos5l_fill_1
X_3701_ _4248_/D _3690_/A _3698_/S hold846/X VPWR VGND sg13cmos5l_a21oi_1
X_3632_ _3658_/A _3632_/A VPWR VGND sg13cmos5l_inv_1
X_3563_ _3565_/B _3563_/A _3563_/B VPWR VGND sg13cmos5l_nor2_1
X_3494_ _3494_/Y _3500_/B _3500_/C VPWR VGND sg13cmos5l_nand2_1
X_2514_ _2514_/Y _2422_/B _2513_/Y _3704_/A VPWR VGND sg13cmos5l_o21ai_1
X_2445_ _4019_/D _3874_/A _2445_/B VPWR VGND sg13cmos5l_nor2_1
X_4160__480 _4160_/RESET_B VPWR VGND sg13cmos5l_tiehi
X_3978__313 _3978_/RESET_B VPWR VGND sg13cmos5l_tiehi
X_2376_ _3973_/D _2416_/A0 hold736/X _2381_/S VPWR VGND sg13cmos5l_mux2_1
X_4115_ _4115_/Q _4168_/CLK _4115_/D _4115_/RESET_B VPWR VGND sg13cmos5l_dfrbpq_1
X_4046_ _4046_/Q clkload9/A _4046_/D _4046_/RESET_B VPWR VGND sg13cmos5l_dfrbpq_1
XFILLER_17_16 VPWR VGND sg13cmos5l_fill_1
X_3985__306 _3985_/RESET_B VPWR VGND sg13cmos5l_tiehi
XFILLER_3_149 VPWR VGND sg13cmos5l_fill_1
XFILLER_0_823 VPWR VGND sg13cmos5l_decap_8
XFILLER_47_359 VPWR VGND sg13cmos5l_fill_1
XFILLER_28_540 VPWR VGND sg13cmos5l_fill_2
XFILLER_16_702 VPWR VGND sg13cmos5l_decap_8
XFILLER_16_757 VPWR VGND sg13cmos5l_fill_2
XFILLER_16_779 VPWR VGND sg13cmos5l_decap_8
XFILLER_30_226 VPWR VGND sg13cmos5l_decap_8
XFILLER_8_901 VPWR VGND sg13cmos5l_fill_1
XFILLER_8_934 VPWR VGND sg13cmos5l_decap_8
XFILLER_11_495 VPWR VGND sg13cmos5l_decap_8
XFILLER_48_1014 VPWR VGND sg13cmos5l_decap_8
X_4144__497 _4144_/RESET_B VPWR VGND sg13cmos5l_tiehi
X_4062__197 _4062_/RESET_B VPWR VGND sg13cmos5l_tiehi
X_2230_ _2230_/Y _4069_/Q VPWR VGND sg13cmos5l_inv_1
XFILLER_2_182 VPWR VGND sg13cmos5l_fill_1
X_2161_ _2161_/Y _4225_/Q VPWR VGND sg13cmos5l_inv_1
XFILLER_47_882 VPWR VGND sg13cmos5l_decap_8
XFILLER_0_1005 VPWR VGND sg13cmos5l_decap_8
XFILLER_19_573 VPWR VGND sg13cmos5l_fill_1
XFILLER_0_63 VPWR VGND sg13cmos5l_fill_1
X_2994_ _3048_/C _2994_/A _2994_/B _2994_/C VPWR VGND sg13cmos5l_nand3_1
XFILLER_22_738 VPWR VGND sg13cmos5l_fill_1
X_3615_ _4236_/D _3597_/B _3608_/Y _3614_/Y VPWR VGND sg13cmos5l_a21oi_1
Xhold912 hold912/X _4219_/Q VPWR VGND sg13cmos5l_dlygate4sd3_1
Xhold901 hold901/X _4155_/Q VPWR VGND sg13cmos5l_dlygate4sd3_1
X_3546_ _4220_/D _3537_/B hold884/X _3540_/A VPWR VGND sg13cmos5l_a21oi_1
Xhold923 hold923/X _2495_/B VPWR VGND sg13cmos5l_dlygate4sd3_1
Xhold934 _2498_/B _4279_/Q VPWR VGND sg13cmos5l_dlygate4sd3_1
Xhold945 hold945/X _4030_/Q VPWR VGND sg13cmos5l_dlygate4sd3_1
Xhold978 hold978/X _4112_/Q VPWR VGND sg13cmos5l_dlygate4sd3_1
Xhold956 hold956/X _2922_/Y VPWR VGND sg13cmos5l_dlygate4sd3_1
Xhold989 _3305_/C _3301_/C VPWR VGND sg13cmos5l_dlygate4sd3_1
Xhold967 hold967/X _4239_/Q VPWR VGND sg13cmos5l_dlygate4sd3_1
X_3477_ _3477_/Y _3769_/A _3480_/B VPWR VGND sg13cmos5l_nand2_1
X_2428_ _2428_/Y _4026_/Q _2452_/B _2429_/A VPWR VGND sg13cmos5l_a21oi_1
X_2359_ _3959_/D _2419_/A0 hold744/X _2361_/S VPWR VGND sg13cmos5l_mux2_1
XFILLER_28_48 VPWR VGND sg13cmos5l_decap_4
XFILLER_44_318 VPWR VGND sg13cmos5l_fill_2
X_4029_ _4029_/Q clkload2/A _4029_/D _4029_/RESET_B VPWR VGND sg13cmos5l_dfrbpq_1
XFILLER_25_554 VPWR VGND sg13cmos5l_fill_2
XFILLER_25_565 VPWR VGND sg13cmos5l_decap_8
XFILLER_40_579 VPWR VGND sg13cmos5l_fill_1
XFILLER_40_568 VPWR VGND sg13cmos5l_decap_8
XFILLER_4_403 VPWR VGND sg13cmos5l_fill_1
XFILLER_0_653 VPWR VGND sg13cmos5l_decap_8
XFILLER_0_697 VPWR VGND sg13cmos5l_decap_8
XFILLER_47_123 VPWR VGND sg13cmos5l_fill_1
XFILLER_47_189 VPWR VGND sg13cmos5l_fill_1
XFILLER_16_543 VPWR VGND sg13cmos5l_decap_8
XFILLER_28_370 VPWR VGND sg13cmos5l_decap_4
XFILLER_29_893 VPWR VGND sg13cmos5l_decap_8
XFILLER_43_384 VPWR VGND sg13cmos5l_decap_8
XFILLER_15_1002 VPWR VGND sg13cmos5l_decap_8
XFILLER_31_568 VPWR VGND sg13cmos5l_decap_8
X_3968__323 _3968_/RESET_B VPWR VGND sg13cmos5l_tiehi
XFILLER_7_296 VPWR VGND sg13cmos5l_decap_8
X_3400_ _3400_/Y _3432_/B _3432_/A VPWR VGND sg13cmos5l_nand2b_1
X_3331_ _3343_/C _4152_/Q _3332_/B VPWR VGND sg13cmos5l_xor2_1
X_3262_ _3262_/X _3254_/X _3259_/Y _3261_/Y VPWR VGND sg13cmos5l_a21o_1
XFILLER_39_613 VPWR VGND sg13cmos5l_decap_8
XFILLER_38_112 VPWR VGND sg13cmos5l_decap_4
X_2213_ _3715_/A _3531_/A VPWR VGND sg13cmos5l_inv_1
X_3193_ _3193_/Y _3201_/B _3190_/Y _3201_/A VPWR VGND sg13cmos5l_o21ai_1
XFILLER_38_145 VPWR VGND sg13cmos5l_decap_8
XFILLER_22_1028 VPWR VGND sg13cmos5l_fill_1
X_3975__316 _3975_/RESET_B VPWR VGND sg13cmos5l_tiehi
XFILLER_34_340 VPWR VGND sg13cmos5l_decap_8
X_2977_ _2986_/C _2976_/B _2977_/B VPWR VGND sg13cmos5l_nand2b_1
XFILLER_22_579 VPWR VGND sg13cmos5l_fill_2
X_3982__309 _3982_/RESET_B VPWR VGND sg13cmos5l_tiehi
Xhold720 hold720/X _4035_/Q VPWR VGND sg13cmos5l_dlygate4sd3_1
Xhold731 hold731/X _3987_/Q VPWR VGND sg13cmos5l_dlygate4sd3_1
Xhold764 hold764/X _3938_/Q VPWR VGND sg13cmos5l_dlygate4sd3_1
Xhold742 _2163_/A _4223_/Q VPWR VGND sg13cmos5l_dlygate4sd3_1
Xhold753 hold753/X _3879_/Q VPWR VGND sg13cmos5l_dlygate4sd3_1
Xhold775 hold775/X _3949_/Q VPWR VGND sg13cmos5l_dlygate4sd3_1
X_3529_ _3529_/Y _3529_/A VPWR VGND sg13cmos5l_inv_1
Xhold797 hold797/X _3989_/Q VPWR VGND sg13cmos5l_dlygate4sd3_1
Xhold786 hold786/X _3878_/Q VPWR VGND sg13cmos5l_dlygate4sd3_1
XFILLER_26_863 VPWR VGND sg13cmos5l_decap_4
XFILLER_40_321 VPWR VGND sg13cmos5l_decap_8
XFILLER_5_723 VPWR VGND sg13cmos5l_decap_4
XFILLER_4_255 VPWR VGND sg13cmos5l_fill_1
XFILLER_45_1006 VPWR VGND sg13cmos5l_decap_8
XFILLER_4_277 VPWR VGND sg13cmos5l_fill_2
XFILLER_49_933 VPWR VGND sg13cmos5l_decap_8
XFILLER_1_995 VPWR VGND sg13cmos5l_decap_8
XFILLER_0_494 VPWR VGND sg13cmos5l_fill_2
XFILLER_35_104 VPWR VGND sg13cmos5l_fill_2
XFILLER_36_616 VPWR VGND sg13cmos5l_fill_1
XFILLER_48_498 VPWR VGND sg13cmos5l_decap_4
XFILLER_35_126 VPWR VGND sg13cmos5l_decap_8
XFILLER_16_351 VPWR VGND sg13cmos5l_decap_8
XFILLER_17_852 VPWR VGND sg13cmos5l_decap_8
X_2900_ _2900_/Y _2900_/A _2916_/B VPWR VGND sg13cmos5l_nand2_1
XFILLER_17_885 VPWR VGND sg13cmos5l_fill_1
X_3880_ _3880_/Q clkload7/A _3880_/D _3880_/RESET_B VPWR VGND sg13cmos5l_dfrbpq_1
X_2831_ _2831_/Y _4082_/Q _2828_/Y _2829_/Y _2830_/Y VPWR VGND sg13cmos5l_a22oi_1
XFILLER_32_888 VPWR VGND sg13cmos5l_decap_8
XFILLER_32_899 VPWR VGND sg13cmos5l_fill_2
X_2762_ _2762_/Y _2768_/A _2768_/B VPWR VGND sg13cmos5l_nand2_1
XFILLER_8_572 VPWR VGND sg13cmos5l_decap_8
X_2693_ _2695_/C _2693_/A _2693_/B VPWR VGND sg13cmos5l_xnor2_1
XFILLER_6_73 VPWR VGND sg13cmos5l_decap_4
X_3314_ _4178_/D _3347_/A _3432_/A VPWR VGND sg13cmos5l_nor2_1
X_3245_ _3253_/B _3218_/A _3163_/B _3251_/S VPWR VGND sg13cmos5l_mux2_1
XFILLER_39_432 VPWR VGND sg13cmos5l_fill_2
X_3176_ _3176_/Y _4126_/Q _3176_/B VPWR VGND sg13cmos5l_nor2_1
XFILLER_42_619 VPWR VGND sg13cmos5l_decap_4
XFILLER_41_129 VPWR VGND sg13cmos5l_decap_8
XFILLER_41_118 VPWR VGND sg13cmos5l_fill_1
XFILLER_41_15 VPWR VGND sg13cmos5l_fill_2
XFILLER_2_737 VPWR VGND sg13cmos5l_decap_8
Xhold594 _2758_/B _4054_/Q VPWR VGND sg13cmos5l_dlygate4sd3_1
X_3958__333 _3958_/RESET_B VPWR VGND sg13cmos5l_tiehi
XFILLER_46_947 VPWR VGND sg13cmos5l_decap_8
XFILLER_17_126 VPWR VGND sg13cmos5l_decap_8
XFILLER_33_608 VPWR VGND sg13cmos5l_fill_1
XFILLER_14_833 VPWR VGND sg13cmos5l_decap_8
XFILLER_9_325 VPWR VGND sg13cmos5l_fill_1
XFILLER_15_60 VPWR VGND sg13cmos5l_decap_8
X_3965__326 _3965_/RESET_B VPWR VGND sg13cmos5l_tiehi
XFILLER_5_586 VPWR VGND sg13cmos5l_decap_8
XFILLER_49_730 VPWR VGND sg13cmos5l_decap_8
XFILLER_1_792 VPWR VGND sg13cmos5l_decap_8
X_3030_ _3030_/Y hold914/X _3025_/Y _3000_/A VPWR VGND sg13cmos5l_o21ai_1
X_3972__319 _3972_/RESET_B VPWR VGND sg13cmos5l_tiehi
X_3932_ _3932_/Q clkload7/A _3932_/D _3932_/RESET_B VPWR VGND sg13cmos5l_dfrbpq_1
XFILLER_20_825 VPWR VGND sg13cmos5l_fill_1
X_3863_ _3892_/D _3863_/A0 hold809/X _3864_/S VPWR VGND sg13cmos5l_mux2_1
X_2814_ _2814_/Y _2814_/A _2818_/S VPWR VGND sg13cmos5l_nor2_1
XFILLER_31_162 VPWR VGND sg13cmos5l_fill_2
X_3794_ _3803_/A _3794_/A _3794_/B _3794_/C VPWR VGND sg13cmos5l_nor3_1
X_2745_ _2745_/Y _2855_/B _2743_/Y _2744_/Y VPWR VGND sg13cmos5l_a21oi_1
X_2676_ _2682_/B _2676_/A _2676_/B _2676_/C VPWR VGND sg13cmos5l_nor3_1
X_4277_ _4277_/Q _4277_/CLK _4277_/D _4277_/RESET_B VPWR VGND sg13cmos5l_dfrbpq_1
XFILLER_39_262 VPWR VGND sg13cmos5l_fill_2
X_3228_ _3228_/Y _4159_/Q _4131_/Q VPWR VGND sg13cmos5l_xnor2_1
X_3159_ _3159_/Y _3159_/A _3159_/B VPWR VGND sg13cmos5l_nand2_1
XFILLER_42_416 VPWR VGND sg13cmos5l_decap_4
XFILLER_42_449 VPWR VGND sg13cmos5l_fill_2
XFILLER_22_151 VPWR VGND sg13cmos5l_decap_8
XFILLER_23_663 VPWR VGND sg13cmos5l_decap_8
XFILLER_35_1005 VPWR VGND sg13cmos5l_decap_8
XFILLER_7_807 VPWR VGND sg13cmos5l_decap_8
XFILLER_10_379 VPWR VGND sg13cmos5l_fill_2
XFILLER_2_589 VPWR VGND sg13cmos5l_decap_8
XFILLER_2_578 VPWR VGND sg13cmos5l_fill_2
XFILLER_2_567 VPWR VGND sg13cmos5l_decap_8
XFILLER_46_744 VPWR VGND sg13cmos5l_decap_8
XFILLER_27_980 VPWR VGND sg13cmos5l_decap_8
Xclkbuf_leaf_25_clk clkload4/A clkbuf_leaf_4_clk/A VPWR VGND sg13cmos5l_buf_8
XFILLER_33_438 VPWR VGND sg13cmos5l_decap_8
XFILLER_42_961 VPWR VGND sg13cmos5l_decap_8
XFILLER_14_663 VPWR VGND sg13cmos5l_fill_2
XFILLER_6_851 VPWR VGND sg13cmos5l_decap_8
X_2530_ _2530_/Y _4043_/Q _2530_/B _2530_/C VPWR VGND sg13cmos5l_nor3_1
XFILLER_6_895 VPWR VGND sg13cmos5l_fill_2
XFILLER_5_350 VPWR VGND sg13cmos5l_decap_8
X_2461_ _2463_/C _2461_/A _2461_/B VPWR VGND sg13cmos5l_xnor2_1
X_4200_ _4200_/Q _4205_/CLK _4200_/D _4200_/RESET_B VPWR VGND sg13cmos5l_dfrbpq_1
X_2392_ _2400_/S _3855_/C _3855_/D _2392_/C VPWR VGND sg13cmos5l_nand3_1
X_4131_ _4131_/Q _4193_/CLK _4131_/D _4131_/RESET_B VPWR VGND sg13cmos5l_dfrbpq_1
X_4062_ _4062_/Q clkload8/A _4062_/D _4062_/RESET_B VPWR VGND sg13cmos5l_dfrbpq_1
XFILLER_49_582 VPWR VGND sg13cmos5l_fill_1
XFILLER_3_1014 VPWR VGND sg13cmos5l_decap_8
X_3013_ _3013_/Y _4096_/Q _3013_/B _3016_/C VPWR VGND sg13cmos5l_nor3_1
XFILLER_37_766 VPWR VGND sg13cmos5l_fill_1
Xclkbuf_leaf_16_clk _4193_/CLK clkload1/A VPWR VGND sg13cmos5l_buf_8
X_3915_ _3915_/Q clkload7/A _3915_/D _3915_/RESET_B VPWR VGND sg13cmos5l_dfrbpq_1
XFILLER_33_983 VPWR VGND sg13cmos5l_decap_8
XFILLER_20_622 VPWR VGND sg13cmos5l_fill_1
XFILLER_20_655 VPWR VGND sg13cmos5l_decap_8
XFILLER_22_39 VPWR VGND sg13cmos5l_decap_4
X_3846_ _3854_/S _4031_/Q _3846_/B _3855_/C _3846_/D VPWR VGND sg13cmos5l_and4_1
X_3948__343 _3948_/RESET_B VPWR VGND sg13cmos5l_tiehi
X_3777_ _3777_/Y _3778_/B VPWR VGND sg13cmos5l_inv_1
X_2728_ _2729_/B _2193_/Y _2883_/A _4081_/Q VPWR VGND sg13cmos5l_o21ai_1
X_2659_ _2659_/Y _2657_/S _3880_/Q _2658_/Y VPWR VGND sg13cmos5l_a21oi_1
Xfanout101 _3617_/B _3272_/A VPWR VGND sg13cmos5l_buf_1
Xfanout112 _3863_/A0 input13/X VPWR VGND sg13cmos5l_buf_1
Xfanout123 _3704_/A input1/X VPWR VGND sg13cmos5l_buf_1
XFILLER_47_14 VPWR VGND sg13cmos5l_decap_8
XFILLER_41_1020 VPWR VGND sg13cmos5l_decap_8
X_3955__336 _3955_/RESET_B VPWR VGND sg13cmos5l_tiehi
XFILLER_15_416 VPWR VGND sg13cmos5l_fill_2
XFILLER_28_788 VPWR VGND sg13cmos5l_decap_8
XFILLER_28_799 VPWR VGND sg13cmos5l_fill_2
XFILLER_43_769 VPWR VGND sg13cmos5l_decap_8
XFILLER_42_235 VPWR VGND sg13cmos5l_decap_4
XFILLER_42_279 VPWR VGND sg13cmos5l_fill_2
XFILLER_24_950 VPWR VGND sg13cmos5l_decap_8
XFILLER_7_648 VPWR VGND sg13cmos5l_fill_1
XFILLER_6_125 VPWR VGND sg13cmos5l_decap_8
X_3962__329 _3962_/RESET_B VPWR VGND sg13cmos5l_tiehi
XFILLER_5_0 VPWR VGND sg13cmos5l_fill_2
XFILLER_3_832 VPWR VGND sg13cmos5l_decap_8
XFILLER_2_320 VPWR VGND sg13cmos5l_fill_2
XFILLER_2_331 VPWR VGND sg13cmos5l_decap_8
XFILLER_38_519 VPWR VGND sg13cmos5l_decap_8
XFILLER_46_530 VPWR VGND sg13cmos5l_decap_8
XFILLER_46_574 VPWR VGND sg13cmos5l_fill_1
XFILLER_19_777 VPWR VGND sg13cmos5l_decap_8
XFILLER_33_202 VPWR VGND sg13cmos5l_decap_8
XFILLER_18_287 VPWR VGND sg13cmos5l_decap_4
XFILLER_15_950 VPWR VGND sg13cmos5l_decap_8
XFILLER_15_961 VPWR VGND sg13cmos5l_fill_2
XFILLER_18_1011 VPWR VGND sg13cmos5l_decap_8
X_3700_ _3700_/Y _3690_/B _3698_/S _3711_/B VPWR VGND sg13cmos5l_o21ai_1
X_3631_ _3632_/A _3638_/B _3630_/Y VPWR VGND sg13cmos5l_nor2b_1
XFILLER_30_997 VPWR VGND sg13cmos5l_decap_8
X_3562_ _3565_/A _3569_/A _3505_/B _3564_/B _3589_/A VPWR VGND sg13cmos5l_a22oi_1
X_2513_ _2513_/Y _2516_/A _2516_/B VPWR VGND sg13cmos5l_nand2b_1
X_3493_ _3500_/C _4181_/Q _4180_/Q _4182_/Q VPWR VGND sg13cmos5l_o21ai_1
X_2444_ _2444_/Y _2434_/A _4019_/Q _2435_/B hold720/X VPWR VGND sg13cmos5l_a22oi_1
Xclkbuf_leaf_5_clk clkload5/A clkload0/A VPWR VGND sg13cmos5l_buf_8
X_2375_ _3972_/D _2415_/A0 hold694/X _2381_/S VPWR VGND sg13cmos5l_mux2_1
XFILLER_25_1015 VPWR VGND sg13cmos5l_decap_8
X_4114_ _4114_/Q _4168_/CLK _4114_/D _4114_/RESET_B VPWR VGND sg13cmos5l_dfrbpq_1
XFILLER_37_541 VPWR VGND sg13cmos5l_decap_8
XFILLER_17_28 VPWR VGND sg13cmos5l_decap_4
X_4045_ _4045_/Q clkload9/A _4045_/D _4045_/RESET_B VPWR VGND sg13cmos5l_dfrbpq_1
XFILLER_24_224 VPWR VGND sg13cmos5l_decap_8
XFILLER_40_739 VPWR VGND sg13cmos5l_decap_8
XFILLER_33_791 VPWR VGND sg13cmos5l_decap_8
XFILLER_32_1008 VPWR VGND sg13cmos5l_decap_8
X_3829_ _3829_/Y _3829_/A _3829_/B VPWR VGND sg13cmos5l_nand2_1
XFILLER_4_629 VPWR VGND sg13cmos5l_decap_8
XFILLER_0_802 VPWR VGND sg13cmos5l_decap_8
XFILLER_0_879 VPWR VGND sg13cmos5l_decap_8
XFILLER_48_839 VPWR VGND sg13cmos5l_decap_8
XFILLER_15_202 VPWR VGND sg13cmos5l_fill_2
XFILLER_16_725 VPWR VGND sg13cmos5l_fill_1
XFILLER_16_736 VPWR VGND sg13cmos5l_decap_8
XFILLER_15_246 VPWR VGND sg13cmos5l_decap_8
XFILLER_43_588 VPWR VGND sg13cmos5l_fill_2
XFILLER_12_942 VPWR VGND sg13cmos5l_decap_4
XFILLER_12_986 VPWR VGND sg13cmos5l_decap_8
XFILLER_7_456 VPWR VGND sg13cmos5l_decap_8
XFILLER_2_161 VPWR VGND sg13cmos5l_decap_8
XFILLER_2_172 VPWR VGND sg13cmos5l_fill_1
XFILLER_39_828 VPWR VGND sg13cmos5l_decap_4
X_2160_ _2160_/Y _2271_/C VPWR VGND sg13cmos5l_inv_1
XFILLER_38_338 VPWR VGND sg13cmos5l_fill_1
XFILLER_19_530 VPWR VGND sg13cmos5l_decap_8
XFILLER_19_541 VPWR VGND sg13cmos5l_fill_1
XFILLER_47_861 VPWR VGND sg13cmos5l_decap_8
XFILLER_0_53 VPWR VGND sg13cmos5l_fill_1
X_3938__353 _3938_/RESET_B VPWR VGND sg13cmos5l_tiehi
XFILLER_0_1028 VPWR VGND sg13cmos5l_fill_1
XFILLER_34_522 VPWR VGND sg13cmos5l_decap_4
XFILLER_0_97 VPWR VGND sg13cmos5l_fill_1
X_2993_ _4117_/D _3090_/A _2993_/B VPWR VGND sg13cmos5l_nor2_1
XFILLER_21_249 VPWR VGND sg13cmos5l_fill_2
XFILLER_9_73 VPWR VGND sg13cmos5l_fill_1
XFILLER_9_95 VPWR VGND sg13cmos5l_decap_8
X_3614_ _3614_/Y _3597_/A _3608_/Y _3450_/Y VPWR VGND sg13cmos5l_o21ai_1
Xhold913 _4219_/D _3544_/Y VPWR VGND sg13cmos5l_dlygate4sd3_1
Xhold902 _4155_/D _3200_/Y VPWR VGND sg13cmos5l_dlygate4sd3_1
X_3545_ _3545_/Y _4221_/Q _3545_/B VPWR VGND sg13cmos5l_nand2b_1
Xhold924 _3720_/A _4259_/Q VPWR VGND sg13cmos5l_dlygate4sd3_1
Xhold946 _3591_/A _4229_/Q VPWR VGND sg13cmos5l_dlygate4sd3_1
Xhold935 hold935/X _2498_/Y VPWR VGND sg13cmos5l_dlygate4sd3_1
X_3945__346 _3945_/RESET_B VPWR VGND sg13cmos5l_tiehi
Xhold979 _2972_/A _4092_/Q VPWR VGND sg13cmos5l_dlygate4sd3_1
Xhold968 _2802_/A _4088_/Q VPWR VGND sg13cmos5l_dlygate4sd3_1
Xhold957 _4108_/D _2924_/Y VPWR VGND sg13cmos5l_dlygate4sd3_1
X_3476_ _3483_/S _3474_/Y _3475_/Y _3457_/Y VPWR VGND sg13cmos5l_o21ai_1
XFILLER_0_109 VPWR VGND sg13cmos5l_decap_4
X_2427_ _4013_/D _3874_/A _3874_/B VPWR VGND sg13cmos5l_nor2_1
XFILLER_29_316 VPWR VGND sg13cmos5l_decap_4
X_2358_ _2358_/X _2418_/A0 hold756/X _2358_/S VPWR VGND sg13cmos5l_mux2_1
X_3991__300 _3991_/RESET_B VPWR VGND sg13cmos5l_tiehi
X_2289_ _2474_/C input3/X input2/X _2290_/C VPWR VGND sg13cmos5l_and3_1
X_4028_ _4028_/Q clkload4/A _4028_/D _4028_/RESET_B VPWR VGND sg13cmos5l_dfrbpq_1
XFILLER_38_894 VPWR VGND sg13cmos5l_fill_1
X_3952__339 _3952_/RESET_B VPWR VGND sg13cmos5l_tiehi
XFILLER_8_209 VPWR VGND sg13cmos5l_fill_1
XFILLER_21_794 VPWR VGND sg13cmos5l_fill_2
XFILLER_4_459 VPWR VGND sg13cmos5l_decap_8
XFILLER_16_500 VPWR VGND sg13cmos5l_decap_4
XFILLER_44_842 VPWR VGND sg13cmos5l_fill_2
XFILLER_44_897 VPWR VGND sg13cmos5l_decap_8
X_4150__491 _4150_/RESET_B VPWR VGND sg13cmos5l_tiehi
XFILLER_31_525 VPWR VGND sg13cmos5l_fill_1
XFILLER_11_271 VPWR VGND sg13cmos5l_decap_8
X_3330_ _3338_/B _3326_/X _3327_/Y _3328_/Y VPWR VGND sg13cmos5l_a21o_1
X_3261_ _3261_/Y _3255_/Y _3258_/Y _3260_/X VPWR VGND sg13cmos5l_o21ai_1
X_2212_ _3714_/A _2212_/A VPWR VGND sg13cmos5l_inv_1
X_3192_ _3194_/B _3188_/Y _3189_/Y _3191_/Y VPWR VGND sg13cmos5l_o21ai_1
XFILLER_22_1007 VPWR VGND sg13cmos5l_decap_8
XFILLER_27_809 VPWR VGND sg13cmos5l_decap_8
XFILLER_19_371 VPWR VGND sg13cmos5l_decap_8
XFILLER_35_831 VPWR VGND sg13cmos5l_fill_1
XFILLER_22_503 VPWR VGND sg13cmos5l_decap_4
XFILLER_34_363 VPWR VGND sg13cmos5l_fill_2
X_2976_ _2976_/Y _2976_/A _2976_/B VPWR VGND sg13cmos5l_nor2_1
X_3882__411 _3882_/RESET_B VPWR VGND sg13cmos5l_tiehi
Xhold721 _2445_/B _2444_/Y VPWR VGND sg13cmos5l_dlygate4sd3_1
XFILLER_30_39 VPWR VGND sg13cmos5l_decap_8
Xhold710 hold710/X _3922_/Q VPWR VGND sg13cmos5l_dlygate4sd3_1
XFILLER_2_919 VPWR VGND sg13cmos5l_decap_8
Xhold754 hold754/X _3993_/Q VPWR VGND sg13cmos5l_dlygate4sd3_1
Xhold743 _4252_/D _3706_/Y VPWR VGND sg13cmos5l_dlygate4sd3_1
Xhold732 hold732/X _3929_/Q VPWR VGND sg13cmos5l_dlygate4sd3_1
Xhold765 hold765/X _3946_/Q VPWR VGND sg13cmos5l_dlygate4sd3_1
X_3528_ _3529_/A _3526_/Y _3527_/Y _3528_/S VPWR VGND sg13cmos5l_mux2_1
Xhold787 hold787/X _3991_/Q VPWR VGND sg13cmos5l_dlygate4sd3_1
Xhold776 hold776/X _3913_/Q VPWR VGND sg13cmos5l_dlygate4sd3_1
X_3459_ _3459_/Y _4210_/Q _3473_/A VPWR VGND sg13cmos5l_xnor2_1
Xhold798 hold798/X _3980_/Q VPWR VGND sg13cmos5l_dlygate4sd3_1
XFILLER_39_59 VPWR VGND sg13cmos5l_decap_8
XFILLER_29_113 VPWR VGND sg13cmos5l_decap_4
XFILLER_29_135 VPWR VGND sg13cmos5l_decap_8
XFILLER_45_606 VPWR VGND sg13cmos5l_decap_8
XFILLER_26_842 VPWR VGND sg13cmos5l_decap_8
XFILLER_41_801 VPWR VGND sg13cmos5l_decap_4
X_4017__273 _4017_/RESET_B VPWR VGND sg13cmos5l_tiehi
XFILLER_41_834 VPWR VGND sg13cmos5l_fill_1
XFILLER_41_823 VPWR VGND sg13cmos5l_decap_8
XFILLER_40_300 VPWR VGND sg13cmos5l_decap_8
XFILLER_25_363 VPWR VGND sg13cmos5l_decap_4
XFILLER_26_897 VPWR VGND sg13cmos5l_fill_1
XFILLER_40_333 VPWR VGND sg13cmos5l_fill_2
XFILLER_13_558 VPWR VGND sg13cmos5l_decap_8
XFILLER_4_212 VPWR VGND sg13cmos5l_decap_8
XFILLER_4_201 VPWR VGND sg13cmos5l_fill_2
X_3928__363 _3928_/RESET_B VPWR VGND sg13cmos5l_tiehi
XFILLER_49_912 VPWR VGND sg13cmos5l_decap_8
XFILLER_0_473 VPWR VGND sg13cmos5l_decap_8
XFILLER_1_974 VPWR VGND sg13cmos5l_decap_8
XFILLER_49_989 VPWR VGND sg13cmos5l_decap_8
XFILLER_17_820 VPWR VGND sg13cmos5l_decap_8
XFILLER_17_831 VPWR VGND sg13cmos5l_fill_2
X_3935__356 _3935_/RESET_B VPWR VGND sg13cmos5l_tiehi
XFILLER_44_672 VPWR VGND sg13cmos5l_decap_8
XFILLER_44_661 VPWR VGND sg13cmos5l_fill_2
X_2830_ _2830_/Y _4081_/Q _4063_/Q VPWR VGND sg13cmos5l_nor2_1
X_2761_ _2761_/X _2761_/A _2761_/B VPWR VGND sg13cmos5l_and2_1
XFILLER_8_551 VPWR VGND sg13cmos5l_decap_8
X_2692_ _2695_/B _2692_/A _2692_/B VPWR VGND sg13cmos5l_nor2_1
X_3981__310 _3981_/RESET_B VPWR VGND sg13cmos5l_tiehi
X_3942__349 _3942_/RESET_B VPWR VGND sg13cmos5l_tiehi
X_3313_ _3432_/A _3313_/A _3313_/B VPWR VGND sg13cmos5l_nor2_1
X_3244_ _3253_/A _3244_/A VPWR VGND sg13cmos5l_inv_1
XFILLER_39_444 VPWR VGND sg13cmos5l_decap_8
XFILLER_39_422 VPWR VGND sg13cmos5l_fill_1
XFILLER_39_455 VPWR VGND sg13cmos5l_fill_2
X_3175_ _3180_/B _3171_/Y _3173_/Y _3174_/Y VPWR VGND sg13cmos5l_o21ai_1
XFILLER_39_488 VPWR VGND sg13cmos5l_decap_4
XFILLER_25_17 VPWR VGND sg13cmos5l_decap_8
XFILLER_25_28 VPWR VGND sg13cmos5l_fill_2
XFILLER_22_333 VPWR VGND sg13cmos5l_fill_2
XFILLER_23_889 VPWR VGND sg13cmos5l_decap_8
X_2959_ _2960_/C _2959_/A _2959_/B VPWR VGND sg13cmos5l_and2_1
Xhold595 _3211_/B _4132_/Q VPWR VGND sg13cmos5l_dlygate4sd3_1
XFILLER_46_926 VPWR VGND sg13cmos5l_decap_8
X_4238__274 _4238_/RESET_B VPWR VGND sg13cmos5l_tiehi
XFILLER_45_458 VPWR VGND sg13cmos5l_decap_8
XFILLER_32_119 VPWR VGND sg13cmos5l_decap_4
XFILLER_41_631 VPWR VGND sg13cmos5l_decap_4
XFILLER_25_182 VPWR VGND sg13cmos5l_decap_8
XFILLER_25_193 VPWR VGND sg13cmos5l_fill_1
XFILLER_41_675 VPWR VGND sg13cmos5l_decap_8
XFILLER_14_878 VPWR VGND sg13cmos5l_decap_8
XFILLER_12_1028 VPWR VGND sg13cmos5l_fill_1
XFILLER_31_71 VPWR VGND sg13cmos5l_fill_2
XFILLER_1_771 VPWR VGND sg13cmos5l_decap_8
XFILLER_49_786 VPWR VGND sg13cmos5l_decap_8
XFILLER_37_959 VPWR VGND sg13cmos5l_decap_8
XFILLER_45_992 VPWR VGND sg13cmos5l_decap_8
X_3931_ _3931_/Q clkload7/A _3931_/D _3931_/RESET_B VPWR VGND sg13cmos5l_dfrbpq_1
XFILLER_16_193 VPWR VGND sg13cmos5l_fill_1
X_3862_ _3862_/X _3873_/A0 hold751/X _3862_/S VPWR VGND sg13cmos5l_mux2_1
XFILLER_31_141 VPWR VGND sg13cmos5l_decap_8
XFILLER_31_152 VPWR VGND sg13cmos5l_fill_2
X_2813_ _2818_/S _2811_/Y _2812_/Y _2803_/Y VPWR VGND sg13cmos5l_o21ai_1
X_3793_ _3794_/C _3793_/A _3793_/B _3793_/C VPWR VGND sg13cmos5l_and3_1
X_2744_ _2744_/Y _2739_/B _2743_/Y _2761_/B VPWR VGND sg13cmos5l_o21ai_1
X_2675_ _2676_/C _2671_/Y _2672_/Y _2674_/Y _2675_/B2 _2675_/C1 VPWR VGND sg13cmos5l_a221oi_1
X_4276_ _4276_/Q _4278_/CLK _4276_/D _4276_/RESET_B VPWR VGND sg13cmos5l_dfrbpq_1
XFILLER_39_241 VPWR VGND sg13cmos5l_decap_8
X_3227_ _3227_/Y _4161_/Q _4133_/Q VPWR VGND sg13cmos5l_nand2_1
X_3158_ _4148_/D _3215_/B _3158_/B VPWR VGND sg13cmos5l_nor2_1
XFILLER_36_16 VPWR VGND sg13cmos5l_decap_8
X_3089_ _3090_/C _3089_/A _3088_/A VPWR VGND sg13cmos5l_nor2b_1
XFILLER_14_119 VPWR VGND sg13cmos5l_decap_8
X_3918__373 _3918_/RESET_B VPWR VGND sg13cmos5l_tiehi
XFILLER_22_141 VPWR VGND sg13cmos5l_fill_1
XFILLER_35_1028 VPWR VGND sg13cmos5l_fill_1
XFILLER_10_303 VPWR VGND sg13cmos5l_fill_2
XFILLER_10_314 VPWR VGND sg13cmos5l_decap_4
XFILLER_11_826 VPWR VGND sg13cmos5l_fill_2
XFILLER_22_196 VPWR VGND sg13cmos5l_fill_2
XFILLER_2_513 VPWR VGND sg13cmos5l_decap_4
XFILLER_7_4 VPWR VGND sg13cmos5l_fill_2
X_3925__366 _3925_/RESET_B VPWR VGND sg13cmos5l_tiehi
XFILLER_46_701 VPWR VGND sg13cmos5l_decap_8
XFILLER_45_211 VPWR VGND sg13cmos5l_decap_8
X_4058__181 _4058_/D VPWR VGND sg13cmos5l_tielo
XFILLER_18_403 VPWR VGND sg13cmos5l_fill_1
XFILLER_19_948 VPWR VGND sg13cmos5l_decap_8
XFILLER_19_959 VPWR VGND sg13cmos5l_fill_1
XFILLER_45_266 VPWR VGND sg13cmos5l_fill_2
X_3971__320 _3971_/RESET_B VPWR VGND sg13cmos5l_tiehi
XFILLER_42_940 VPWR VGND sg13cmos5l_decap_8
X_3932__359 _3932_/RESET_B VPWR VGND sg13cmos5l_tiehi
XFILLER_9_123 VPWR VGND sg13cmos5l_decap_8
XFILLER_10_892 VPWR VGND sg13cmos5l_decap_4
X_2460_ _4023_/D _2464_/A _2458_/Y _2459_/Y VPWR VGND sg13cmos5l_a21oi_1
XFILLER_5_395 VPWR VGND sg13cmos5l_decap_8
X_2391_ _3986_/D hold686/X _3854_/A1 _2391_/S VPWR VGND sg13cmos5l_mux2_1
X_4130_ _4130_/Q _4136_/CLK _4130_/D _4130_/RESET_B VPWR VGND sg13cmos5l_dfrbpq_1
XFILLER_49_561 VPWR VGND sg13cmos5l_decap_8
X_4061_ _4061_/Q clkload8/A _4061_/D _4061_/RESET_B VPWR VGND sg13cmos5l_dfrbpq_1
XFILLER_49_594 VPWR VGND sg13cmos5l_decap_8
XFILLER_37_723 VPWR VGND sg13cmos5l_decap_8
X_3012_ _3012_/Y _4124_/Q _3012_/B VPWR VGND sg13cmos5l_nand2b_1
XFILLER_25_907 VPWR VGND sg13cmos5l_decap_8
XFILLER_36_233 VPWR VGND sg13cmos5l_fill_2
XFILLER_36_255 VPWR VGND sg13cmos5l_decap_8
XFILLER_36_288 VPWR VGND sg13cmos5l_decap_8
X_3914_ _3914_/Q clkload7/A _3914_/D _3914_/RESET_B VPWR VGND sg13cmos5l_dfrbpq_1
XFILLER_33_962 VPWR VGND sg13cmos5l_decap_8
X_3845_ _4271_/D _4272_/D _3845_/B VPWR VGND sg13cmos5l_nor2_1
X_3776_ _3778_/B _3775_/Y _3774_/Y _3776_/S VPWR VGND sg13cmos5l_mux2_1
X_2727_ _4063_/D _2727_/A _4078_/D VPWR VGND sg13cmos5l_nor2b_1
X_2658_ _2658_/Y _2657_/S _2227_/Y _2675_/B2 VPWR VGND sg13cmos5l_o21ai_1
Xfanout113 _3854_/A1 input13/X VPWR VGND sg13cmos5l_buf_1
Xfanout102 _4272_/D _3272_/A VPWR VGND sg13cmos5l_buf_1
X_2589_ _2589_/Y _2657_/S _3879_/Q _2588_/Y VPWR VGND sg13cmos5l_a21oi_1
Xfanout124 _3547_/A _3827_/B1 VPWR VGND sg13cmos5l_buf_1
X_4259_ _4259_/Q _4259_/CLK _4259_/D _4259_/RESET_B VPWR VGND sg13cmos5l_dfrbpq_1
XFILLER_28_745 VPWR VGND sg13cmos5l_decap_8
XFILLER_27_266 VPWR VGND sg13cmos5l_decap_4
XFILLER_23_461 VPWR VGND sg13cmos5l_decap_4
X_4088__174 _4088_/D VPWR VGND sg13cmos5l_tielo
XFILLER_10_133 VPWR VGND sg13cmos5l_fill_1
XFILLER_11_656 VPWR VGND sg13cmos5l_decap_8
XFILLER_12_62 VPWR VGND sg13cmos5l_fill_1
XFILLER_3_811 VPWR VGND sg13cmos5l_decap_8
XFILLER_2_310 VPWR VGND sg13cmos5l_decap_4
XFILLER_3_888 VPWR VGND sg13cmos5l_decap_8
XFILLER_19_723 VPWR VGND sg13cmos5l_decap_8
XFILLER_18_211 VPWR VGND sg13cmos5l_decap_4
XFILLER_19_734 VPWR VGND sg13cmos5l_fill_2
XFILLER_19_767 VPWR VGND sg13cmos5l_decap_4
XFILLER_18_255 VPWR VGND sg13cmos5l_fill_2
XFILLER_15_995 VPWR VGND sg13cmos5l_decap_8
XFILLER_30_910 VPWR VGND sg13cmos5l_fill_1
X_3630_ _3630_/Y _4262_/Q _4261_/Q _4263_/Q VPWR VGND sg13cmos5l_o21ai_1
XFILLER_30_976 VPWR VGND sg13cmos5l_decap_8
X_3561_ _4233_/D _3561_/A _3561_/B VPWR VGND sg13cmos5l_nor2_1
X_2512_ _2516_/B _2267_/B _2510_/Y _2511_/Y _2695_/A VPWR VGND sg13cmos5l_a22oi_1
X_3492_ _3492_/Y _3492_/A VPWR VGND sg13cmos5l_inv_1
XFILLER_6_693 VPWR VGND sg13cmos5l_decap_8
XFILLER_5_192 VPWR VGND sg13cmos5l_decap_8
X_2443_ _4018_/D _2441_/Y hold852/X _3874_/A VPWR VGND sg13cmos5l_a21oi_1
X_4258__211 _4258_/RESET_B VPWR VGND sg13cmos5l_tiehi
X_3908__383 _3908_/RESET_B VPWR VGND sg13cmos5l_tiehi
X_2374_ _3971_/D _2414_/A0 hold701/X _2381_/S VPWR VGND sg13cmos5l_mux2_1
X_4113_ _4113_/Q _4168_/CLK _4113_/D _4113_/RESET_B VPWR VGND sg13cmos5l_dfrbpq_1
X_4044_ _4044_/Q clkload9/A _4044_/D _4044_/RESET_B VPWR VGND sg13cmos5l_dfrbpq_1
XFILLER_25_759 VPWR VGND sg13cmos5l_decap_8
XFILLER_40_718 VPWR VGND sg13cmos5l_decap_8
XFILLER_24_269 VPWR VGND sg13cmos5l_decap_8
X_3915__376 _3915_/RESET_B VPWR VGND sg13cmos5l_tiehi
XFILLER_33_17 VPWR VGND sg13cmos5l_decap_4
XFILLER_20_431 VPWR VGND sg13cmos5l_decap_8
XFILLER_20_442 VPWR VGND sg13cmos5l_fill_2
X_3828_ _3828_/Y _3829_/A _3826_/Y _3827_/Y VPWR VGND sg13cmos5l_a21oi_1
XFILLER_21_987 VPWR VGND sg13cmos5l_decap_8
XFILLER_4_608 VPWR VGND sg13cmos5l_decap_8
X_3759_ _3759_/Y _3775_/A _3768_/B VPWR VGND sg13cmos5l_nand2_1
X_3961__330 _3961_/RESET_B VPWR VGND sg13cmos5l_tiehi
XFILLER_48_818 VPWR VGND sg13cmos5l_decap_8
XFILLER_0_858 VPWR VGND sg13cmos5l_decap_8
X_3922__369 _3922_/RESET_B VPWR VGND sg13cmos5l_tiehi
XFILLER_47_306 VPWR VGND sg13cmos5l_fill_1
XFILLER_28_553 VPWR VGND sg13cmos5l_decap_8
XFILLER_43_512 VPWR VGND sg13cmos5l_decap_8
XFILLER_16_759 VPWR VGND sg13cmos5l_fill_1
XFILLER_43_567 VPWR VGND sg13cmos5l_decap_8
XFILLER_31_707 VPWR VGND sg13cmos5l_decap_8
XFILLER_24_781 VPWR VGND sg13cmos5l_fill_2
XFILLER_12_965 VPWR VGND sg13cmos5l_decap_8
XFILLER_7_424 VPWR VGND sg13cmos5l_decap_8
XFILLER_8_969 VPWR VGND sg13cmos5l_decap_8
X_4027__253 _4027_/RESET_B VPWR VGND sg13cmos5l_tiehi
XFILLER_3_641 VPWR VGND sg13cmos5l_fill_2
XFILLER_47_840 VPWR VGND sg13cmos5l_decap_8
XFILLER_48_91 VPWR VGND sg13cmos5l_decap_4
XFILLER_0_21 VPWR VGND sg13cmos5l_decap_8
XFILLER_22_718 VPWR VGND sg13cmos5l_decap_8
X_2992_ _3049_/B _4089_/Q _2989_/B _2990_/Y VPWR VGND sg13cmos5l_o21ai_1
XFILLER_21_228 VPWR VGND sg13cmos5l_decap_8
XFILLER_9_52 VPWR VGND sg13cmos5l_fill_2
XFILLER_14_291 VPWR VGND sg13cmos5l_fill_1
XFILLER_30_773 VPWR VGND sg13cmos5l_fill_2
X_3613_ _3613_/Y _3590_/Y _3608_/Y _3612_/Y VPWR VGND sg13cmos5l_a21oi_1
XFILLER_31_1020 VPWR VGND sg13cmos5l_decap_8
Xhold903 _2271_/C _4266_/Q VPWR VGND sg13cmos5l_dlygate4sd3_1
X_3544_ _3544_/Y _3525_/Y _3539_/S _3543_/Y VPWR VGND sg13cmos5l_a21oi_1
Xhold936 _2688_/C _2506_/B VPWR VGND sg13cmos5l_dlygate4sd3_1
Xhold914 hold914/X _4124_/Q VPWR VGND sg13cmos5l_dlygate4sd3_1
Xhold925 _2860_/A _4093_/Q VPWR VGND sg13cmos5l_dlygate4sd3_1
Xhold969 hold969/X _2802_/X VPWR VGND sg13cmos5l_dlygate4sd3_1
X_3475_ _3475_/Y _3756_/A _3458_/X _3480_/B VPWR VGND sg13cmos5l_o21ai_1
Xhold947 hold947/X _3592_/Y VPWR VGND sg13cmos5l_dlygate4sd3_1
Xhold958 _3423_/A _4197_/Q VPWR VGND sg13cmos5l_dlygate4sd3_1
X_2426_ _3874_/B _2429_/B _2452_/B VPWR VGND sg13cmos5l_xnor2_1
X_2357_ _3957_/D _2417_/A0 hold698/X _2361_/S VPWR VGND sg13cmos5l_mux2_1
X_2288_ _3901_/D _3854_/A1 hold770/X _3873_/S VPWR VGND sg13cmos5l_mux2_1
XFILLER_38_862 VPWR VGND sg13cmos5l_fill_2
X_4027_ _4027_/Q _4027_/CLK _4027_/D _4027_/RESET_B VPWR VGND sg13cmos5l_dfrbpq_1
XFILLER_37_372 VPWR VGND sg13cmos5l_decap_4
XFILLER_13_707 VPWR VGND sg13cmos5l_decap_8
XFILLER_25_556 VPWR VGND sg13cmos5l_fill_1
XFILLER_12_239 VPWR VGND sg13cmos5l_fill_1
XFILLER_21_762 VPWR VGND sg13cmos5l_fill_2
XFILLER_21_773 VPWR VGND sg13cmos5l_decap_8
XFILLER_5_939 VPWR VGND sg13cmos5l_decap_8
XFILLER_4_438 VPWR VGND sg13cmos5l_fill_2
X_4098__549 _4098_/RESET_B VPWR VGND sg13cmos5l_tiehi
X_4139__502 _4139_/RESET_B VPWR VGND sg13cmos5l_tiehi
XFILLER_0_633 VPWR VGND sg13cmos5l_decap_8
X_4057__202 _4057_/RESET_B VPWR VGND sg13cmos5l_tiehi
XFILLER_47_114 VPWR VGND sg13cmos5l_decap_8
XFILLER_29_873 VPWR VGND sg13cmos5l_fill_1
XFILLER_18_72 VPWR VGND sg13cmos5l_decap_8
XFILLER_44_876 VPWR VGND sg13cmos5l_decap_8
XFILLER_11_250 VPWR VGND sg13cmos5l_decap_8
XFILLER_8_777 VPWR VGND sg13cmos5l_decap_8
XFILLER_7_254 VPWR VGND sg13cmos5l_fill_2
XFILLER_7_243 VPWR VGND sg13cmos5l_decap_8
XFILLER_4_994 VPWR VGND sg13cmos5l_decap_8
X_3260_ _3260_/X _4169_/Q _3260_/B _3260_/C VPWR VGND sg13cmos5l_or3_1
X_2211_ _3713_/A _2211_/A VPWR VGND sg13cmos5l_inv_1
X_3191_ _3191_/Y hold901/X _3183_/Y _3190_/Y _3201_/B VPWR VGND sg13cmos5l_a22oi_1
X_3905__386 _3905_/RESET_B VPWR VGND sg13cmos5l_tiehi
XFILLER_39_659 VPWR VGND sg13cmos5l_decap_8
XFILLER_39_648 VPWR VGND sg13cmos5l_fill_2
XFILLER_39_637 VPWR VGND sg13cmos5l_decap_8
XFILLER_38_136 VPWR VGND sg13cmos5l_decap_4
XFILLER_35_810 VPWR VGND sg13cmos5l_fill_1
XFILLER_35_854 VPWR VGND sg13cmos5l_decap_8
X_3951__340 _3951_/RESET_B VPWR VGND sg13cmos5l_tiehi
XFILLER_22_526 VPWR VGND sg13cmos5l_decap_8
XFILLER_35_898 VPWR VGND sg13cmos5l_decap_8
XFILLER_34_397 VPWR VGND sg13cmos5l_fill_1
X_2975_ _2976_/B _4092_/Q _2975_/B VPWR VGND sg13cmos5l_xnor2_1
XFILLER_30_570 VPWR VGND sg13cmos5l_fill_1
X_3912__379 _3912_/RESET_B VPWR VGND sg13cmos5l_tiehi
Xhold711 hold711/X _3920_/Q VPWR VGND sg13cmos5l_dlygate4sd3_1
Xhold700 _3994_/D _2400_/X VPWR VGND sg13cmos5l_dlygate4sd3_1
Xhold755 hold755/X _3881_/Q VPWR VGND sg13cmos5l_dlygate4sd3_1
Xhold722 hold722/X _3983_/Q VPWR VGND sg13cmos5l_dlygate4sd3_1
X_3527_ _3527_/Y _3712_/A _3531_/A VPWR VGND sg13cmos5l_nor2_1
Xhold744 hold744/X _3959_/Q VPWR VGND sg13cmos5l_dlygate4sd3_1
Xhold733 hold733/X _3954_/Q VPWR VGND sg13cmos5l_dlygate4sd3_1
X_4045__183 _4045_/D VPWR VGND sg13cmos5l_tielo
Xhold777 hold777/X _3969_/Q VPWR VGND sg13cmos5l_dlygate4sd3_1
Xhold766 hold766/X _3985_/Q VPWR VGND sg13cmos5l_dlygate4sd3_1
XFILLER_1_419 VPWR VGND sg13cmos5l_decap_4
Xhold788 hold788/X _3997_/Q VPWR VGND sg13cmos5l_dlygate4sd3_1
Xhold799 hold799/X _3911_/Q VPWR VGND sg13cmos5l_dlygate4sd3_1
X_3458_ _3458_/X _4210_/Q _3473_/A VPWR VGND sg13cmos5l_xor2_1
X_2409_ _4001_/D _2418_/A0 hold767/X _2411_/S VPWR VGND sg13cmos5l_mux2_1
X_3389_ _4196_/D _3389_/A _3389_/B VPWR VGND sg13cmos5l_and2_1
XFILLER_45_629 VPWR VGND sg13cmos5l_fill_2
XFILLER_38_1026 VPWR VGND sg13cmos5l_fill_2
XFILLER_26_876 VPWR VGND sg13cmos5l_fill_1
XFILLER_41_868 VPWR VGND sg13cmos5l_fill_2
XFILLER_40_378 VPWR VGND sg13cmos5l_decap_8
XFILLER_4_246 VPWR VGND sg13cmos5l_decap_8
XFILLER_20_73 VPWR VGND sg13cmos5l_fill_2
XFILLER_1_953 VPWR VGND sg13cmos5l_decap_8
XFILLER_0_452 VPWR VGND sg13cmos5l_decap_8
XFILLER_49_968 VPWR VGND sg13cmos5l_decap_8
XFILLER_0_496 VPWR VGND sg13cmos5l_fill_1
XFILLER_36_607 VPWR VGND sg13cmos5l_decap_8
XFILLER_35_117 VPWR VGND sg13cmos5l_decap_4
XFILLER_45_81 VPWR VGND sg13cmos5l_fill_1
XFILLER_43_161 VPWR VGND sg13cmos5l_decap_8
XFILLER_44_695 VPWR VGND sg13cmos5l_decap_4
XFILLER_31_323 VPWR VGND sg13cmos5l_decap_4
XFILLER_31_367 VPWR VGND sg13cmos5l_fill_2
X_2760_ _4079_/D _2775_/A _2761_/B VPWR VGND sg13cmos5l_and2_1
X_2691_ _4054_/D _2693_/B _2691_/B VPWR VGND sg13cmos5l_nor2_1
XFILLER_6_42 VPWR VGND sg13cmos5l_fill_2
XFILLER_6_86 VPWR VGND sg13cmos5l_fill_2
X_3312_ _3313_/B _3312_/A _3312_/B VPWR VGND sg13cmos5l_nor2_1
X_3243_ _3243_/Y _3240_/A _3240_/B _3242_/X VPWR VGND sg13cmos5l_o21ai_1
XFILLER_6_1024 VPWR VGND sg13cmos5l_decap_4
XFILLER_39_467 VPWR VGND sg13cmos5l_decap_8
X_3174_ _3174_/Y _4174_/Q _3032_/A _4125_/Q _3393_/A VPWR VGND sg13cmos5l_a22oi_1
XFILLER_27_629 VPWR VGND sg13cmos5l_fill_2
XFILLER_35_673 VPWR VGND sg13cmos5l_decap_8
XFILLER_41_39 VPWR VGND sg13cmos5l_fill_1
X_2958_ _3160_/A _3214_/A _2964_/A VPWR VGND sg13cmos5l_nand2_1
X_2889_ _2890_/B _2914_/A _2889_/B VPWR VGND sg13cmos5l_nor2_1
Xhold596 _2757_/B _4053_/Q VPWR VGND sg13cmos5l_dlygate4sd3_1
XFILLER_49_209 VPWR VGND sg13cmos5l_decap_4
XFILLER_46_905 VPWR VGND sg13cmos5l_decap_8
X_4136__505 _4136_/RESET_B VPWR VGND sg13cmos5l_tiehi
XFILLER_18_607 VPWR VGND sg13cmos5l_fill_2
X_4054__205 _4054_/RESET_B VPWR VGND sg13cmos5l_tiehi
XFILLER_41_610 VPWR VGND sg13cmos5l_decap_8
XFILLER_40_131 VPWR VGND sg13cmos5l_decap_8
XFILLER_15_95 VPWR VGND sg13cmos5l_decap_8
XFILLER_12_1007 VPWR VGND sg13cmos5l_decap_8
XFILLER_1_750 VPWR VGND sg13cmos5l_decap_8
X_3941__350 _3941_/RESET_B VPWR VGND sg13cmos5l_tiehi
XFILLER_49_765 VPWR VGND sg13cmos5l_decap_8
X_3902__389 _3902_/RESET_B VPWR VGND sg13cmos5l_tiehi
XFILLER_37_938 VPWR VGND sg13cmos5l_decap_8
XFILLER_36_448 VPWR VGND sg13cmos5l_decap_8
XFILLER_45_971 VPWR VGND sg13cmos5l_decap_8
X_3930_ _3930_/Q _4031_/CLK _3930_/D _3930_/RESET_B VPWR VGND sg13cmos5l_dfrbpq_1
XFILLER_17_695 VPWR VGND sg13cmos5l_decap_8
XFILLER_20_816 VPWR VGND sg13cmos5l_decap_8
X_3861_ _3890_/D _3872_/A0 hold802/X _3864_/S VPWR VGND sg13cmos5l_mux2_1
X_2812_ _2812_/Y _2984_/A _2806_/Y _2977_/B VPWR VGND sg13cmos5l_o21ai_1
X_3792_ _3792_/X _3792_/A _3792_/B VPWR VGND sg13cmos5l_or2_1
XFILLER_31_175 VPWR VGND sg13cmos5l_decap_8
XFILLER_31_186 VPWR VGND sg13cmos5l_fill_2
X_2743_ _2743_/Y _2743_/A _2743_/B VPWR VGND sg13cmos5l_nor2_1
X_2674_ _2674_/Y _2673_/A _3882_/Q _2673_/Y VPWR VGND sg13cmos5l_a21oi_1
X_4007__284 _4007_/RESET_B VPWR VGND sg13cmos5l_tiehi
XFILLER_28_1025 VPWR VGND sg13cmos5l_decap_4
X_4275_ _4275_/Q clkload3/A _4275_/D _4275_/RESET_B VPWR VGND sg13cmos5l_dfrbpq_1
XFILLER_39_220 VPWR VGND sg13cmos5l_decap_8
X_3226_ _3226_/X _3119_/X _3158_/B _3251_/S VPWR VGND sg13cmos5l_mux2_1
XFILLER_39_286 VPWR VGND sg13cmos5l_decap_8
XFILLER_28_949 VPWR VGND sg13cmos5l_fill_2
X_3157_ _3158_/B _3157_/A _3157_/B VPWR VGND sg13cmos5l_nor2_1
XFILLER_43_919 VPWR VGND sg13cmos5l_decap_8
X_3088_ _3090_/B _3088_/A _3070_/Y VPWR VGND sg13cmos5l_nor2b_1
XFILLER_36_982 VPWR VGND sg13cmos5l_decap_8
XFILLER_23_610 VPWR VGND sg13cmos5l_decap_8
XFILLER_11_805 VPWR VGND sg13cmos5l_decap_8
X_4014__277 _4014_/RESET_B VPWR VGND sg13cmos5l_tiehi
XFILLER_18_437 VPWR VGND sg13cmos5l_fill_2
XFILLER_46_779 VPWR VGND sg13cmos5l_decap_8
XFILLER_14_610 VPWR VGND sg13cmos5l_fill_2
XFILLER_42_996 VPWR VGND sg13cmos5l_decap_8
XFILLER_9_102 VPWR VGND sg13cmos5l_fill_2
XFILLER_13_175 VPWR VGND sg13cmos5l_decap_8
XFILLER_14_687 VPWR VGND sg13cmos5l_decap_8
XFILLER_13_186 VPWR VGND sg13cmos5l_fill_1
XFILLER_9_168 VPWR VGND sg13cmos5l_fill_2
XFILLER_10_871 VPWR VGND sg13cmos5l_decap_8
XFILLER_6_864 VPWR VGND sg13cmos5l_decap_8
XFILLER_5_374 VPWR VGND sg13cmos5l_decap_8
X_2390_ _3985_/D hold766/X _2419_/A0 _2391_/S VPWR VGND sg13cmos5l_mux2_1
XFILLER_3_65 VPWR VGND sg13cmos5l_decap_8
XFILLER_3_32 VPWR VGND sg13cmos5l_decap_8
X_4060_ _4060_/Q clkload8/A _4060_/D _4060_/RESET_B VPWR VGND sg13cmos5l_dfrbpq_1
X_3011_ _3011_/Y _3012_/B VPWR VGND sg13cmos5l_inv_1
X_4037__233 _4037_/RESET_B VPWR VGND sg13cmos5l_tiehi
XFILLER_33_941 VPWR VGND sg13cmos5l_decap_8
X_3913_ _3913_/Q _4031_/CLK _3913_/D _3913_/RESET_B VPWR VGND sg13cmos5l_dfrbpq_1
X_3844_ _3844_/Y _2266_/Y _3832_/Y _3843_/Y _2247_/A VPWR VGND sg13cmos5l_a22oi_1
X_3775_ _3775_/Y _3775_/A _3775_/B VPWR VGND sg13cmos5l_nand2_1
X_2726_ _2726_/X _2726_/A _2761_/B VPWR VGND sg13cmos5l_and2_1
X_2657_ _2657_/X _3931_/Q _3914_/Q _2657_/S VPWR VGND sg13cmos5l_mux2_1
X_2588_ _2588_/Y _2657_/S _2226_/Y _2677_/S1 VPWR VGND sg13cmos5l_o21ai_1
Xfanout103 _3272_/A _2223_/Y VPWR VGND sg13cmos5l_buf_1
Xfanout114 _2419_/A0 input12/X VPWR VGND sg13cmos5l_buf_1
X_4120__169 _4120_/D VPWR VGND sg13cmos5l_tielo
Xfanout125 _2792_/B _2688_/A VPWR VGND sg13cmos5l_buf_1
X_4258_ _4258_/Q clkload3/A _4258_/D _4258_/RESET_B VPWR VGND sg13cmos5l_dfrbpq_1
X_3879__417 _3879_/RESET_B VPWR VGND sg13cmos5l_tiehi
X_3209_ _4161_/D _2179_/Y _3553_/A2 _3208_/Y VPWR VGND sg13cmos5l_a21oi_1
XFILLER_28_702 VPWR VGND sg13cmos5l_decap_4
X_4189_ _4189_/Q _4259_/CLK _4189_/D _4189_/RESET_B VPWR VGND sg13cmos5l_dfrbpq_1
X_4133__508 _4133_/RESET_B VPWR VGND sg13cmos5l_tiehi
XFILLER_15_418 VPWR VGND sg13cmos5l_fill_1
XFILLER_43_749 VPWR VGND sg13cmos5l_fill_1
XFILLER_11_602 VPWR VGND sg13cmos5l_decap_8
X_3931__360 _3931_/RESET_B VPWR VGND sg13cmos5l_tiehi
XFILLER_7_606 VPWR VGND sg13cmos5l_decap_8
XFILLER_6_149 VPWR VGND sg13cmos5l_decap_8
XFILLER_10_189 VPWR VGND sg13cmos5l_fill_1
XFILLER_10_178 VPWR VGND sg13cmos5l_fill_2
XFILLER_12_85 VPWR VGND sg13cmos5l_decap_4
XFILLER_5_2 VPWR VGND sg13cmos5l_fill_1
XFILLER_3_867 VPWR VGND sg13cmos5l_decap_8
XFILLER_2_388 VPWR VGND sg13cmos5l_decap_8
XFILLER_18_234 VPWR VGND sg13cmos5l_decap_8
XFILLER_37_82 VPWR VGND sg13cmos5l_fill_2
XFILLER_37_71 VPWR VGND sg13cmos5l_fill_2
XFILLER_15_930 VPWR VGND sg13cmos5l_fill_2
XFILLER_34_727 VPWR VGND sg13cmos5l_fill_1
XFILLER_33_248 VPWR VGND sg13cmos5l_fill_1
XFILLER_14_451 VPWR VGND sg13cmos5l_decap_8
XFILLER_14_462 VPWR VGND sg13cmos5l_decap_8
XFILLER_15_974 VPWR VGND sg13cmos5l_decap_8
XFILLER_30_922 VPWR VGND sg13cmos5l_decap_8
X_4225__403 _4225_/RESET_B VPWR VGND sg13cmos5l_tiehi
XFILLER_10_690 VPWR VGND sg13cmos5l_decap_8
X_3560_ _4232_/D _3560_/A _3560_/B VPWR VGND sg13cmos5l_and2_1
X_2511_ _2511_/Y _2511_/A _2511_/B _2511_/C VPWR VGND sg13cmos5l_nor3_1
X_3491_ _3492_/A _4183_/Q _3500_/B VPWR VGND sg13cmos5l_xor2_1
XFILLER_5_171 VPWR VGND sg13cmos5l_decap_4
X_2442_ _2442_/Y _2434_/A _4018_/Q _2435_/B hold851/X VPWR VGND sg13cmos5l_a22oi_1
X_2373_ _3970_/D _2413_/A0 hold795/X _2381_/S VPWR VGND sg13cmos5l_mux2_1
X_4112_ _4112_/Q _4168_/CLK _4112_/D _4112_/RESET_B VPWR VGND sg13cmos5l_dfrbpq_1
X_4004__287 _4004_/RESET_B VPWR VGND sg13cmos5l_tiehi
X_4043_ _4043_/Q clkload9/A _4043_/D _4043_/RESET_B VPWR VGND sg13cmos5l_dfrbpq_1
XFILLER_37_510 VPWR VGND sg13cmos5l_decap_4
XFILLER_25_738 VPWR VGND sg13cmos5l_decap_8
XFILLER_24_248 VPWR VGND sg13cmos5l_decap_8
X_3827_ _3827_/Y _3825_/A _3829_/A _3827_/B1 VPWR VGND sg13cmos5l_o21ai_1
X_3758_ _3758_/X _3775_/A _3768_/B VPWR VGND sg13cmos5l_or2_1
X_2709_ _2709_/Y _4060_/Q _2711_/A _2883_/A VPWR VGND sg13cmos5l_o21ai_1
X_3689_ _3689_/Y _4265_/Q _3689_/B VPWR VGND sg13cmos5l_nand2b_1
XFILLER_0_837 VPWR VGND sg13cmos5l_decap_8
XFILLER_47_329 VPWR VGND sg13cmos5l_decap_8
XFILLER_16_716 VPWR VGND sg13cmos5l_decap_8
XFILLER_15_204 VPWR VGND sg13cmos5l_fill_1
XFILLER_28_598 VPWR VGND sg13cmos5l_decap_4
XFILLER_24_793 VPWR VGND sg13cmos5l_decap_8
XFILLER_8_948 VPWR VGND sg13cmos5l_decap_8
XFILLER_48_1028 VPWR VGND sg13cmos5l_fill_1
XFILLER_3_686 VPWR VGND sg13cmos5l_fill_2
XFILLER_17_7 VPWR VGND sg13cmos5l_decap_8
XFILLER_0_44 VPWR VGND sg13cmos5l_decap_4
XFILLER_47_896 VPWR VGND sg13cmos5l_decap_8
XFILLER_0_1019 VPWR VGND sg13cmos5l_decap_8
XFILLER_19_598 VPWR VGND sg13cmos5l_fill_2
X_2991_ _2993_/B _2991_/A _2990_/Y VPWR VGND sg13cmos5l_nor2b_1
XFILLER_34_579 VPWR VGND sg13cmos5l_decap_8
XFILLER_42_590 VPWR VGND sg13cmos5l_fill_2
XFILLER_30_741 VPWR VGND sg13cmos5l_fill_1
X_3612_ _3612_/Y _3588_/Y _3608_/Y _3560_/B VPWR VGND sg13cmos5l_o21ai_1
Xhold904 _4266_/D _3823_/Y VPWR VGND sg13cmos5l_dlygate4sd3_1
Xhold937 _3073_/A _4134_/Q VPWR VGND sg13cmos5l_dlygate4sd3_1
X_3543_ _3543_/Y hold912/X _3539_/S _3560_/B VPWR VGND sg13cmos5l_o21ai_1
Xhold915 _4124_/D _3031_/Y VPWR VGND sg13cmos5l_dlygate4sd3_1
Xhold926 _2867_/B _2866_/X VPWR VGND sg13cmos5l_dlygate4sd3_1
Xhold959 _2839_/A _4063_/Q VPWR VGND sg13cmos5l_dlygate4sd3_1
X_3474_ _3474_/Y _3756_/A _3458_/X _3466_/X _3471_/Y _3473_/X VPWR VGND sg13cmos5l_a221oi_1
Xhold948 _2771_/A _4078_/Q VPWR VGND sg13cmos5l_dlygate4sd3_1
XFILLER_9_1011 VPWR VGND sg13cmos5l_decap_8
X_2425_ _2452_/B _2451_/A _2519_/B VPWR VGND sg13cmos5l_nor2_1
X_3921__370 _3921_/RESET_B VPWR VGND sg13cmos5l_tiehi
X_2356_ _3956_/D _2416_/A0 hold781/X _2361_/S VPWR VGND sg13cmos5l_mux2_1
X_2287_ _3872_/S _3846_/D _2292_/A VPWR VGND sg13cmos5l_nand2_1
X_4026_ _4026_/Q _4027_/CLK _4026_/D _4026_/RESET_B VPWR VGND sg13cmos5l_dfrbpq_1
XFILLER_38_885 VPWR VGND sg13cmos5l_decap_4
XFILLER_37_384 VPWR VGND sg13cmos5l_fill_1
XFILLER_25_513 VPWR VGND sg13cmos5l_decap_8
XFILLER_40_505 VPWR VGND sg13cmos5l_decap_8
XFILLER_13_719 VPWR VGND sg13cmos5l_decap_8
XFILLER_25_579 VPWR VGND sg13cmos5l_decap_8
XFILLER_21_741 VPWR VGND sg13cmos5l_decap_8
XFILLER_5_918 VPWR VGND sg13cmos5l_decap_8
XFILLER_0_612 VPWR VGND sg13cmos5l_decap_8
XFILLER_0_667 VPWR VGND sg13cmos5l_decap_8
XFILLER_29_830 VPWR VGND sg13cmos5l_decap_8
XFILLER_47_159 VPWR VGND sg13cmos5l_decap_8
XFILLER_44_800 VPWR VGND sg13cmos5l_decap_8
XFILLER_18_40 VPWR VGND sg13cmos5l_decap_4
XFILLER_28_351 VPWR VGND sg13cmos5l_decap_4
XFILLER_16_513 VPWR VGND sg13cmos5l_fill_2
XFILLER_44_855 VPWR VGND sg13cmos5l_decap_8
XFILLER_16_557 VPWR VGND sg13cmos5l_decap_8
XFILLER_16_568 VPWR VGND sg13cmos5l_fill_2
XFILLER_16_579 VPWR VGND sg13cmos5l_fill_2
XFILLER_31_505 VPWR VGND sg13cmos5l_fill_2
XFILLER_31_516 VPWR VGND sg13cmos5l_decap_4
XFILLER_12_730 VPWR VGND sg13cmos5l_decap_8
XFILLER_24_590 VPWR VGND sg13cmos5l_decap_4
XFILLER_15_1016 VPWR VGND sg13cmos5l_decap_8
XFILLER_15_1027 VPWR VGND sg13cmos5l_fill_2
XFILLER_7_222 VPWR VGND sg13cmos5l_decap_8
XFILLER_7_277 VPWR VGND sg13cmos5l_fill_2
XFILLER_4_973 VPWR VGND sg13cmos5l_decap_8
X_2210_ _3712_/A _2210_/A VPWR VGND sg13cmos5l_inv_1
XFILLER_3_483 VPWR VGND sg13cmos5l_decap_8
X_3190_ _3190_/Y _2220_/A _3394_/A _3032_/A _4125_/Q VPWR VGND sg13cmos5l_a22oi_1
XFILLER_38_159 VPWR VGND sg13cmos5l_decap_8
XFILLER_35_822 VPWR VGND sg13cmos5l_decap_8
X_2974_ _2986_/B _2974_/A _2994_/A VPWR VGND sg13cmos5l_xnor2_1
Xhold712 hold712/X _3882_/Q VPWR VGND sg13cmos5l_dlygate4sd3_1
Xhold701 hold701/X _3971_/Q VPWR VGND sg13cmos5l_dlygate4sd3_1
Xhold723 hold723/X _3948_/Q VPWR VGND sg13cmos5l_dlygate4sd3_1
Xhold745 hold745/X _3968_/Q VPWR VGND sg13cmos5l_dlygate4sd3_1
X_3526_ _3526_/Y _4189_/Q _3526_/B VPWR VGND sg13cmos5l_nor2_1
Xhold734 hold734/X _3976_/Q VPWR VGND sg13cmos5l_dlygate4sd3_1
Xhold778 hold778/X _4003_/Q VPWR VGND sg13cmos5l_dlygate4sd3_1
Xhold767 hold767/X _4001_/Q VPWR VGND sg13cmos5l_dlygate4sd3_1
X_4197__438 _4197_/RESET_B VPWR VGND sg13cmos5l_tiehi
Xhold756 hold756/X _3958_/Q VPWR VGND sg13cmos5l_dlygate4sd3_1
X_3457_ _3457_/Y _4211_/Q _3457_/B VPWR VGND sg13cmos5l_xnor2_1
Xhold789 hold789/X _4006_/Q VPWR VGND sg13cmos5l_dlygate4sd3_1
X_2408_ _4000_/D _2417_/A0 hold729/X _2411_/S VPWR VGND sg13cmos5l_mux2_1
X_3388_ _4195_/D _3389_/A _3388_/B VPWR VGND sg13cmos5l_and2_1
X_4097__550 _4097_/RESET_B VPWR VGND sg13cmos5l_tiehi
X_2339_ _3942_/D _3873_/A0 hold665/X _2341_/S VPWR VGND sg13cmos5l_mux2_1
X_4009_ _4009_/Q clkload5/A _4009_/D _4009_/RESET_B VPWR VGND sg13cmos5l_dfrbpq_1
XFILLER_38_1005 VPWR VGND sg13cmos5l_decap_8
XFILLER_26_888 VPWR VGND sg13cmos5l_fill_2
XFILLER_41_847 VPWR VGND sg13cmos5l_decap_8
XFILLER_40_335 VPWR VGND sg13cmos5l_fill_1
XFILLER_4_203 VPWR VGND sg13cmos5l_fill_1
XFILLER_5_759 VPWR VGND sg13cmos5l_decap_8
XFILLER_1_932 VPWR VGND sg13cmos5l_decap_8
XFILLER_49_947 VPWR VGND sg13cmos5l_decap_8
XFILLER_16_321 VPWR VGND sg13cmos5l_decap_8
XFILLER_17_866 VPWR VGND sg13cmos5l_fill_1
XFILLER_45_60 VPWR VGND sg13cmos5l_decap_8
XFILLER_44_663 VPWR VGND sg13cmos5l_fill_1
XFILLER_16_365 VPWR VGND sg13cmos5l_fill_2
XFILLER_16_376 VPWR VGND sg13cmos5l_fill_2
XFILLER_32_814 VPWR VGND sg13cmos5l_fill_2
XFILLER_32_825 VPWR VGND sg13cmos5l_fill_1
XFILLER_43_173 VPWR VGND sg13cmos5l_decap_8
XFILLER_31_346 VPWR VGND sg13cmos5l_decap_8
X_3911__380 _3911_/RESET_B VPWR VGND sg13cmos5l_tiehi
X_2690_ _4053_/D _2692_/B _2691_/B VPWR VGND sg13cmos5l_nor2_1
XFILLER_8_586 VPWR VGND sg13cmos5l_decap_8
XFILLER_6_54 VPWR VGND sg13cmos5l_decap_4
X_3311_ _4177_/D _3390_/B _3311_/B VPWR VGND sg13cmos5l_and2_1
XFILLER_4_792 VPWR VGND sg13cmos5l_fill_2
XFILLER_3_280 VPWR VGND sg13cmos5l_fill_2
XFILLER_6_1003 VPWR VGND sg13cmos5l_decap_8
X_3242_ _3242_/X _3242_/A _3242_/B VPWR VGND sg13cmos5l_xor2_1
X_3173_ _3173_/Y _3392_/A _4124_/Q _3172_/Y VPWR VGND sg13cmos5l_o21ai_1
XFILLER_35_652 VPWR VGND sg13cmos5l_decap_8
X_2957_ _4112_/D _3047_/B _3049_/A VPWR VGND sg13cmos5l_nor2_1
X_2888_ _2890_/A _2888_/A _2894_/B VPWR VGND sg13cmos5l_nor2_1
X_3509_ _3563_/B _3494_/Y _3309_/X _3509_/S VPWR VGND sg13cmos5l_mux2_1
Xhold597 _3554_/B _4194_/Q VPWR VGND sg13cmos5l_dlygate4sd3_1
XFILLER_45_427 VPWR VGND sg13cmos5l_decap_8
XFILLER_45_416 VPWR VGND sg13cmos5l_decap_8
XFILLER_26_652 VPWR VGND sg13cmos5l_decap_4
XFILLER_14_847 VPWR VGND sg13cmos5l_decap_8
XFILLER_25_162 VPWR VGND sg13cmos5l_decap_8
XFILLER_26_696 VPWR VGND sg13cmos5l_fill_2
XFILLER_41_655 VPWR VGND sg13cmos5l_fill_2
XFILLER_13_335 VPWR VGND sg13cmos5l_decap_8
XFILLER_41_688 VPWR VGND sg13cmos5l_decap_4
XFILLER_9_339 VPWR VGND sg13cmos5l_decap_4
XFILLER_13_379 VPWR VGND sg13cmos5l_decap_8
XFILLER_5_556 VPWR VGND sg13cmos5l_decap_4
XFILLER_31_84 VPWR VGND sg13cmos5l_fill_2
XFILLER_48_210 VPWR VGND sg13cmos5l_fill_2
XFILLER_49_744 VPWR VGND sg13cmos5l_decap_8
XFILLER_37_917 VPWR VGND sg13cmos5l_decap_8
XFILLER_0_294 VPWR VGND sg13cmos5l_fill_1
XFILLER_0_283 VPWR VGND sg13cmos5l_decap_8
XFILLER_45_950 VPWR VGND sg13cmos5l_decap_8
XFILLER_17_652 VPWR VGND sg13cmos5l_decap_8
XFILLER_16_162 VPWR VGND sg13cmos5l_decap_8
X_3860_ _3889_/D _3871_/A0 hold737/X _3864_/S VPWR VGND sg13cmos5l_mux2_1
XFILLER_32_644 VPWR VGND sg13cmos5l_decap_8
XFILLER_32_655 VPWR VGND sg13cmos5l_decap_8
X_2811_ _2811_/Y _2984_/A _2806_/Y _2808_/Y _2810_/Y VPWR VGND sg13cmos5l_a22oi_1
X_3791_ _3792_/B _3802_/A _3734_/B _3795_/S _3651_/B _3789_/Y VPWR VGND sg13cmos5l_a221oi_1
X_2742_ _2743_/B _4069_/Q _2713_/Y _2748_/A VPWR VGND sg13cmos5l_o21ai_1
XFILLER_9_862 VPWR VGND sg13cmos5l_decap_8
X_2673_ _2673_/Y _2673_/A _3899_/Q VPWR VGND sg13cmos5l_nor2b_1
XFILLER_28_1004 VPWR VGND sg13cmos5l_decap_8
X_4274_ _4274_/Q clkload3/A _4274_/D _4274_/RESET_B VPWR VGND sg13cmos5l_dfrbpq_1
X_3225_ _3251_/S _3255_/A _3223_/B _3224_/Y VPWR VGND sg13cmos5l_a21oi_1
X_3156_ _3157_/B _3160_/B _3160_/C _3155_/X VPWR VGND sg13cmos5l_a21oi_1
X_3087_ _4138_/D _3087_/A _3086_/Y VPWR VGND sg13cmos5l_nor2b_1
Xclkbuf_leaf_19_clk _4231_/CLK clkbuf_leaf_3_clk/A VPWR VGND sg13cmos5l_buf_8
XFILLER_36_961 VPWR VGND sg13cmos5l_decap_8
XFILLER_35_482 VPWR VGND sg13cmos5l_fill_1
XFILLER_35_1019 VPWR VGND sg13cmos5l_decap_8
XFILLER_10_349 VPWR VGND sg13cmos5l_decap_8
X_3989_ _3989_/Q _4027_/CLK _3989_/D _3989_/RESET_B VPWR VGND sg13cmos5l_dfrbpq_1
XFILLER_18_416 VPWR VGND sg13cmos5l_decap_4
XFILLER_46_758 VPWR VGND sg13cmos5l_decap_8
XFILLER_45_268 VPWR VGND sg13cmos5l_fill_1
XFILLER_26_51 VPWR VGND sg13cmos5l_decap_8
XFILLER_27_950 VPWR VGND sg13cmos5l_decap_8
XFILLER_27_994 VPWR VGND sg13cmos5l_decap_8
XFILLER_42_975 VPWR VGND sg13cmos5l_decap_8
XFILLER_14_644 VPWR VGND sg13cmos5l_decap_8
XFILLER_41_474 VPWR VGND sg13cmos5l_decap_8
XFILLER_42_83 VPWR VGND sg13cmos5l_decap_8
XFILLER_6_810 VPWR VGND sg13cmos5l_decap_4
XFILLER_47_7 VPWR VGND sg13cmos5l_decap_8
XFILLER_3_11 VPWR VGND sg13cmos5l_fill_2
XFILLER_3_77 VPWR VGND sg13cmos5l_fill_1
X_3010_ _3012_/B hold906/X _3016_/C _3009_/Y VPWR VGND sg13cmos5l_o21ai_1
XFILLER_37_747 VPWR VGND sg13cmos5l_fill_1
XFILLER_3_1028 VPWR VGND sg13cmos5l_fill_1
XFILLER_36_213 VPWR VGND sg13cmos5l_fill_1
XFILLER_36_235 VPWR VGND sg13cmos5l_fill_1
XFILLER_18_961 VPWR VGND sg13cmos5l_fill_2
XFILLER_18_983 VPWR VGND sg13cmos5l_decap_8
XFILLER_33_920 VPWR VGND sg13cmos5l_decap_8
X_3912_ _3912_/Q clkload9/A _3912_/D _3912_/RESET_B VPWR VGND sg13cmos5l_dfrbpq_1
X_3843_ _3843_/Y _3834_/X _3843_/B VPWR VGND sg13cmos5l_nand2b_1
XFILLER_33_997 VPWR VGND sg13cmos5l_decap_8
X_3774_ _3774_/Y _3768_/B _3774_/B VPWR VGND sg13cmos5l_nand2b_1
X_2725_ _4061_/D _2789_/A _2775_/D VPWR VGND sg13cmos5l_nor2_1
XFILLER_9_692 VPWR VGND sg13cmos5l_decap_8
Xclkbuf_leaf_8_clk clkload7/A clkload0/A VPWR VGND sg13cmos5l_buf_8
X_2656_ _2656_/Y _2662_/A _2655_/X _2654_/Y VPWR VGND sg13cmos5l_a21oi_1
Xfanout104 _3859_/A0 _2416_/A0 VPWR VGND sg13cmos5l_buf_1
X_2587_ _2587_/X _3930_/Q _3913_/Q _2657_/S VPWR VGND sg13cmos5l_mux2_1
Xfanout115 _3873_/A0 input12/X VPWR VGND sg13cmos5l_buf_1
Xfanout126 _2688_/A _3827_/B1 VPWR VGND sg13cmos5l_buf_1
X_4257_ _4257_/Q _4277_/CLK _4257_/D _4257_/RESET_B VPWR VGND sg13cmos5l_dfrbpq_1
X_4188_ _4188_/Q _4259_/CLK _4188_/D _4188_/RESET_B VPWR VGND sg13cmos5l_dfrbpq_1
X_3208_ _3208_/Y _2176_/A _3553_/A2 _3212_/A VPWR VGND sg13cmos5l_o21ai_1
X_3139_ _3139_/Y _4138_/Q _4117_/Q VPWR VGND sg13cmos5l_nor2_1
XFILLER_27_235 VPWR VGND sg13cmos5l_decap_8
XFILLER_28_758 VPWR VGND sg13cmos5l_decap_4
XFILLER_16_909 VPWR VGND sg13cmos5l_decap_8
XFILLER_43_728 VPWR VGND sg13cmos5l_decap_8
XFILLER_6_106 VPWR VGND sg13cmos5l_decap_8
XFILLER_12_20 VPWR VGND sg13cmos5l_decap_8
XFILLER_6_139 VPWR VGND sg13cmos5l_fill_1
XFILLER_3_846 VPWR VGND sg13cmos5l_decap_8
XFILLER_2_345 VPWR VGND sg13cmos5l_decap_8
XFILLER_46_566 VPWR VGND sg13cmos5l_decap_4
XFILLER_18_257 VPWR VGND sg13cmos5l_fill_1
XFILLER_46_588 VPWR VGND sg13cmos5l_decap_8
XFILLER_34_739 VPWR VGND sg13cmos5l_decap_8
XFILLER_42_783 VPWR VGND sg13cmos5l_fill_2
XFILLER_18_1025 VPWR VGND sg13cmos5l_decap_4
X_3490_ _3490_/Y _3490_/A _3490_/B VPWR VGND sg13cmos5l_xnor2_1
X_2510_ _2510_/Y _2510_/A _3833_/B VPWR VGND sg13cmos5l_nand2_1
XFILLER_6_673 VPWR VGND sg13cmos5l_fill_2
X_2441_ _2441_/Y _2451_/A _2441_/B VPWR VGND sg13cmos5l_nand2_1
XFILLER_45_4 VPWR VGND sg13cmos5l_fill_2
X_2372_ _2378_/S _3855_/D _2372_/B VPWR VGND sg13cmos5l_nand2_1
X_4111_ _4111_/Q _4137_/CLK _4111_/D _4111_/RESET_B VPWR VGND sg13cmos5l_dfrbpq_1
X_4275__560 _4275_/RESET_B VPWR VGND sg13cmos5l_tiehi
X_4042_ _4042_/Q _4278_/CLK _4042_/D _4042_/RESET_B VPWR VGND sg13cmos5l_dfrbpq_1
XFILLER_49_393 VPWR VGND sg13cmos5l_decap_8
XFILLER_24_238 VPWR VGND sg13cmos5l_decap_4
XFILLER_32_293 VPWR VGND sg13cmos5l_fill_1
X_3826_ _3826_/Y _4274_/Q _3825_/Y _3818_/A VPWR VGND sg13cmos5l_a21oi_1
X_3757_ _3757_/Y _3749_/X _3752_/Y _3755_/X _3480_/B _3756_/Y VPWR VGND sg13cmos5l_a221oi_1
X_2708_ _2711_/A _4081_/Q _4059_/Q VPWR VGND sg13cmos5l_nand2_1
X_4048__182 _4048_/D VPWR VGND sg13cmos5l_tielo
X_3688_ _3688_/Y _3690_/A _3690_/B _3684_/Y VPWR VGND sg13cmos5l_a21oi_1
X_2639_ _2639_/Y _2639_/A _3907_/Q VPWR VGND sg13cmos5l_nor2b_1
XFILLER_0_816 VPWR VGND sg13cmos5l_decap_8
X_3896__551 _3896_/RESET_B VPWR VGND sg13cmos5l_tiehi
XFILLER_15_216 VPWR VGND sg13cmos5l_decap_4
XFILLER_28_588 VPWR VGND sg13cmos5l_decap_4
XFILLER_8_927 VPWR VGND sg13cmos5l_decap_8
XFILLER_11_488 VPWR VGND sg13cmos5l_decap_8
XFILLER_48_1007 VPWR VGND sg13cmos5l_decap_8
XFILLER_2_142 VPWR VGND sg13cmos5l_decap_8
XFILLER_47_875 VPWR VGND sg13cmos5l_decap_8
XFILLER_0_78 VPWR VGND sg13cmos5l_fill_2
XFILLER_34_503 VPWR VGND sg13cmos5l_decap_4
XFILLER_34_558 VPWR VGND sg13cmos5l_decap_4
X_2990_ _2990_/Y _2990_/A _3047_/A _2990_/C _2995_/D VPWR VGND sg13cmos5l_nand4_1
XFILLER_42_580 VPWR VGND sg13cmos5l_decap_4
XFILLER_15_783 VPWR VGND sg13cmos5l_fill_1
XFILLER_30_775 VPWR VGND sg13cmos5l_fill_1
X_3611_ _4234_/D _3611_/A _3610_/Y VPWR VGND sg13cmos5l_nor2b_1
X_4010__281 _4010_/RESET_B VPWR VGND sg13cmos5l_tiehi
XFILLER_7_993 VPWR VGND sg13cmos5l_decap_8
X_3542_ _3542_/Y _3529_/Y _3539_/S _3541_/Y VPWR VGND sg13cmos5l_a21oi_1
Xhold916 _2175_/A _4217_/Q VPWR VGND sg13cmos5l_dlygate4sd3_1
Xhold905 _2870_/B _4095_/Q VPWR VGND sg13cmos5l_dlygate4sd3_1
Xhold927 _2196_/A _4031_/Q VPWR VGND sg13cmos5l_dlygate4sd3_1
Xhold938 _3087_/A _3085_/Y VPWR VGND sg13cmos5l_dlygate4sd3_1
Xhold949 _2784_/A _2772_/Y VPWR VGND sg13cmos5l_dlygate4sd3_1
X_3473_ _3473_/X _3473_/A _3775_/B _3473_/C VPWR VGND sg13cmos5l_and3_1
X_2424_ _2519_/B _2424_/A _2518_/B VPWR VGND sg13cmos5l_nand2_1
X_2355_ _3955_/D _2415_/A0 hold688/X _2361_/S VPWR VGND sg13cmos5l_mux2_1
XFILLER_36_0 VPWR VGND sg13cmos5l_decap_4
X_2286_ _2292_/A _2322_/A _2342_/B _3855_/C VPWR VGND sg13cmos5l_nor3_1
XFILLER_38_864 VPWR VGND sg13cmos5l_fill_1
X_4025_ _4025_/Q _4027_/CLK _4025_/D _4025_/RESET_B VPWR VGND sg13cmos5l_dfrbpq_1
XFILLER_37_396 VPWR VGND sg13cmos5l_decap_4
X_4189__159 _4189_/D VPWR VGND sg13cmos5l_tielo
XFILLER_21_764 VPWR VGND sg13cmos5l_fill_1
X_3809_ _4260_/D _3815_/A _3809_/B VPWR VGND sg13cmos5l_nor2_1
XFILLER_28_330 VPWR VGND sg13cmos5l_decap_8
XFILLER_29_853 VPWR VGND sg13cmos5l_fill_2
XFILLER_43_300 VPWR VGND sg13cmos5l_decap_4
XFILLER_28_374 VPWR VGND sg13cmos5l_fill_2
XFILLER_29_886 VPWR VGND sg13cmos5l_decap_8
XFILLER_43_322 VPWR VGND sg13cmos5l_decap_8
XFILLER_16_536 VPWR VGND sg13cmos5l_decap_8
XFILLER_43_377 VPWR VGND sg13cmos5l_decap_8
XFILLER_43_399 VPWR VGND sg13cmos5l_decap_8
XFILLER_8_713 VPWR VGND sg13cmos5l_fill_2
XFILLER_8_702 VPWR VGND sg13cmos5l_decap_8
XFILLER_7_289 VPWR VGND sg13cmos5l_decap_8
XFILLER_4_952 VPWR VGND sg13cmos5l_decap_8
XFILLER_3_462 VPWR VGND sg13cmos5l_decap_4
XFILLER_39_606 VPWR VGND sg13cmos5l_decap_8
XFILLER_47_661 VPWR VGND sg13cmos5l_decap_8
XFILLER_46_160 VPWR VGND sg13cmos5l_decap_8
XFILLER_19_363 VPWR VGND sg13cmos5l_fill_2
XFILLER_34_322 VPWR VGND sg13cmos5l_decap_8
X_2973_ _2995_/C _2974_/A _2994_/A VPWR VGND sg13cmos5l_nand2b_1
Xhold702 hold702/X _3914_/Q VPWR VGND sg13cmos5l_dlygate4sd3_1
Xhold735 hold735/X _3915_/Q VPWR VGND sg13cmos5l_dlygate4sd3_1
X_3525_ _3525_/Y _3525_/A VPWR VGND sg13cmos5l_inv_1
Xhold746 hold746/X _3919_/Q VPWR VGND sg13cmos5l_dlygate4sd3_1
Xhold713 hold713/X _3926_/Q VPWR VGND sg13cmos5l_dlygate4sd3_1
Xhold724 _2176_/A _4161_/Q VPWR VGND sg13cmos5l_dlygate4sd3_1
Xhold768 hold768/X _3952_/Q VPWR VGND sg13cmos5l_dlygate4sd3_1
Xhold779 hold779/X _3940_/Q VPWR VGND sg13cmos5l_dlygate4sd3_1
Xhold757 _3958_/D _2358_/X VPWR VGND sg13cmos5l_dlygate4sd3_1
XFILLER_39_29 VPWR VGND sg13cmos5l_fill_1
X_3456_ _3457_/B _4210_/Q _3473_/A VPWR VGND sg13cmos5l_nor2_1
X_2407_ _3999_/D _2416_/A0 hold748/X _2411_/S VPWR VGND sg13cmos5l_mux2_1
X_3387_ _4194_/D _3389_/A _3387_/B VPWR VGND sg13cmos5l_and2_1
X_2338_ _3941_/D _3872_/A0 hold800/X _2338_/S VPWR VGND sg13cmos5l_mux2_1
X_2269_ _2282_/B _2266_/Y _2497_/B _3827_/B1 VPWR VGND sg13cmos5l_o21ai_1
XFILLER_29_149 VPWR VGND sg13cmos5l_fill_2
XFILLER_44_108 VPWR VGND sg13cmos5l_decap_4
XFILLER_38_661 VPWR VGND sg13cmos5l_decap_8
X_4008_ _4008_/Q clkload5/A _4008_/D _4008_/RESET_B VPWR VGND sg13cmos5l_dfrbpq_1
XFILLER_25_311 VPWR VGND sg13cmos5l_fill_2
XFILLER_25_322 VPWR VGND sg13cmos5l_decap_4
XFILLER_26_856 VPWR VGND sg13cmos5l_decap_8
XFILLER_38_1028 VPWR VGND sg13cmos5l_fill_1
XFILLER_40_314 VPWR VGND sg13cmos5l_decap_8
XFILLER_25_399 VPWR VGND sg13cmos5l_fill_1
XFILLER_21_561 VPWR VGND sg13cmos5l_decap_4
XFILLER_21_572 VPWR VGND sg13cmos5l_decap_8
XFILLER_5_727 VPWR VGND sg13cmos5l_fill_1
XFILLER_1_911 VPWR VGND sg13cmos5l_decap_8
XFILLER_20_75 VPWR VGND sg13cmos5l_fill_1
XFILLER_49_926 VPWR VGND sg13cmos5l_decap_8
XFILLER_1_988 VPWR VGND sg13cmos5l_decap_8
XFILLER_0_487 VPWR VGND sg13cmos5l_decap_8
X_4000__291 _4000_/RESET_B VPWR VGND sg13cmos5l_tiehi
XFILLER_17_801 VPWR VGND sg13cmos5l_fill_1
XFILLER_16_300 VPWR VGND sg13cmos5l_fill_1
XFILLER_17_845 VPWR VGND sg13cmos5l_decap_8
XFILLER_43_141 VPWR VGND sg13cmos5l_fill_1
XFILLER_43_130 VPWR VGND sg13cmos5l_decap_8
XFILLER_16_344 VPWR VGND sg13cmos5l_decap_8
XFILLER_31_369 VPWR VGND sg13cmos5l_fill_1
XFILLER_12_572 VPWR VGND sg13cmos5l_decap_8
XFILLER_8_565 VPWR VGND sg13cmos5l_decap_8
XFILLER_6_66 VPWR VGND sg13cmos5l_decap_8
X_3310_ _3311_/B _3309_/X _3276_/Y _3310_/S VPWR VGND sg13cmos5l_mux2_1
XFILLER_4_771 VPWR VGND sg13cmos5l_decap_8
X_3241_ _3242_/B _4165_/Q _3246_/B _3227_/Y VPWR VGND sg13cmos5l_a21oi_1
X_3172_ _3172_/Y _4125_/Q _4173_/Q VPWR VGND sg13cmos5l_nand2b_1
X_2956_ _3049_/A _3154_/A hold978/X _2965_/S VPWR VGND sg13cmos5l_mux2_1
X_4129__514 _4129_/RESET_B VPWR VGND sg13cmos5l_tiehi
X_2887_ _2887_/Y _2887_/A _2892_/A _2887_/C VPWR VGND sg13cmos5l_nand3_1
XFILLER_30_391 VPWR VGND sg13cmos5l_decap_8
X_3508_ _3508_/Y _3309_/X _3509_/S VPWR VGND sg13cmos5l_nand2b_1
X_3439_ _3439_/Y _3432_/X _3435_/Y _3438_/X VPWR VGND sg13cmos5l_o21ai_1
Xhold598 _3389_/B _4164_/Q VPWR VGND sg13cmos5l_dlygate4sd3_1
XFILLER_17_119 VPWR VGND sg13cmos5l_decap_8
XFILLER_25_141 VPWR VGND sg13cmos5l_decap_8
XFILLER_41_601 VPWR VGND sg13cmos5l_decap_4
XFILLER_14_826 VPWR VGND sg13cmos5l_decap_8
XFILLER_15_31 VPWR VGND sg13cmos5l_decap_8
XFILLER_15_53 VPWR VGND sg13cmos5l_decap_8
XFILLER_40_155 VPWR VGND sg13cmos5l_fill_1
XFILLER_22_881 VPWR VGND sg13cmos5l_decap_8
XFILLER_5_502 VPWR VGND sg13cmos5l_fill_1
XFILLER_5_579 VPWR VGND sg13cmos5l_decap_8
XFILLER_49_723 VPWR VGND sg13cmos5l_decap_8
XFILLER_49_701 VPWR VGND sg13cmos5l_decap_8
XFILLER_1_785 VPWR VGND sg13cmos5l_decap_8
XFILLER_36_406 VPWR VGND sg13cmos5l_fill_2
XFILLER_44_450 VPWR VGND sg13cmos5l_decap_8
X_2810_ _2810_/Y _2810_/A _2810_/B VPWR VGND sg13cmos5l_nand2_1
X_3790_ _3790_/X _3651_/B _3795_/S _3789_/Y VPWR VGND sg13cmos5l_a21o_1
X_2741_ _2743_/A _4069_/Q _2713_/Y _2735_/Y _2739_/Y _2740_/Y VPWR VGND sg13cmos5l_a221oi_1
XFILLER_9_841 VPWR VGND sg13cmos5l_decap_8
XFILLER_31_199 VPWR VGND sg13cmos5l_decap_8
XFILLER_8_340 VPWR VGND sg13cmos5l_fill_2
X_2672_ _2672_/Y _2603_/A _3916_/Q _2675_/B2 VPWR VGND sg13cmos5l_a21oi_1
X_4273_ _4273_/Q _4280_/CLK _4273_/D _4273_/RESET_B VPWR VGND sg13cmos5l_dfrbpq_1
X_3224_ _3224_/Y _3224_/A _3224_/B _3224_/C VPWR VGND sg13cmos5l_nor3_1
.ends
