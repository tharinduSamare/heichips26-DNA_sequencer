* NGSPICE file created from heichips26_dna_sequencer.ext - technology: ihp-sg13cmos5l

* Black-box entry subcircuit for sg13cmos5l_fill_2 abstract view
.subckt sg13cmos5l_fill_2 VDD VSS
.ends

* Black-box entry subcircuit for sg13cmos5l_decap_8 abstract view
.subckt sg13cmos5l_decap_8 VDD VSS
.ends

* Black-box entry subcircuit for sg13cmos5l_nor3_1 abstract view
.subckt sg13cmos5l_nor3_1 Y A B C VDD VSS
.ends

* Black-box entry subcircuit for sg13cmos5l_nand2_1 abstract view
.subckt sg13cmos5l_nand2_1 Y A B VDD VSS
.ends

* Black-box entry subcircuit for sg13cmos5l_fill_1 abstract view
.subckt sg13cmos5l_fill_1 VDD VSS
.ends

* Black-box entry subcircuit for sg13cmos5l_a21oi_1 abstract view
.subckt sg13cmos5l_a21oi_1 Y A1 A2 B1 VDD VSS
.ends

* Black-box entry subcircuit for sg13cmos5l_a22oi_1 abstract view
.subckt sg13cmos5l_a22oi_1 Y A1 A2 B1 B2 VDD VSS
.ends

* Black-box entry subcircuit for sg13cmos5l_decap_4 abstract view
.subckt sg13cmos5l_decap_4 VDD VSS
.ends

* Black-box entry subcircuit for sg13cmos5l_tiehi abstract view
.subckt sg13cmos5l_tiehi L_HI VDD VSS
.ends

* Black-box entry subcircuit for sg13cmos5l_nor2_1 abstract view
.subckt sg13cmos5l_nor2_1 Y A B VDD VSS
.ends

* Black-box entry subcircuit for sg13cmos5l_or2_1 abstract view
.subckt sg13cmos5l_or2_1 X A B VDD VSS
.ends

* Black-box entry subcircuit for sg13cmos5l_and2_1 abstract view
.subckt sg13cmos5l_and2_1 X A B VDD VSS
.ends

* Black-box entry subcircuit for sg13cmos5l_mux2_1 abstract view
.subckt sg13cmos5l_mux2_1 X A0 A1 S VDD VSS
.ends

* Black-box entry subcircuit for sg13cmos5l_o21ai_1 abstract view
.subckt sg13cmos5l_o21ai_1 Y A1 A2 B1 VDD VSS
.ends

* Black-box entry subcircuit for sg13cmos5l_dfrbpq_1 abstract view
.subckt sg13cmos5l_dfrbpq_1 Q CLK D RESET_B VDD VSS
.ends

* Black-box entry subcircuit for sg13cmos5l_or3_1 abstract view
.subckt sg13cmos5l_or3_1 X A B C VDD VSS
.ends

* Black-box entry subcircuit for sg13cmos5l_inv_1 abstract view
.subckt sg13cmos5l_inv_1 Y A VDD VSS
.ends

* Black-box entry subcircuit for sg13cmos5l_dlygate4sd3_1 abstract view
.subckt sg13cmos5l_dlygate4sd3_1 X A VDD VSS
.ends

* Black-box entry subcircuit for sg13cmos5l_xnor2_1 abstract view
.subckt sg13cmos5l_xnor2_1 Y A B VDD VSS
.ends

* Black-box entry subcircuit for sg13cmos5l_nor2b_1 abstract view
.subckt sg13cmos5l_nor2b_1 Y A B_N VDD VSS
.ends

* Black-box entry subcircuit for sg13cmos5l_nand2b_1 abstract view
.subckt sg13cmos5l_nand2b_1 Y A_N B VDD VSS
.ends

* Black-box entry subcircuit for sg13cmos5l_a221oi_1 abstract view
.subckt sg13cmos5l_a221oi_1 Y A1 A2 B1 B2 C1 VDD VSS
.ends

* Black-box entry subcircuit for sg13cmos5l_a21o_1 abstract view
.subckt sg13cmos5l_a21o_1 X A1 A2 B1 VDD VSS
.ends

* Black-box entry subcircuit for sg13cmos5l_tielo abstract view
.subckt sg13cmos5l_tielo L_LO VDD VSS
.ends

* Black-box entry subcircuit for sg13cmos5l_xor2_1 abstract view
.subckt sg13cmos5l_xor2_1 X A B VDD VSS
.ends

* Black-box entry subcircuit for sg13cmos5l_and3_1 abstract view
.subckt sg13cmos5l_and3_1 X A B C VDD VSS
.ends

* Black-box entry subcircuit for sg13cmos5l_nor4_1 abstract view
.subckt sg13cmos5l_nor4_1 Y A B C D VDD VSS
.ends

* Black-box entry subcircuit for sg13cmos5l_nand4_1 abstract view
.subckt sg13cmos5l_nand4_1 Y A B C D VDD VSS
.ends

* Black-box entry subcircuit for sg13cmos5l_buf_8 abstract view
.subckt sg13cmos5l_buf_8 X A VDD VSS
.ends

* Black-box entry subcircuit for sg13cmos5l_nand3_1 abstract view
.subckt sg13cmos5l_nand3_1 Y A B C VDD VSS
.ends

* Black-box entry subcircuit for sg13cmos5l_buf_1 abstract view
.subckt sg13cmos5l_buf_1 X A VDD VSS
.ends

* Black-box entry subcircuit for sg13cmos5l_inv_4 abstract view
.subckt sg13cmos5l_inv_4 Y A VDD VSS
.ends

* Black-box entry subcircuit for sg13cmos5l_nand3b_1 abstract view
.subckt sg13cmos5l_nand3b_1 Y A_N B C VDD VSS
.ends

* Black-box entry subcircuit for sg13cmos5l_inv_8 abstract view
.subckt sg13cmos5l_inv_8 Y A VDD VSS
.ends

* Black-box entry subcircuit for sg13cmos5l_inv_2 abstract view
.subckt sg13cmos5l_inv_2 Y A VDD VSS
.ends

* Black-box entry subcircuit for sg13cmos5l_mux4_1 abstract view
.subckt sg13cmos5l_mux4_1 X A0 A1 A2 A3 S0 S1 VDD VSS
.ends

.subckt heichips26_dna_sequencer VGND VPWR clk ena rst_n ui_in[0] ui_in[1] ui_in[2]
+ ui_in[3] ui_in[4] ui_in[5] ui_in[6] ui_in[7] uio_in[0] uio_in[1] uio_in[2] uio_in[3]
+ uio_in[4] uio_in[5] uio_in[6] uio_in[7] uio_oe[0] uio_oe[1] uio_oe[2] uio_oe[3]
+ uio_oe[4] uio_oe[5] uio_oe[6] uio_oe[7] uio_out[0] uio_out[1] uio_out[2] uio_out[3]
+ uio_out[4] uio_out[5] uio_out[6] uio_out[7] uo_out[0] uo_out[1] uo_out[2] uo_out[3]
+ uo_out[4] uo_out[5] uo_out[6] uo_out[7]
XFILLER_28_907 VPWR VGND sg13cmos5l_fill_2
XFILLER_39_277 VPWR VGND sg13cmos5l_decap_8
X_3155_ _3161_/B _3485_/Q _3483_/Q _3484_/Q VPWR VGND sg13cmos5l_nor3_1
X_2106_ _2106_/Y _2262_/A _2216_/A VPWR VGND sg13cmos5l_nand2_1
XFILLER_39_288 VPWR VGND sg13cmos5l_fill_1
X_3086_ _3086_/Y _3492_/Q _3086_/B _3095_/B VPWR VGND sg13cmos5l_nor3_1
X_2037_ _3318_/D _2115_/A hold615/X _2087_/A VPWR VGND sg13cmos5l_a21oi_1
XFILLER_36_973 VPWR VGND sg13cmos5l_decap_8
XFILLER_23_623 VPWR VGND sg13cmos5l_fill_2
XFILLER_22_122 VPWR VGND sg13cmos5l_fill_2
XFILLER_23_645 VPWR VGND sg13cmos5l_decap_8
XFILLER_35_494 VPWR VGND sg13cmos5l_decap_8
X_2939_ _2942_/B _1830_/A _3125_/A _2930_/A _2774_/B VPWR VGND sg13cmos5l_a22oi_1
XFILLER_11_1020 VPWR VGND sg13cmos5l_decap_8
XFILLER_46_737 VPWR VGND sg13cmos5l_decap_8
XFILLER_27_951 VPWR VGND sg13cmos5l_decap_8
XFILLER_33_409 VPWR VGND sg13cmos5l_fill_2
XFILLER_42_910 VPWR VGND sg13cmos5l_decap_8
XFILLER_13_111 VPWR VGND sg13cmos5l_decap_8
XFILLER_42_987 VPWR VGND sg13cmos5l_decap_8
XFILLER_41_453 VPWR VGND sg13cmos5l_decap_8
XFILLER_9_115 VPWR VGND sg13cmos5l_decap_4
XFILLER_13_155 VPWR VGND sg13cmos5l_decap_8
XFILLER_14_689 VPWR VGND sg13cmos5l_decap_4
XFILLER_9_137 VPWR VGND sg13cmos5l_decap_4
XFILLER_42_84 VPWR VGND sg13cmos5l_decap_8
XFILLER_6_811 VPWR VGND sg13cmos5l_decap_8
XFILLER_9_159 VPWR VGND sg13cmos5l_decap_8
XFILLER_5_310 VPWR VGND sg13cmos5l_decap_8
XFILLER_10_884 VPWR VGND sg13cmos5l_decap_8
XFILLER_6_888 VPWR VGND sg13cmos5l_decap_8
XFILLER_5_365 VPWR VGND sg13cmos5l_fill_2
XFILLER_3_12 VPWR VGND sg13cmos5l_fill_2
X_3488__167 _3488_/RESET_B VPWR VGND sg13cmos5l_tiehi
XFILLER_3_78 VPWR VGND sg13cmos5l_decap_8
XFILLER_49_553 VPWR VGND sg13cmos5l_decap_8
XFILLER_18_995 VPWR VGND sg13cmos5l_decap_8
XFILLER_32_442 VPWR VGND sg13cmos5l_decap_4
XFILLER_33_987 VPWR VGND sg13cmos5l_decap_8
XFILLER_9_693 VPWR VGND sg13cmos5l_fill_1
X_2724_ _2724_/Y _2521_/A _2715_/X _2737_/B _2518_/A VPWR VGND sg13cmos5l_a22oi_1
X_2655_ _2655_/Y _2655_/A _2655_/B VPWR VGND sg13cmos5l_nor2_1
X_2586_ _2586_/Y _2586_/A _2596_/A VPWR VGND sg13cmos5l_nor2_1
XFILLER_41_1024 VPWR VGND sg13cmos5l_decap_4
X_3207_ _3208_/B _3207_/A _3207_/B VPWR VGND sg13cmos5l_nand2_1
X_3138_ _3138_/Y _3208_/A _3207_/A VPWR VGND sg13cmos5l_nand2_1
XFILLER_15_409 VPWR VGND sg13cmos5l_fill_1
XFILLER_27_258 VPWR VGND sg13cmos5l_decap_8
X_3069_ _3070_/B _3069_/A _3069_/B VPWR VGND sg13cmos5l_nand2_1
XFILLER_24_910 VPWR VGND sg13cmos5l_decap_4
XFILLER_27_269 VPWR VGND sg13cmos5l_fill_1
X_3404__257 _3404_/RESET_B VPWR VGND sg13cmos5l_tiehi
XFILLER_24_954 VPWR VGND sg13cmos5l_decap_8
XFILLER_35_291 VPWR VGND sg13cmos5l_decap_8
XFILLER_11_626 VPWR VGND sg13cmos5l_fill_1
XFILLER_3_814 VPWR VGND sg13cmos5l_decap_8
XFILLER_12_98 VPWR VGND sg13cmos5l_decap_8
XFILLER_37_51 VPWR VGND sg13cmos5l_fill_1
XFILLER_37_84 VPWR VGND sg13cmos5l_fill_1
XFILLER_18_258 VPWR VGND sg13cmos5l_decap_8
XFILLER_19_759 VPWR VGND sg13cmos5l_decap_8
XFILLER_14_431 VPWR VGND sg13cmos5l_fill_1
XFILLER_27_792 VPWR VGND sg13cmos5l_decap_4
XFILLER_42_773 VPWR VGND sg13cmos5l_fill_1
XFILLER_15_987 VPWR VGND sg13cmos5l_decap_8
XFILLER_41_283 VPWR VGND sg13cmos5l_fill_1
XFILLER_5_173 VPWR VGND sg13cmos5l_decap_4
XFILLER_5_151 VPWR VGND sg13cmos5l_decap_4
X_2440_ _2440_/Y _3401_/Q _3374_/Q VPWR VGND sg13cmos5l_nand2_1
XFILLER_5_184 VPWR VGND sg13cmos5l_fill_1
X_2371_ _2371_/X _2371_/A _2372_/C VPWR VGND sg13cmos5l_or2_1
XFILLER_38_4 VPWR VGND sg13cmos5l_decap_8
XFILLER_49_383 VPWR VGND sg13cmos5l_decap_8
X_2707_ _3448_/D _2786_/B _2794_/A VPWR VGND sg13cmos5l_and2_1
X_3334__340 _3334_/RESET_B VPWR VGND sg13cmos5l_tiehi
X_2638_ _2639_/B _3440_/Q _2645_/B _2662_/C _2637_/Y VPWR VGND sg13cmos5l_a22oi_1
X_2569_ _2569_/Y _3443_/Q _2569_/B VPWR VGND sg13cmos5l_nand2_1
XFILLER_16_707 VPWR VGND sg13cmos5l_decap_4
XFILLER_28_534 VPWR VGND sg13cmos5l_fill_2
X_3341__333 _3341_/RESET_B VPWR VGND sg13cmos5l_tiehi
XFILLER_43_537 VPWR VGND sg13cmos5l_fill_1
XFILLER_24_751 VPWR VGND sg13cmos5l_fill_2
XFILLER_24_773 VPWR VGND sg13cmos5l_decap_8
X_3478__177 _3478_/RESET_B VPWR VGND sg13cmos5l_tiehi
XFILLER_8_939 VPWR VGND sg13cmos5l_decap_8
XFILLER_11_456 VPWR VGND sg13cmos5l_decap_8
XFILLER_12_957 VPWR VGND sg13cmos5l_decap_8
XFILLER_7_427 VPWR VGND sg13cmos5l_decap_8
XFILLER_2_143 VPWR VGND sg13cmos5l_decap_8
XFILLER_19_501 VPWR VGND sg13cmos5l_decap_4
XFILLER_19_523 VPWR VGND sg13cmos5l_decap_4
XFILLER_47_843 VPWR VGND sg13cmos5l_decap_8
XFILLER_0_46 VPWR VGND sg13cmos5l_decap_8
XFILLER_34_515 VPWR VGND sg13cmos5l_decap_4
XFILLER_9_11 VPWR VGND sg13cmos5l_decap_8
XFILLER_15_740 VPWR VGND sg13cmos5l_decap_8
XFILLER_15_762 VPWR VGND sg13cmos5l_decap_8
X_1940_ _1940_/X input12/X hold499/X _1941_/S VPWR VGND sg13cmos5l_mux2_1
XFILLER_15_795 VPWR VGND sg13cmos5l_decap_8
X_1871_ _1871_/Y hold423/X _1962_/A _2018_/A VPWR VGND sg13cmos5l_o21ai_1
XFILLER_31_1001 VPWR VGND sg13cmos5l_decap_8
X_3541_ _3541_/Q clkload3/A _3541_/D _3541_/RESET_B VPWR VGND sg13cmos5l_dfrbpq_1
XFILLER_7_983 VPWR VGND sg13cmos5l_decap_8
XFILLER_6_493 VPWR VGND sg13cmos5l_decap_8
X_3472_ _3472_/Q _3472_/CLK _3472_/D _3472_/RESET_B VPWR VGND sg13cmos5l_dfrbpq_1
X_2423_ _3400_/D _1811_/Y _3117_/A2 _2422_/Y VPWR VGND sg13cmos5l_a21oi_1
X_3288__412 _3288_/RESET_B VPWR VGND sg13cmos5l_tiehi
X_2354_ _2363_/A _3362_/Q _3360_/Q _3361_/Q VPWR VGND sg13cmos5l_or3_1
XFILLER_29_0 VPWR VGND sg13cmos5l_fill_2
X_2285_ _2286_/B _2285_/A _2285_/B VPWR VGND sg13cmos5l_nor2_1
XFILLER_38_865 VPWR VGND sg13cmos5l_decap_4
XFILLER_37_331 VPWR VGND sg13cmos5l_decap_8
XFILLER_25_515 VPWR VGND sg13cmos5l_decap_4
XFILLER_21_721 VPWR VGND sg13cmos5l_decap_8
XFILLER_21_776 VPWR VGND sg13cmos5l_decap_8
XFILLER_0_636 VPWR VGND sg13cmos5l_decap_8
XFILLER_18_42 VPWR VGND sg13cmos5l_decap_8
XFILLER_28_353 VPWR VGND sg13cmos5l_decap_8
XFILLER_44_846 VPWR VGND sg13cmos5l_fill_2
XFILLER_43_367 VPWR VGND sg13cmos5l_fill_1
XFILLER_12_721 VPWR VGND sg13cmos5l_decap_8
XFILLER_24_570 VPWR VGND sg13cmos5l_fill_2
XFILLER_34_63 VPWR VGND sg13cmos5l_decap_4
XFILLER_11_231 VPWR VGND sg13cmos5l_fill_2
XFILLER_7_202 VPWR VGND sg13cmos5l_decap_8
XFILLER_12_798 VPWR VGND sg13cmos5l_decap_8
XFILLER_11_286 VPWR VGND sg13cmos5l_decap_8
XFILLER_4_931 VPWR VGND sg13cmos5l_decap_8
XFILLER_3_441 VPWR VGND sg13cmos5l_decap_8
XFILLER_3_485 VPWR VGND sg13cmos5l_decap_4
XFILLER_39_618 VPWR VGND sg13cmos5l_decap_8
X_2070_ _2070_/Y _2070_/A _3272_/Q VPWR VGND sg13cmos5l_nand2_1
XFILLER_19_397 VPWR VGND sg13cmos5l_decap_8
X_3324__350 _3324_/RESET_B VPWR VGND sg13cmos5l_tiehi
XFILLER_34_323 VPWR VGND sg13cmos5l_fill_1
XFILLER_35_835 VPWR VGND sg13cmos5l_decap_4
XFILLER_35_879 VPWR VGND sg13cmos5l_decap_8
X_2972_ _2972_/Y _2974_/B _2974_/C _2974_/A VPWR VGND sg13cmos5l_o21ai_1
X_1923_ _3275_/D input5/X hold511/X _1923_/S VPWR VGND sg13cmos5l_mux2_1
X_1854_ _1854_/Y _3457_/Q VPWR VGND sg13cmos5l_inv_1
Xhold703 hold703/X _3446_/Q VPWR VGND sg13cmos5l_dlygate4sd3_1
Xhold736 _2504_/A _3418_/Q VPWR VGND sg13cmos5l_dlygate4sd3_1
Xhold714 _2806_/A _3470_/Q VPWR VGND sg13cmos5l_dlygate4sd3_1
Xhold725 _2488_/B _3415_/Q VPWR VGND sg13cmos5l_dlygate4sd3_1
X_3524_ _3524_/Q _3527_/CLK _3524_/D _3524_/RESET_B VPWR VGND sg13cmos5l_dfrbpq_1
X_3331__343 _3331_/RESET_B VPWR VGND sg13cmos5l_tiehi
X_3455_ _3455_/Q _3485_/CLK _3455_/D _3455_/RESET_B VPWR VGND sg13cmos5l_dfrbpq_1
X_2406_ _2408_/B _2402_/Y _2403_/Y _2405_/Y VPWR VGND sg13cmos5l_o21ai_1
X_3386_ _3386_/Q _3442_/CLK _3386_/D _3386_/RESET_B VPWR VGND sg13cmos5l_dfrbpq_1
X_3468__187 _3468_/RESET_B VPWR VGND sg13cmos5l_tiehi
X_2337_ _2434_/A _2552_/A hold705/X _2346_/S VPWR VGND sg13cmos5l_mux2_1
XFILLER_29_139 VPWR VGND sg13cmos5l_decap_8
X_2268_ _2268_/Y _3369_/Q _3346_/Q VPWR VGND sg13cmos5l_xnor2_1
X_2199_ _2199_/Y _2430_/A _2199_/B VPWR VGND sg13cmos5l_nand2_1
XFILLER_40_304 VPWR VGND sg13cmos5l_decap_8
XFILLER_13_518 VPWR VGND sg13cmos5l_decap_8
XFILLER_40_337 VPWR VGND sg13cmos5l_decap_8
XFILLER_21_540 VPWR VGND sg13cmos5l_decap_8
XFILLER_4_249 VPWR VGND sg13cmos5l_decap_8
XFILLER_20_76 VPWR VGND sg13cmos5l_fill_1
XFILLER_1_956 VPWR VGND sg13cmos5l_decap_8
XFILLER_0_466 VPWR VGND sg13cmos5l_decap_8
XFILLER_29_30 VPWR VGND sg13cmos5l_fill_2
XFILLER_0_499 VPWR VGND sg13cmos5l_decap_8
XFILLER_21_1011 VPWR VGND sg13cmos5l_decap_8
XFILLER_29_63 VPWR VGND sg13cmos5l_fill_1
XFILLER_16_323 VPWR VGND sg13cmos5l_decap_4
XFILLER_43_142 VPWR VGND sg13cmos5l_decap_4
XFILLER_16_356 VPWR VGND sg13cmos5l_decap_8
XFILLER_28_194 VPWR VGND sg13cmos5l_fill_1
XFILLER_45_84 VPWR VGND sg13cmos5l_fill_1
XFILLER_44_698 VPWR VGND sg13cmos5l_decap_4
XFILLER_43_186 VPWR VGND sg13cmos5l_decap_8
XFILLER_32_827 VPWR VGND sg13cmos5l_fill_2
X_3497__394 _3497_/RESET_B VPWR VGND sg13cmos5l_tiehi
XFILLER_25_890 VPWR VGND sg13cmos5l_decap_8
XFILLER_8_511 VPWR VGND sg13cmos5l_decap_8
XFILLER_12_584 VPWR VGND sg13cmos5l_decap_8
X_3430__231 _3430_/RESET_B VPWR VGND sg13cmos5l_tiehi
X_3240_ _3241_/C _3240_/A _3226_/Y VPWR VGND sg13cmos5l_nor2b_1
X_3285__415 _3285_/RESET_B VPWR VGND sg13cmos5l_tiehi
X_3171_ _3184_/S _3167_/Y _3170_/Y _2865_/Y VPWR VGND sg13cmos5l_o21ai_1
XFILLER_20_4 VPWR VGND sg13cmos5l_decap_8
X_2122_ _2122_/X _2032_/Y _2121_/Y _2123_/C VPWR VGND sg13cmos5l_mux2_1
XFILLER_39_437 VPWR VGND sg13cmos5l_decap_8
XFILLER_48_971 VPWR VGND sg13cmos5l_decap_8
XFILLER_26_109 VPWR VGND sg13cmos5l_decap_4
X_2053_ _2053_/Y _2043_/A _3280_/Q _2042_/Y VPWR VGND sg13cmos5l_a21oi_1
XFILLER_23_805 VPWR VGND sg13cmos5l_fill_2
XFILLER_23_827 VPWR VGND sg13cmos5l_fill_2
XFILLER_34_197 VPWR VGND sg13cmos5l_decap_8
X_2955_ _3095_/A _3492_/Q _2955_/B VPWR VGND sg13cmos5l_nand2b_1
X_1906_ _3260_/D hold534/X input7/X _1912_/S VPWR VGND sg13cmos5l_mux2_1
X_2886_ _3481_/D _2968_/B _2976_/A VPWR VGND sg13cmos5l_nor2_1
X_3292__408 _3292_/RESET_B VPWR VGND sg13cmos5l_tiehi
X_1837_ _2432_/A _2373_/B VPWR VGND sg13cmos5l_inv_1
Xhold500 _3290_/D _1940_/X VPWR VGND sg13cmos5l_dlygate4sd3_1
Xhold511 hold511/X _3275_/Q VPWR VGND sg13cmos5l_dlygate4sd3_1
Xhold533 _3274_/D _1922_/X VPWR VGND sg13cmos5l_dlygate4sd3_1
X_3507_ _3507_/Q clkload4/A _3507_/D _3507_/RESET_B VPWR VGND sg13cmos5l_dfrbpq_1
Xhold544 _1802_/A _3517_/Q VPWR VGND sg13cmos5l_dlygate4sd3_1
Xhold522 _2446_/A _3401_/Q VPWR VGND sg13cmos5l_dlygate4sd3_1
Xhold555 hold555/X _2027_/Y VPWR VGND sg13cmos5l_dlygate4sd3_1
Xhold566 _3236_/B _3235_/Y VPWR VGND sg13cmos5l_dlygate4sd3_1
Xhold588 _3424_/D _2593_/Y VPWR VGND sg13cmos5l_dlygate4sd3_1
Xhold577 hold577/X _3464_/Q VPWR VGND sg13cmos5l_dlygate4sd3_1
XFILLER_44_1022 VPWR VGND sg13cmos5l_decap_8
Xhold599 _2417_/B _3396_/Q VPWR VGND sg13cmos5l_dlygate4sd3_1
X_3438_ _3438_/Q _3444_/CLK _3438_/D _3438_/RESET_B VPWR VGND sg13cmos5l_dfrbpq_1
X_3369_ _3369_/Q _3551_/CLK _3369_/D _3369_/RESET_B VPWR VGND sg13cmos5l_dfrbpq_1
XFILLER_39_982 VPWR VGND sg13cmos5l_decap_8
XFILLER_38_481 VPWR VGND sg13cmos5l_decap_8
XFILLER_26_610 VPWR VGND sg13cmos5l_decap_8
XFILLER_41_602 VPWR VGND sg13cmos5l_fill_1
XFILLER_13_315 VPWR VGND sg13cmos5l_fill_2
XFILLER_13_337 VPWR VGND sg13cmos5l_decap_8
XFILLER_15_65 VPWR VGND sg13cmos5l_decap_8
XFILLER_40_189 VPWR VGND sg13cmos5l_decap_8
XFILLER_1_753 VPWR VGND sg13cmos5l_decap_8
XFILLER_49_757 VPWR VGND sg13cmos5l_decap_8
XFILLER_29_481 VPWR VGND sg13cmos5l_decap_8
XFILLER_45_963 VPWR VGND sg13cmos5l_decap_8
XFILLER_44_484 VPWR VGND sg13cmos5l_fill_2
XFILLER_16_153 VPWR VGND sg13cmos5l_decap_4
XFILLER_17_676 VPWR VGND sg13cmos5l_decap_8
XFILLER_17_687 VPWR VGND sg13cmos5l_fill_2
XFILLER_31_134 VPWR VGND sg13cmos5l_decap_8
XFILLER_32_635 VPWR VGND sg13cmos5l_fill_2
XFILLER_31_145 VPWR VGND sg13cmos5l_fill_1
XFILLER_32_668 VPWR VGND sg13cmos5l_decap_4
X_2740_ _3453_/D _2839_/A _2794_/B VPWR VGND sg13cmos5l_nor2_1
XFILLER_8_352 VPWR VGND sg13cmos5l_decap_4
XFILLER_9_886 VPWR VGND sg13cmos5l_decap_8
X_2671_ _3443_/D _2673_/A _2671_/B VPWR VGND sg13cmos5l_nor2_1
XFILLER_8_374 VPWR VGND sg13cmos5l_decap_8
X_3223_ _3534_/D _3223_/A _3223_/B VPWR VGND sg13cmos5l_nor2_1
XFILLER_39_223 VPWR VGND sg13cmos5l_decap_4
XFILLER_39_256 VPWR VGND sg13cmos5l_fill_1
X_3154_ _3154_/Y _3172_/B _3152_/X _3153_/X _3122_/A VPWR VGND sg13cmos5l_a22oi_1
X_2105_ _2110_/S _2099_/Y _2103_/Y _2104_/Y VPWR VGND sg13cmos5l_o21ai_1
X_3085_ _3085_/Y _2948_/Y _3095_/B _3084_/Y VPWR VGND sg13cmos5l_o21ai_1
X_2036_ _3317_/D _2033_/Y _2035_/Y _2087_/A VPWR VGND sg13cmos5l_a21oi_1
XFILLER_36_952 VPWR VGND sg13cmos5l_decap_8
XFILLER_22_134 VPWR VGND sg13cmos5l_decap_4
XFILLER_11_808 VPWR VGND sg13cmos5l_fill_1
XFILLER_23_668 VPWR VGND sg13cmos5l_fill_1
X_2938_ _2938_/Y _2951_/B _2952_/A _2947_/A _2948_/B _2937_/Y VPWR VGND sg13cmos5l_a221oi_1
XFILLER_22_189 VPWR VGND sg13cmos5l_decap_8
X_2869_ _2869_/Y _3166_/A _2863_/X _2879_/B VPWR VGND sg13cmos5l_o21ai_1
XFILLER_2_506 VPWR VGND sg13cmos5l_fill_2
XFILLER_19_919 VPWR VGND sg13cmos5l_decap_8
XFILLER_39_790 VPWR VGND sg13cmos5l_decap_8
XFILLER_27_930 VPWR VGND sg13cmos5l_decap_8
XFILLER_26_31 VPWR VGND sg13cmos5l_fill_1
XFILLER_42_966 VPWR VGND sg13cmos5l_decap_8
XFILLER_14_624 VPWR VGND sg13cmos5l_decap_8
X_3420__241 _3420_/RESET_B VPWR VGND sg13cmos5l_tiehi
XFILLER_10_863 VPWR VGND sg13cmos5l_decap_8
XFILLER_6_867 VPWR VGND sg13cmos5l_decap_8
XFILLER_1_583 VPWR VGND sg13cmos5l_decap_4
X_3282__418 _3282_/RESET_B VPWR VGND sg13cmos5l_tiehi
XFILLER_37_716 VPWR VGND sg13cmos5l_decap_4
XFILLER_49_598 VPWR VGND sg13cmos5l_decap_8
XFILLER_18_974 VPWR VGND sg13cmos5l_decap_8
XFILLER_45_793 VPWR VGND sg13cmos5l_decap_8
XFILLER_33_966 VPWR VGND sg13cmos5l_decap_8
XFILLER_20_638 VPWR VGND sg13cmos5l_decap_4
XFILLER_32_498 VPWR VGND sg13cmos5l_fill_2
X_2723_ _2723_/X _2720_/X _2722_/Y _2718_/Y VPWR VGND sg13cmos5l_a21o_1
XFILLER_8_182 VPWR VGND sg13cmos5l_decap_8
X_2654_ _2654_/Y _2650_/A _2652_/Y _2653_/Y VPWR VGND sg13cmos5l_o21ai_1
X_2585_ _2585_/Y _3425_/Q _2583_/Y _2580_/Y VPWR VGND sg13cmos5l_o21ai_1
XFILLER_41_1003 VPWR VGND sg13cmos5l_decap_8
X_3206_ _3206_/Y _3206_/A VPWR VGND sg13cmos5l_inv_1
X_3137_ _3212_/C _3208_/A _3207_/A VPWR VGND sg13cmos5l_and2_1
XFILLER_27_237 VPWR VGND sg13cmos5l_decap_8
X_3068_ _3512_/D _3125_/B _3068_/B VPWR VGND sg13cmos5l_nor2_1
X_2019_ _2087_/A _2136_/B _2019_/B VPWR VGND sg13cmos5l_nand2b_1
XFILLER_23_421 VPWR VGND sg13cmos5l_decap_8
XFILLER_24_933 VPWR VGND sg13cmos5l_decap_8
XFILLER_35_270 VPWR VGND sg13cmos5l_decap_8
XFILLER_7_609 VPWR VGND sg13cmos5l_decap_8
XFILLER_12_11 VPWR VGND sg13cmos5l_decap_8
XFILLER_12_55 VPWR VGND sg13cmos5l_decap_8
XFILLER_2_347 VPWR VGND sg13cmos5l_decap_8
XFILLER_37_63 VPWR VGND sg13cmos5l_decap_8
XFILLER_18_237 VPWR VGND sg13cmos5l_decap_8
XFILLER_15_900 VPWR VGND sg13cmos5l_decap_4
XFILLER_34_719 VPWR VGND sg13cmos5l_decap_8
XFILLER_15_966 VPWR VGND sg13cmos5l_decap_8
XFILLER_18_1016 VPWR VGND sg13cmos5l_decap_8
XFILLER_18_1027 VPWR VGND sg13cmos5l_fill_2
X_3455__101 _3455_/D VPWR VGND sg13cmos5l_tielo
XFILLER_14_487 VPWR VGND sg13cmos5l_decap_8
XFILLER_41_295 VPWR VGND sg13cmos5l_decap_8
XFILLER_30_969 VPWR VGND sg13cmos5l_decap_8
XFILLER_6_653 VPWR VGND sg13cmos5l_decap_8
XFILLER_5_130 VPWR VGND sg13cmos5l_decap_8
X_2370_ _2372_/C _2366_/Y _2367_/Y _2368_/Y _2369_/Y _2364_/Y VPWR VGND sg13cmos5l_a221oi_1
XFILLER_1_380 VPWR VGND sg13cmos5l_decap_8
XFILLER_37_502 VPWR VGND sg13cmos5l_fill_2
XFILLER_24_229 VPWR VGND sg13cmos5l_fill_2
XFILLER_33_741 VPWR VGND sg13cmos5l_decap_8
XFILLER_33_752 VPWR VGND sg13cmos5l_fill_1
XFILLER_32_284 VPWR VGND sg13cmos5l_decap_8
XFILLER_33_785 VPWR VGND sg13cmos5l_fill_2
XFILLER_21_969 VPWR VGND sg13cmos5l_decap_8
XFILLER_9_480 VPWR VGND sg13cmos5l_decap_8
XFILLER_20_479 VPWR VGND sg13cmos5l_fill_1
X_2706_ _2794_/A _2701_/S _2705_/X _2704_/Y VPWR VGND sg13cmos5l_a21o_1
X_2637_ _2637_/Y _3439_/Q _2645_/B VPWR VGND sg13cmos5l_nand2_1
X_3410__251 _3410_/RESET_B VPWR VGND sg13cmos5l_tiehi
X_2568_ _2568_/Y _2788_/A _3395_/Q _3394_/Q _2787_/A _2567_/Y VPWR VGND sg13cmos5l_a221oi_1
X_2499_ _2499_/Y _2491_/Y _2498_/X _2487_/X VPWR VGND sg13cmos5l_o21ai_1
XFILLER_28_524 VPWR VGND sg13cmos5l_fill_2
XFILLER_28_546 VPWR VGND sg13cmos5l_fill_1
XFILLER_28_579 VPWR VGND sg13cmos5l_decap_8
XFILLER_24_730 VPWR VGND sg13cmos5l_decap_8
XFILLER_12_936 VPWR VGND sg13cmos5l_decap_8
XFILLER_23_21 VPWR VGND sg13cmos5l_decap_8
XFILLER_8_918 VPWR VGND sg13cmos5l_decap_8
XFILLER_11_435 VPWR VGND sg13cmos5l_fill_2
XFILLER_20_980 VPWR VGND sg13cmos5l_decap_8
XFILLER_3_645 VPWR VGND sg13cmos5l_fill_1
XFILLER_3_634 VPWR VGND sg13cmos5l_decap_8
XFILLER_2_122 VPWR VGND sg13cmos5l_decap_8
XFILLER_47_822 VPWR VGND sg13cmos5l_decap_8
XFILLER_0_14 VPWR VGND sg13cmos5l_decap_8
XFILLER_19_546 VPWR VGND sg13cmos5l_decap_4
XFILLER_47_899 VPWR VGND sg13cmos5l_decap_8
XFILLER_42_593 VPWR VGND sg13cmos5l_fill_2
XFILLER_14_284 VPWR VGND sg13cmos5l_fill_1
X_1870_ _1962_/A _1988_/B _1870_/B VPWR VGND sg13cmos5l_nor2_1
XFILLER_30_733 VPWR VGND sg13cmos5l_decap_4
XFILLER_7_962 VPWR VGND sg13cmos5l_decap_8
X_3540_ _3540_/Q clkload3/A _3540_/D _3540_/RESET_B VPWR VGND sg13cmos5l_dfrbpq_1
X_3471_ _3471_/Q _3472_/CLK _3471_/D _3471_/RESET_B VPWR VGND sg13cmos5l_dfrbpq_1
X_2422_ _2422_/Y hold512/X _3117_/A2 _2427_/A VPWR VGND sg13cmos5l_o21ai_1
X_2353_ _2358_/B _3362_/Q _3360_/Q _3361_/Q VPWR VGND sg13cmos5l_nor3_1
X_2284_ _2303_/B _2289_/B _2288_/B VPWR VGND sg13cmos5l_and2_1
XFILLER_49_181 VPWR VGND sg13cmos5l_decap_8
XFILLER_21_733 VPWR VGND sg13cmos5l_decap_8
XFILLER_21_755 VPWR VGND sg13cmos5l_decap_8
XFILLER_33_593 VPWR VGND sg13cmos5l_fill_2
X_1999_ _2040_/B _1999_/A _2001_/D VPWR VGND sg13cmos5l_nand2_1
XFILLER_0_615 VPWR VGND sg13cmos5l_decap_8
XFILLER_47_107 VPWR VGND sg13cmos5l_decap_4
X_3484__171 _3484_/RESET_B VPWR VGND sg13cmos5l_tiehi
XFILLER_44_825 VPWR VGND sg13cmos5l_decap_8
XFILLER_18_87 VPWR VGND sg13cmos5l_decap_4
XFILLER_43_379 VPWR VGND sg13cmos5l_fill_1
XFILLER_34_42 VPWR VGND sg13cmos5l_decap_8
XFILLER_15_1008 VPWR VGND sg13cmos5l_decap_8
XFILLER_12_766 VPWR VGND sg13cmos5l_fill_1
XFILLER_12_777 VPWR VGND sg13cmos5l_decap_8
XFILLER_7_247 VPWR VGND sg13cmos5l_decap_8
XFILLER_4_910 VPWR VGND sg13cmos5l_decap_8
XFILLER_3_420 VPWR VGND sg13cmos5l_decap_8
XFILLER_4_987 VPWR VGND sg13cmos5l_decap_8
XFILLER_47_641 VPWR VGND sg13cmos5l_fill_2
XFILLER_38_129 VPWR VGND sg13cmos5l_decap_8
XFILLER_35_814 VPWR VGND sg13cmos5l_decap_8
XFILLER_46_184 VPWR VGND sg13cmos5l_decap_4
XFILLER_19_376 VPWR VGND sg13cmos5l_decap_8
XFILLER_35_858 VPWR VGND sg13cmos5l_fill_1
XFILLER_34_368 VPWR VGND sg13cmos5l_fill_2
X_2971_ _2971_/Y _2971_/A _2971_/B VPWR VGND sg13cmos5l_nor2_1
X_1922_ _1922_/X input13/X hold532/X _1922_/S VPWR VGND sg13cmos5l_mux2_1
XFILLER_15_582 VPWR VGND sg13cmos5l_decap_8
X_1853_ _2922_/B _3458_/Q VPWR VGND sg13cmos5l_inv_1
Xhold704 _2699_/B _2698_/X VPWR VGND sg13cmos5l_dlygate4sd3_1
Xhold715 hold715/X _3505_/Q VPWR VGND sg13cmos5l_dlygate4sd3_1
Xhold726 _2513_/A _2488_/Y VPWR VGND sg13cmos5l_dlygate4sd3_1
Xhold737 hold737/X _3543_/Q VPWR VGND sg13cmos5l_dlygate4sd3_1
X_3523_ _3523_/Q clkload3/A _3523_/D _3523_/RESET_B VPWR VGND sg13cmos5l_dfrbpq_1
XFILLER_6_291 VPWR VGND sg13cmos5l_decap_4
X_3454_ _3454_/Q _3485_/CLK _3454_/D _3454_/RESET_B VPWR VGND sg13cmos5l_dfrbpq_1
X_2405_ _2405_/Y _3395_/Q _2394_/Y _2404_/Y _3396_/Q VPWR VGND sg13cmos5l_a22oi_1
X_3385_ _3385_/Q _3409_/CLK _3385_/D _3385_/RESET_B VPWR VGND sg13cmos5l_dfrbpq_1
X_2336_ _2341_/B _2350_/A _2349_/B VPWR VGND sg13cmos5l_and2_1
X_2267_ _2285_/A _3371_/Q _3348_/Q VPWR VGND sg13cmos5l_nand2_1
XFILLER_38_652 VPWR VGND sg13cmos5l_fill_2
X_2198_ _3356_/D _2307_/A _2296_/A VPWR VGND sg13cmos5l_nor2_1
XFILLER_20_11 VPWR VGND sg13cmos5l_decap_8
XFILLER_20_22 VPWR VGND sg13cmos5l_fill_2
XFILLER_20_33 VPWR VGND sg13cmos5l_fill_1
XFILLER_1_935 VPWR VGND sg13cmos5l_decap_8
XFILLER_0_445 VPWR VGND sg13cmos5l_decap_8
XFILLER_49_939 VPWR VGND sg13cmos5l_decap_8
XFILLER_28_173 VPWR VGND sg13cmos5l_decap_4
XFILLER_44_655 VPWR VGND sg13cmos5l_decap_8
XFILLER_43_121 VPWR VGND sg13cmos5l_decap_8
XFILLER_32_806 VPWR VGND sg13cmos5l_decap_8
XFILLER_44_677 VPWR VGND sg13cmos5l_decap_8
XFILLER_31_327 VPWR VGND sg13cmos5l_decap_8
XFILLER_31_338 VPWR VGND sg13cmos5l_fill_2
XFILLER_12_563 VPWR VGND sg13cmos5l_decap_8
XFILLER_8_556 VPWR VGND sg13cmos5l_decap_8
XFILLER_6_46 VPWR VGND sg13cmos5l_fill_1
XFILLER_6_79 VPWR VGND sg13cmos5l_decap_8
XFILLER_3_294 VPWR VGND sg13cmos5l_decap_8
XFILLER_6_1028 VPWR VGND sg13cmos5l_fill_1
X_3170_ _3170_/Y _3168_/A _3183_/B _3169_/Y VPWR VGND sg13cmos5l_o21ai_1
X_2121_ _2121_/Y _3355_/Q _3352_/Q VPWR VGND sg13cmos5l_nor2b_1
XFILLER_13_4 VPWR VGND sg13cmos5l_decap_8
XFILLER_48_950 VPWR VGND sg13cmos5l_decap_8
X_2052_ _2052_/Y _2070_/A _2052_/B VPWR VGND sg13cmos5l_nand2_1
XFILLER_19_140 VPWR VGND sg13cmos5l_decap_4
XFILLER_34_121 VPWR VGND sg13cmos5l_decap_8
XFILLER_34_132 VPWR VGND sg13cmos5l_decap_8
XFILLER_35_655 VPWR VGND sg13cmos5l_fill_1
XFILLER_16_880 VPWR VGND sg13cmos5l_fill_1
X_2954_ _2954_/Y _2954_/A _2954_/B VPWR VGND sg13cmos5l_nor2_1
XFILLER_31_861 VPWR VGND sg13cmos5l_decap_8
X_2885_ _3009_/A _2976_/A VPWR VGND sg13cmos5l_inv_1
X_1905_ _3259_/D hold527/X input6/X _1912_/S VPWR VGND sg13cmos5l_mux2_1
X_1836_ _1836_/Y _3360_/Q VPWR VGND sg13cmos5l_inv_1
X_3474__181 _3474_/RESET_B VPWR VGND sg13cmos5l_tiehi
XFILLER_30_393 VPWR VGND sg13cmos5l_fill_1
Xhold501 hold501/X _3292_/Q VPWR VGND sg13cmos5l_dlygate4sd3_1
Xhold523 hold523/X _3283_/Q VPWR VGND sg13cmos5l_dlygate4sd3_1
Xhold534 hold534/X _3260_/Q VPWR VGND sg13cmos5l_dlygate4sd3_1
X_3506_ _3506_/Q clkload4/A _3506_/D _3506_/RESET_B VPWR VGND sg13cmos5l_dfrbpq_1
Xhold545 _3304_/D _1975_/Y VPWR VGND sg13cmos5l_dlygate4sd3_1
Xhold512 hold512/X _3400_/Q VPWR VGND sg13cmos5l_dlygate4sd3_1
Xhold556 _3314_/D _2029_/Y VPWR VGND sg13cmos5l_dlygate4sd3_1
Xhold578 _1851_/A _3338_/Q VPWR VGND sg13cmos5l_dlygate4sd3_1
Xhold567 _2264_/A _3354_/Q VPWR VGND sg13cmos5l_dlygate4sd3_1
XFILLER_44_1001 VPWR VGND sg13cmos5l_decap_8
Xhold589 _2050_/B _3265_/Q VPWR VGND sg13cmos5l_dlygate4sd3_1
X_3437_ _3437_/Q _3444_/CLK _3437_/D _3437_/RESET_B VPWR VGND sg13cmos5l_dfrbpq_1
X_3368_ _3368_/Q _3551_/CLK _3368_/D _3368_/RESET_B VPWR VGND sg13cmos5l_dfrbpq_1
X_2319_ _2350_/B _3386_/Q _2324_/A VPWR VGND sg13cmos5l_xor2_1
XFILLER_39_961 VPWR VGND sg13cmos5l_decap_8
X_3481__174 _3481_/RESET_B VPWR VGND sg13cmos5l_tiehi
X_3299_ _3299_/Q clkload2/A _3299_/D _3299_/RESET_B VPWR VGND sg13cmos5l_dfrbpq_1
XFILLER_14_806 VPWR VGND sg13cmos5l_decap_8
XFILLER_15_11 VPWR VGND sg13cmos5l_decap_8
XFILLER_25_176 VPWR VGND sg13cmos5l_decap_4
XFILLER_41_658 VPWR VGND sg13cmos5l_decap_8
XFILLER_15_55 VPWR VGND sg13cmos5l_decap_4
XFILLER_25_198 VPWR VGND sg13cmos5l_decap_8
XFILLER_40_168 VPWR VGND sg13cmos5l_fill_2
XFILLER_21_371 VPWR VGND sg13cmos5l_decap_8
XFILLER_21_382 VPWR VGND sg13cmos5l_fill_2
XFILLER_5_504 VPWR VGND sg13cmos5l_decap_4
XFILLER_31_98 VPWR VGND sg13cmos5l_decap_4
XFILLER_1_732 VPWR VGND sg13cmos5l_decap_8
XFILLER_49_736 VPWR VGND sg13cmos5l_decap_8
XFILLER_0_286 VPWR VGND sg13cmos5l_decap_8
XFILLER_37_909 VPWR VGND sg13cmos5l_decap_8
XFILLER_45_942 VPWR VGND sg13cmos5l_decap_8
XFILLER_44_463 VPWR VGND sg13cmos5l_fill_2
XFILLER_8_331 VPWR VGND sg13cmos5l_decap_8
XFILLER_9_865 VPWR VGND sg13cmos5l_decap_8
X_2670_ _2671_/B _2652_/Y _2650_/Y _2672_/S VPWR VGND sg13cmos5l_mux2_1
X_3509__95 _3509_/D VPWR VGND sg13cmos5l_tielo
XFILLER_28_1018 VPWR VGND sg13cmos5l_decap_8
X_3222_ _3223_/B _3209_/Y _3206_/Y _3222_/S VPWR VGND sg13cmos5l_mux2_1
X_3153_ _3153_/X _3505_/Q _3483_/Q _3484_/Q VPWR VGND sg13cmos5l_or3_1
X_2104_ _2104_/Y _2104_/A _2104_/B VPWR VGND sg13cmos5l_xnor2_1
XFILLER_36_931 VPWR VGND sg13cmos5l_decap_8
X_3084_ _3084_/Y _3063_/A _3536_/Q _3095_/B VPWR VGND sg13cmos5l_o21ai_1
X_2035_ _2035_/Y _2162_/A hold615/X _2162_/B VPWR VGND sg13cmos5l_o21ai_1
XFILLER_23_603 VPWR VGND sg13cmos5l_fill_1
XFILLER_22_124 VPWR VGND sg13cmos5l_fill_1
X_2937_ _2937_/Y _3488_/Q _2936_/Y _2933_/Y VPWR VGND sg13cmos5l_a21oi_1
X_2868_ _2879_/B _3509_/Q _2868_/B VPWR VGND sg13cmos5l_xnor2_1
X_2799_ _2799_/Y _3464_/Q _3435_/Q VPWR VGND sg13cmos5l_nand2_1
X_1819_ _1902_/B _1866_/B VPWR VGND sg13cmos5l_inv_1
XFILLER_45_205 VPWR VGND sg13cmos5l_decap_8
XFILLER_14_603 VPWR VGND sg13cmos5l_decap_8
XFILLER_26_474 VPWR VGND sg13cmos5l_decap_4
XFILLER_27_986 VPWR VGND sg13cmos5l_decap_8
XFILLER_42_945 VPWR VGND sg13cmos5l_decap_8
XFILLER_26_87 VPWR VGND sg13cmos5l_decap_8
XFILLER_22_680 VPWR VGND sg13cmos5l_decap_8
XFILLER_10_842 VPWR VGND sg13cmos5l_decap_8
XFILLER_6_846 VPWR VGND sg13cmos5l_decap_8
XFILLER_5_345 VPWR VGND sg13cmos5l_decap_8
XFILLER_5_367 VPWR VGND sg13cmos5l_fill_1
XFILLER_49_533 VPWR VGND sg13cmos5l_decap_8
X_3542__300 _3542_/RESET_B VPWR VGND sg13cmos5l_tiehi
XFILLER_37_739 VPWR VGND sg13cmos5l_decap_4
XFILLER_18_953 VPWR VGND sg13cmos5l_decap_8
XFILLER_45_772 VPWR VGND sg13cmos5l_decap_8
XFILLER_32_400 VPWR VGND sg13cmos5l_decap_4
XFILLER_20_606 VPWR VGND sg13cmos5l_decap_8
XFILLER_13_680 VPWR VGND sg13cmos5l_decap_8
XFILLER_32_477 VPWR VGND sg13cmos5l_decap_8
XFILLER_34_1011 VPWR VGND sg13cmos5l_decap_8
XFILLER_12_190 VPWR VGND sg13cmos5l_decap_8
X_2722_ _2722_/Y _3441_/Q _3419_/Q _2733_/B VPWR VGND sg13cmos5l_o21ai_1
XFILLER_8_172 VPWR VGND sg13cmos5l_decap_4
XFILLER_9_684 VPWR VGND sg13cmos5l_decap_8
X_3471__184 _3471_/RESET_B VPWR VGND sg13cmos5l_tiehi
X_2653_ _2653_/Y _2653_/A _2653_/B VPWR VGND sg13cmos5l_nand2_1
X_2584_ _2584_/Y _1860_/A _2576_/Y _2583_/Y _3425_/Q VPWR VGND sg13cmos5l_a22oi_1
X_3205_ _3206_/A _3205_/A _3205_/B VPWR VGND sg13cmos5l_nand2_1
X_3136_ _3207_/A _3529_/Q _3143_/B VPWR VGND sg13cmos5l_or2_1
XFILLER_27_216 VPWR VGND sg13cmos5l_decap_8
X_3067_ _3068_/B _3032_/X _3066_/Y _3070_/A VPWR VGND sg13cmos5l_mux2_1
XFILLER_42_219 VPWR VGND sg13cmos5l_decap_8
XFILLER_36_761 VPWR VGND sg13cmos5l_decap_8
XFILLER_36_750 VPWR VGND sg13cmos5l_fill_1
X_2018_ _3313_/D _2018_/A _2018_/B _2018_/C VPWR VGND sg13cmos5l_and3_1
XFILLER_36_783 VPWR VGND sg13cmos5l_decap_4
X_3519__302 _3519_/RESET_B VPWR VGND sg13cmos5l_tiehi
XFILLER_24_989 VPWR VGND sg13cmos5l_decap_8
XFILLER_11_617 VPWR VGND sg13cmos5l_decap_8
XFILLER_23_477 VPWR VGND sg13cmos5l_fill_1
XFILLER_12_89 VPWR VGND sg13cmos5l_decap_4
XFILLER_3_849 VPWR VGND sg13cmos5l_decap_8
XFILLER_2_326 VPWR VGND sg13cmos5l_decap_8
XFILLER_46_514 VPWR VGND sg13cmos5l_fill_1
XFILLER_37_42 VPWR VGND sg13cmos5l_decap_8
XFILLER_27_750 VPWR VGND sg13cmos5l_decap_8
XFILLER_15_945 VPWR VGND sg13cmos5l_decap_8
XFILLER_42_797 VPWR VGND sg13cmos5l_fill_1
XFILLER_42_786 VPWR VGND sg13cmos5l_decap_8
XFILLER_41_252 VPWR VGND sg13cmos5l_fill_2
XFILLER_30_948 VPWR VGND sg13cmos5l_decap_8
XFILLER_6_621 VPWR VGND sg13cmos5l_decap_8
XFILLER_6_610 VPWR VGND sg13cmos5l_decap_4
XFILLER_5_120 VPWR VGND sg13cmos5l_decap_4
XFILLER_10_683 VPWR VGND sg13cmos5l_decap_8
XFILLER_2_882 VPWR VGND sg13cmos5l_decap_8
XFILLER_49_396 VPWR VGND sg13cmos5l_decap_8
XFILLER_37_558 VPWR VGND sg13cmos5l_fill_2
XFILLER_45_591 VPWR VGND sg13cmos5l_decap_4
XFILLER_18_783 VPWR VGND sg13cmos5l_decap_8
XFILLER_32_241 VPWR VGND sg13cmos5l_decap_8
XFILLER_20_414 VPWR VGND sg13cmos5l_fill_2
XFILLER_21_948 VPWR VGND sg13cmos5l_decap_8
XFILLER_20_425 VPWR VGND sg13cmos5l_decap_8
X_2705_ _2705_/X _2705_/A _2708_/B VPWR VGND sg13cmos5l_and2_1
X_2636_ _2662_/C _3439_/Q _2645_/B _2657_/A VPWR VGND sg13cmos5l_o21ai_1
XFILLER_0_819 VPWR VGND sg13cmos5l_decap_8
X_2567_ _2567_/Y _3442_/Q _2581_/B _2573_/B _3441_/Q VPWR VGND sg13cmos5l_a22oi_1
X_2498_ _2498_/X _2498_/A _2498_/B _2518_/A VPWR VGND sg13cmos5l_and3_1
XFILLER_28_536 VPWR VGND sg13cmos5l_fill_1
X_3119_ _3119_/Y _3525_/Q _3119_/A2 _2966_/A VPWR VGND sg13cmos5l_o21ai_1
XFILLER_11_414 VPWR VGND sg13cmos5l_decap_8
XFILLER_12_915 VPWR VGND sg13cmos5l_decap_8
XFILLER_23_44 VPWR VGND sg13cmos5l_decap_8
XFILLER_23_99 VPWR VGND sg13cmos5l_decap_8
XFILLER_3_668 VPWR VGND sg13cmos5l_fill_1
XFILLER_2_178 VPWR VGND sg13cmos5l_decap_8
XFILLER_24_1010 VPWR VGND sg13cmos5l_decap_8
XFILLER_47_801 VPWR VGND sg13cmos5l_decap_8
XFILLER_46_322 VPWR VGND sg13cmos5l_fill_2
XFILLER_47_878 VPWR VGND sg13cmos5l_decap_8
XFILLER_34_539 VPWR VGND sg13cmos5l_fill_2
XFILLER_14_230 VPWR VGND sg13cmos5l_fill_1
XFILLER_9_68 VPWR VGND sg13cmos5l_fill_2
XFILLER_14_296 VPWR VGND sg13cmos5l_decap_8
XFILLER_30_756 VPWR VGND sg13cmos5l_fill_2
XFILLER_30_778 VPWR VGND sg13cmos5l_decap_8
XFILLER_7_941 VPWR VGND sg13cmos5l_decap_8
XFILLER_11_992 VPWR VGND sg13cmos5l_decap_8
XFILLER_6_440 VPWR VGND sg13cmos5l_fill_1
X_3470_ _3470_/Q _3472_/CLK _3470_/D _3470_/RESET_B VPWR VGND sg13cmos5l_dfrbpq_1
XFILLER_43_4 VPWR VGND sg13cmos5l_decap_4
X_2421_ _2421_/Y _1812_/Y _3119_/A2 _2420_/Y VPWR VGND sg13cmos5l_a21oi_1
X_2352_ _3386_/D _2383_/A _2468_/A VPWR VGND sg13cmos5l_nor2_1
XFILLER_9_1026 VPWR VGND sg13cmos5l_fill_2
X_2283_ _2304_/A _2283_/A _2283_/B _2283_/C _2283_/D VPWR VGND sg13cmos5l_nor4_1
XFILLER_29_2 VPWR VGND sg13cmos5l_fill_1
XFILLER_38_801 VPWR VGND sg13cmos5l_decap_8
XFILLER_38_834 VPWR VGND sg13cmos5l_decap_4
XFILLER_37_388 VPWR VGND sg13cmos5l_fill_2
XFILLER_37_377 VPWR VGND sg13cmos5l_decap_8
XFILLER_18_591 VPWR VGND sg13cmos5l_decap_8
XFILLER_20_211 VPWR VGND sg13cmos5l_decap_4
XFILLER_21_789 VPWR VGND sg13cmos5l_decap_8
X_1998_ _2001_/D _1988_/B _2006_/B _1997_/Y VPWR VGND sg13cmos5l_o21ai_1
X_2619_ _2619_/Y _2617_/A _2617_/B _2617_/C _2617_/D VPWR VGND sg13cmos5l_a22oi_1
XFILLER_18_11 VPWR VGND sg13cmos5l_decap_4
XFILLER_43_314 VPWR VGND sg13cmos5l_fill_1
XFILLER_28_388 VPWR VGND sg13cmos5l_decap_4
XFILLER_43_358 VPWR VGND sg13cmos5l_decap_8
XFILLER_31_509 VPWR VGND sg13cmos5l_fill_1
XFILLER_11_211 VPWR VGND sg13cmos5l_fill_1
XFILLER_8_705 VPWR VGND sg13cmos5l_decap_8
XFILLER_11_233 VPWR VGND sg13cmos5l_fill_1
XFILLER_8_749 VPWR VGND sg13cmos5l_decap_8
XFILLER_4_966 VPWR VGND sg13cmos5l_decap_8
XFILLER_1_0 VPWR VGND sg13cmos5l_decap_8
XFILLER_47_620 VPWR VGND sg13cmos5l_decap_8
XFILLER_19_366 VPWR VGND sg13cmos5l_fill_2
XFILLER_47_686 VPWR VGND sg13cmos5l_decap_8
XFILLER_34_303 VPWR VGND sg13cmos5l_decap_4
XFILLER_34_347 VPWR VGND sg13cmos5l_decap_8
XFILLER_43_881 VPWR VGND sg13cmos5l_decap_8
X_2970_ _3503_/D _2970_/A _2970_/B VPWR VGND sg13cmos5l_and2_1
XFILLER_15_561 VPWR VGND sg13cmos5l_decap_8
X_1921_ _3273_/D input12/X hold536/X _1923_/S VPWR VGND sg13cmos5l_mux2_1
X_1852_ _2930_/A _3460_/Q VPWR VGND sg13cmos5l_inv_1
XFILLER_30_542 VPWR VGND sg13cmos5l_fill_2
Xhold705 hold705/X _3383_/Q VPWR VGND sg13cmos5l_dlygate4sd3_1
XFILLER_6_270 VPWR VGND sg13cmos5l_decap_8
X_3522_ _3522_/Q _3539_/CLK _3522_/D _3522_/RESET_B VPWR VGND sg13cmos5l_dfrbpq_1
Xhold716 _2996_/A _3501_/Q VPWR VGND sg13cmos5l_dlygate4sd3_1
Xhold727 _2515_/A _2617_/A VPWR VGND sg13cmos5l_dlygate4sd3_1
X_3453_ _3453_/Q _3453_/CLK _3453_/D _3453_/RESET_B VPWR VGND sg13cmos5l_dfrbpq_1
Xhold738 hold738/X _3493_/Q VPWR VGND sg13cmos5l_dlygate4sd3_1
X_2404_ _2404_/Y _3413_/Q _2614_/A VPWR VGND sg13cmos5l_nand2b_1
X_3384_ _3384_/Q _3409_/CLK _3384_/D _3384_/RESET_B VPWR VGND sg13cmos5l_dfrbpq_1
XFILLER_34_0 VPWR VGND sg13cmos5l_decap_8
X_2335_ _2552_/A _2611_/A _2349_/B VPWR VGND sg13cmos5l_nand2_1
XFILLER_38_620 VPWR VGND sg13cmos5l_decap_8
X_2266_ _2266_/X _3371_/Q _3348_/Q VPWR VGND sg13cmos5l_and2_1
X_2197_ _2296_/A hold667/X _2196_/Y _2200_/S VPWR VGND sg13cmos5l_mux2_1
XFILLER_26_815 VPWR VGND sg13cmos5l_decap_4
XFILLER_41_829 VPWR VGND sg13cmos5l_decap_8
XFILLER_25_369 VPWR VGND sg13cmos5l_decap_8
XFILLER_33_391 VPWR VGND sg13cmos5l_decap_8
XFILLER_34_892 VPWR VGND sg13cmos5l_decap_8
X_3299__395 _3299_/RESET_B VPWR VGND sg13cmos5l_tiehi
XFILLER_21_575 VPWR VGND sg13cmos5l_decap_8
XFILLER_21_597 VPWR VGND sg13cmos5l_decap_8
XFILLER_0_413 VPWR VGND sg13cmos5l_decap_8
XFILLER_1_914 VPWR VGND sg13cmos5l_decap_8
XFILLER_49_918 VPWR VGND sg13cmos5l_decap_8
XFILLER_48_406 VPWR VGND sg13cmos5l_decap_8
XFILLER_29_664 VPWR VGND sg13cmos5l_fill_1
XFILLER_28_152 VPWR VGND sg13cmos5l_decap_4
XFILLER_44_634 VPWR VGND sg13cmos5l_decap_8
XFILLER_31_317 VPWR VGND sg13cmos5l_fill_1
XFILLER_32_829 VPWR VGND sg13cmos5l_fill_1
XFILLER_12_520 VPWR VGND sg13cmos5l_fill_2
XFILLER_40_851 VPWR VGND sg13cmos5l_decap_8
XFILLER_12_553 VPWR VGND sg13cmos5l_fill_2
XFILLER_40_895 VPWR VGND sg13cmos5l_decap_8
XFILLER_8_535 VPWR VGND sg13cmos5l_decap_8
XFILLER_6_1007 VPWR VGND sg13cmos5l_decap_8
X_2120_ _2123_/C _3355_/Q _2116_/Y _2119_/Y _2100_/Y VPWR VGND sg13cmos5l_a22oi_1
XFILLER_0_980 VPWR VGND sg13cmos5l_decap_8
X_2051_ _2051_/Y _2043_/A _3282_/Q _1868_/Y VPWR VGND sg13cmos5l_a21oi_1
XFILLER_47_494 VPWR VGND sg13cmos5l_decap_8
XFILLER_23_829 VPWR VGND sg13cmos5l_fill_1
X_2953_ _2954_/B _2944_/Y _2951_/Y _2970_/B VPWR VGND sg13cmos5l_o21ai_1
XFILLER_16_892 VPWR VGND sg13cmos5l_decap_8
XFILLER_15_391 VPWR VGND sg13cmos5l_decap_8
X_1904_ _1912_/S input2/X _1914_/A _1924_/D VPWR VGND sg13cmos5l_nor3_1
XFILLER_31_840 VPWR VGND sg13cmos5l_decap_8
X_2884_ _2976_/A _2884_/A _2884_/B _2884_/C VPWR VGND sg13cmos5l_and3_1
XFILLER_31_895 VPWR VGND sg13cmos5l_decap_8
X_1835_ _2612_/A _1835_/A VPWR VGND sg13cmos5l_inv_1
Xhold502 hold502/X _3279_/Q VPWR VGND sg13cmos5l_dlygate4sd3_1
Xhold513 hold513/X _3266_/Q VPWR VGND sg13cmos5l_dlygate4sd3_1
Xhold524 hold524/X _3287_/Q VPWR VGND sg13cmos5l_dlygate4sd3_1
Xhold535 hold535/X _3280_/Q VPWR VGND sg13cmos5l_dlygate4sd3_1
X_3505_ _3505_/Q clkload4/A _3505_/D _3505_/RESET_B VPWR VGND sg13cmos5l_dfrbpq_1
Xhold579 _3338_/D _2131_/Y VPWR VGND sg13cmos5l_dlygate4sd3_1
Xhold546 _3100_/B _3535_/Q VPWR VGND sg13cmos5l_dlygate4sd3_1
Xhold568 _3114_/B _3493_/Q VPWR VGND sg13cmos5l_dlygate4sd3_1
Xhold557 _1840_/A _3444_/Q VPWR VGND sg13cmos5l_dlygate4sd3_1
X_3436_ _3436_/Q _3444_/CLK _3436_/D _3436_/RESET_B VPWR VGND sg13cmos5l_dfrbpq_1
X_3367_ _3367_/Q _3444_/CLK _3367_/D _3367_/RESET_B VPWR VGND sg13cmos5l_dfrbpq_1
X_2318_ _2349_/A _3412_/Q _2318_/B VPWR VGND sg13cmos5l_xor2_1
XFILLER_39_940 VPWR VGND sg13cmos5l_decap_8
X_3298_ _3298_/Q _3539_/CLK _3298_/D _3298_/RESET_B VPWR VGND sg13cmos5l_dfrbpq_1
X_2249_ _3365_/D _2309_/A _2249_/B VPWR VGND sg13cmos5l_nor2_1
XFILLER_26_689 VPWR VGND sg13cmos5l_fill_2
XFILLER_40_125 VPWR VGND sg13cmos5l_decap_4
XFILLER_22_840 VPWR VGND sg13cmos5l_fill_2
XFILLER_31_11 VPWR VGND sg13cmos5l_decap_8
XFILLER_5_538 VPWR VGND sg13cmos5l_fill_2
XFILLER_5_527 VPWR VGND sg13cmos5l_decap_8
XFILLER_31_55 VPWR VGND sg13cmos5l_decap_8
XFILLER_31_77 VPWR VGND sg13cmos5l_fill_1
XFILLER_1_711 VPWR VGND sg13cmos5l_decap_8
XFILLER_49_715 VPWR VGND sg13cmos5l_decap_8
XFILLER_0_243 VPWR VGND sg13cmos5l_decap_8
XFILLER_0_265 VPWR VGND sg13cmos5l_decap_8
XFILLER_1_788 VPWR VGND sg13cmos5l_decap_8
XFILLER_45_921 VPWR VGND sg13cmos5l_decap_8
XFILLER_17_612 VPWR VGND sg13cmos5l_decap_8
XFILLER_45_998 VPWR VGND sg13cmos5l_decap_8
XFILLER_44_442 VPWR VGND sg13cmos5l_decap_8
XFILLER_16_177 VPWR VGND sg13cmos5l_decap_8
XFILLER_40_670 VPWR VGND sg13cmos5l_fill_2
XFILLER_9_844 VPWR VGND sg13cmos5l_decap_8
XFILLER_12_372 VPWR VGND sg13cmos5l_decap_8
XFILLER_8_398 VPWR VGND sg13cmos5l_decap_8
XFILLER_4_582 VPWR VGND sg13cmos5l_decap_8
X_3221_ _3533_/D _3210_/B _3222_/S _3220_/Y VPWR VGND sg13cmos5l_a21oi_1
X_3152_ _3152_/X _3505_/Q _3483_/Q VPWR VGND sg13cmos5l_or2_1
X_2103_ _2103_/Y _2214_/A _2095_/A _2216_/A VPWR VGND sg13cmos5l_o21ai_1
XFILLER_36_910 VPWR VGND sg13cmos5l_decap_8
X_3083_ _3095_/B _3536_/Q _3082_/Y _3081_/Y VPWR VGND sg13cmos5l_o21ai_1
XFILLER_27_409 VPWR VGND sg13cmos5l_decap_8
X_2034_ _2034_/Y _3319_/Q _2034_/B VPWR VGND sg13cmos5l_nand2b_1
XFILLER_35_431 VPWR VGND sg13cmos5l_fill_2
XFILLER_36_987 VPWR VGND sg13cmos5l_decap_8
XFILLER_35_453 VPWR VGND sg13cmos5l_decap_8
XFILLER_22_147 VPWR VGND sg13cmos5l_decap_8
XFILLER_23_659 VPWR VGND sg13cmos5l_decap_4
X_2936_ _2936_/Y _2930_/A _2934_/X _2935_/Y _2931_/C VPWR VGND sg13cmos5l_a22oi_1
XFILLER_22_169 VPWR VGND sg13cmos5l_fill_2
X_2867_ _2884_/A _2867_/A _2868_/B VPWR VGND sg13cmos5l_nand2_1
XFILLER_31_692 VPWR VGND sg13cmos5l_decap_4
X_1818_ _1818_/Y _3318_/Q VPWR VGND sg13cmos5l_inv_1
XFILLER_7_90 VPWR VGND sg13cmos5l_fill_1
X_2798_ _2822_/A _2698_/X _2731_/Y _2825_/S VPWR VGND sg13cmos5l_mux2_1
XFILLER_2_519 VPWR VGND sg13cmos5l_decap_8
X_3419_ _3419_/Q _3453_/CLK _3419_/D _3419_/RESET_B VPWR VGND sg13cmos5l_dfrbpq_1
XFILLER_26_55 VPWR VGND sg13cmos5l_fill_1
XFILLER_27_965 VPWR VGND sg13cmos5l_decap_8
XFILLER_42_924 VPWR VGND sg13cmos5l_decap_8
XFILLER_41_401 VPWR VGND sg13cmos5l_decap_4
XFILLER_41_467 VPWR VGND sg13cmos5l_decap_4
XFILLER_41_489 VPWR VGND sg13cmos5l_fill_1
XFILLER_41_478 VPWR VGND sg13cmos5l_decap_8
XFILLER_13_169 VPWR VGND sg13cmos5l_decap_8
X_3535__330 _3535_/RESET_B VPWR VGND sg13cmos5l_tiehi
XFILLER_42_98 VPWR VGND sg13cmos5l_fill_1
XFILLER_6_825 VPWR VGND sg13cmos5l_decap_8
XFILLER_5_324 VPWR VGND sg13cmos5l_decap_8
XFILLER_10_898 VPWR VGND sg13cmos5l_decap_8
XFILLER_5_379 VPWR VGND sg13cmos5l_decap_8
XFILLER_49_567 VPWR VGND sg13cmos5l_decap_8
XFILLER_49_578 VPWR VGND sg13cmos5l_fill_2
XFILLER_18_932 VPWR VGND sg13cmos5l_decap_8
X_3464__192 _3464_/RESET_B VPWR VGND sg13cmos5l_tiehi
XFILLER_45_751 VPWR VGND sg13cmos5l_decap_8
XFILLER_44_272 VPWR VGND sg13cmos5l_decap_4
XFILLER_44_294 VPWR VGND sg13cmos5l_fill_2
X_2721_ _2733_/B _3419_/Q _2721_/B VPWR VGND sg13cmos5l_xor2_1
XFILLER_9_663 VPWR VGND sg13cmos5l_decap_8
X_2652_ _2652_/Y _2520_/B _2651_/B _2651_/Y VPWR VGND sg13cmos5l_a21oi_1
X_2583_ _2583_/Y _2577_/B _2581_/Y _2582_/Y _2578_/C VPWR VGND sg13cmos5l_a22oi_1
X_3204_ _3205_/B _3212_/A _3204_/B VPWR VGND sg13cmos5l_nand2_1
XFILLER_28_707 VPWR VGND sg13cmos5l_decap_8
X_3135_ _3208_/A _3528_/Q _3143_/B _3201_/A VPWR VGND sg13cmos5l_a21o_1
X_3066_ _3066_/Y _3066_/A _3069_/B VPWR VGND sg13cmos5l_nand2_1
X_2017_ _3312_/D _2013_/B _2014_/Y _2016_/Y VPWR VGND sg13cmos5l_a21oi_1
XFILLER_35_250 VPWR VGND sg13cmos5l_decap_8
XFILLER_24_968 VPWR VGND sg13cmos5l_decap_8
XFILLER_10_117 VPWR VGND sg13cmos5l_fill_2
X_2919_ _3486_/D _2968_/B _2978_/B VPWR VGND sg13cmos5l_nor2_1
XFILLER_12_46 VPWR VGND sg13cmos5l_decap_4
XFILLER_3_828 VPWR VGND sg13cmos5l_decap_8
XFILLER_2_305 VPWR VGND sg13cmos5l_decap_8
XFILLER_46_537 VPWR VGND sg13cmos5l_decap_8
XFILLER_14_456 VPWR VGND sg13cmos5l_decap_8
X_3502__384 _3502_/RESET_B VPWR VGND sg13cmos5l_tiehi
XFILLER_14_467 VPWR VGND sg13cmos5l_fill_2
XFILLER_10_651 VPWR VGND sg13cmos5l_decap_4
XFILLER_6_666 VPWR VGND sg13cmos5l_decap_8
XFILLER_6_699 VPWR VGND sg13cmos5l_decap_8
XFILLER_2_861 VPWR VGND sg13cmos5l_decap_8
XFILLER_49_320 VPWR VGND sg13cmos5l_decap_4
XFILLER_49_364 VPWR VGND sg13cmos5l_fill_1
XFILLER_49_353 VPWR VGND sg13cmos5l_decap_8
XFILLER_37_526 VPWR VGND sg13cmos5l_decap_8
XFILLER_18_762 VPWR VGND sg13cmos5l_decap_8
XFILLER_21_905 VPWR VGND sg13cmos5l_decap_8
XFILLER_21_927 VPWR VGND sg13cmos5l_decap_8
XFILLER_33_787 VPWR VGND sg13cmos5l_fill_1
X_2704_ _2704_/Y _2692_/A _2692_/B _2701_/S VPWR VGND sg13cmos5l_a21oi_1
X_2635_ _2657_/A _3438_/Q _2645_/B _2649_/A VPWR VGND sg13cmos5l_a21o_1
X_2566_ _3422_/D _2615_/B _2655_/B VPWR VGND sg13cmos5l_and2_1
X_2497_ _2497_/Y _2521_/A _2522_/A VPWR VGND sg13cmos5l_nand2_1
X_3118_ _3524_/D _1796_/Y _3118_/A2 _3117_/Y VPWR VGND sg13cmos5l_a21oi_1
XFILLER_36_581 VPWR VGND sg13cmos5l_decap_8
X_3049_ _3056_/A _3535_/Q _3049_/B VPWR VGND sg13cmos5l_xnor2_1
XFILLER_23_253 VPWR VGND sg13cmos5l_fill_1
XFILLER_23_264 VPWR VGND sg13cmos5l_decap_8
XFILLER_24_787 VPWR VGND sg13cmos5l_decap_8
XFILLER_11_437 VPWR VGND sg13cmos5l_fill_1
XFILLER_3_603 VPWR VGND sg13cmos5l_decap_4
XFILLER_2_157 VPWR VGND sg13cmos5l_decap_8
XFILLER_47_857 VPWR VGND sg13cmos5l_decap_8
XFILLER_48_97 VPWR VGND sg13cmos5l_fill_1
XFILLER_19_559 VPWR VGND sg13cmos5l_decap_8
XFILLER_27_592 VPWR VGND sg13cmos5l_fill_1
XFILLER_42_562 VPWR VGND sg13cmos5l_decap_8
XFILLER_9_25 VPWR VGND sg13cmos5l_decap_8
XFILLER_15_776 VPWR VGND sg13cmos5l_decap_8
XFILLER_42_595 VPWR VGND sg13cmos5l_fill_1
XFILLER_14_275 VPWR VGND sg13cmos5l_decap_8
XFILLER_31_1015 VPWR VGND sg13cmos5l_decap_8
XFILLER_7_920 VPWR VGND sg13cmos5l_decap_8
XFILLER_11_971 VPWR VGND sg13cmos5l_decap_8
XFILLER_6_463 VPWR VGND sg13cmos5l_decap_8
XFILLER_7_997 VPWR VGND sg13cmos5l_decap_8
X_2420_ _2420_/Y _3399_/Q _3117_/A2 _2776_/A VPWR VGND sg13cmos5l_o21ai_1
X_2351_ _2468_/A _2349_/A _2349_/B _2350_/Y VPWR VGND sg13cmos5l_a21oi_1
XFILLER_9_1005 VPWR VGND sg13cmos5l_decap_8
XFILLER_36_4 VPWR VGND sg13cmos5l_fill_2
X_2282_ _2303_/A _2282_/A _2287_/A _2282_/C VPWR VGND sg13cmos5l_nor3_1
XFILLER_38_813 VPWR VGND sg13cmos5l_decap_8
XFILLER_37_345 VPWR VGND sg13cmos5l_decap_8
XFILLER_18_581 VPWR VGND sg13cmos5l_decap_8
XFILLER_21_713 VPWR VGND sg13cmos5l_decap_4
XFILLER_33_551 VPWR VGND sg13cmos5l_decap_8
XFILLER_21_746 VPWR VGND sg13cmos5l_decap_4
XFILLER_33_595 VPWR VGND sg13cmos5l_fill_1
X_1997_ _1997_/Y hold647/X _1996_/Y _1885_/Y VPWR VGND sg13cmos5l_a21oi_1
XFILLER_47_1011 VPWR VGND sg13cmos5l_decap_8
X_2618_ _2618_/Y _2618_/A _2618_/B _2618_/C _2618_/D VPWR VGND sg13cmos5l_nand4_1
X_2549_ _2557_/C _2548_/A _2556_/B VPWR VGND sg13cmos5l_nand2b_1
XFILLER_29_813 VPWR VGND sg13cmos5l_decap_4
XFILLER_44_805 VPWR VGND sg13cmos5l_fill_2
XFILLER_16_507 VPWR VGND sg13cmos5l_fill_1
XFILLER_18_56 VPWR VGND sg13cmos5l_fill_2
XFILLER_29_868 VPWR VGND sg13cmos5l_decap_4
XFILLER_28_367 VPWR VGND sg13cmos5l_decap_8
XFILLER_12_702 VPWR VGND sg13cmos5l_fill_2
XFILLER_12_713 VPWR VGND sg13cmos5l_fill_2
XFILLER_12_735 VPWR VGND sg13cmos5l_fill_2
XFILLER_12_757 VPWR VGND sg13cmos5l_decap_8
XFILLER_7_216 VPWR VGND sg13cmos5l_decap_4
XFILLER_4_945 VPWR VGND sg13cmos5l_decap_8
XFILLER_3_455 VPWR VGND sg13cmos5l_decap_8
XFILLER_19_345 VPWR VGND sg13cmos5l_decap_8
XFILLER_15_540 VPWR VGND sg13cmos5l_decap_8
X_1920_ _3272_/D input11/X hold525/X _1923_/S VPWR VGND sg13cmos5l_mux2_1
XFILLER_42_370 VPWR VGND sg13cmos5l_decap_8
X_3400__263 _3400_/RESET_B VPWR VGND sg13cmos5l_tiehi
XFILLER_30_521 VPWR VGND sg13cmos5l_decap_8
X_1851_ _2235_/B _1851_/A VPWR VGND sg13cmos5l_inv_1
X_3277__138 _3277_/RESET_B VPWR VGND sg13cmos5l_tiehi
X_3521_ _3521_/Q clkload6/A _3521_/D _3521_/RESET_B VPWR VGND sg13cmos5l_dfrbpq_1
Xhold706 hold706/X _3353_/Q VPWR VGND sg13cmos5l_dlygate4sd3_1
Xhold728 _2721_/B _3420_/Q VPWR VGND sg13cmos5l_dlygate4sd3_1
Xhold717 hold717/X _3312_/Q VPWR VGND sg13cmos5l_dlygate4sd3_1
X_3452_ _3452_/Q _3485_/CLK _3452_/D _3452_/RESET_B VPWR VGND sg13cmos5l_dfrbpq_1
X_3383_ _3383_/Q _3409_/CLK _3383_/D _3383_/RESET_B VPWR VGND sg13cmos5l_dfrbpq_1
X_2403_ _2403_/Y _3394_/Q _2412_/A _2395_/Y VPWR VGND sg13cmos5l_o21ai_1
X_2334_ _2346_/S _2350_/A _2341_/A VPWR VGND sg13cmos5l_nor2_1
XFILLER_27_0 VPWR VGND sg13cmos5l_decap_8
X_2265_ _3378_/D _2265_/A _2307_/A VPWR VGND sg13cmos5l_nor2_1
X_2196_ _2196_/Y _2196_/A _2199_/B VPWR VGND sg13cmos5l_nand2_1
XFILLER_25_348 VPWR VGND sg13cmos5l_decap_8
XFILLER_41_808 VPWR VGND sg13cmos5l_decap_8
XFILLER_40_318 VPWR VGND sg13cmos5l_decap_8
XFILLER_21_554 VPWR VGND sg13cmos5l_decap_8
XFILLER_14_1021 VPWR VGND sg13cmos5l_decap_8
XFILLER_5_709 VPWR VGND sg13cmos5l_decap_8
XFILLER_21_1025 VPWR VGND sg13cmos5l_decap_4
XFILLER_28_131 VPWR VGND sg13cmos5l_fill_2
XFILLER_44_613 VPWR VGND sg13cmos5l_decap_8
XFILLER_17_838 VPWR VGND sg13cmos5l_decap_8
XFILLER_29_676 VPWR VGND sg13cmos5l_decap_8
XFILLER_17_849 VPWR VGND sg13cmos5l_fill_1
XFILLER_12_532 VPWR VGND sg13cmos5l_decap_8
XFILLER_40_874 VPWR VGND sg13cmos5l_decap_4
XFILLER_8_525 VPWR VGND sg13cmos5l_decap_4
X_3387__111 _3387_/D VPWR VGND sg13cmos5l_tielo
XFILLER_3_252 VPWR VGND sg13cmos5l_decap_8
XFILLER_3_274 VPWR VGND sg13cmos5l_fill_2
XFILLER_47_440 VPWR VGND sg13cmos5l_fill_1
X_2050_ _2050_/Y _2070_/A _2050_/B VPWR VGND sg13cmos5l_nand2_1
XFILLER_48_985 VPWR VGND sg13cmos5l_decap_8
XFILLER_47_473 VPWR VGND sg13cmos5l_decap_8
XFILLER_35_602 VPWR VGND sg13cmos5l_decap_8
XFILLER_34_101 VPWR VGND sg13cmos5l_decap_8
XFILLER_43_690 VPWR VGND sg13cmos5l_fill_1
XFILLER_37_1021 VPWR VGND sg13cmos5l_decap_8
XFILLER_15_370 VPWR VGND sg13cmos5l_decap_8
XFILLER_15_381 VPWR VGND sg13cmos5l_fill_1
X_2952_ _2954_/A _2952_/A _2944_/Y VPWR VGND sg13cmos5l_nor2b_1
X_1903_ _1924_/D input3/X _1948_/A VPWR VGND sg13cmos5l_nand2_1
X_2883_ _2884_/C _2861_/B _3125_/A VPWR VGND sg13cmos5l_nand2b_1
XFILLER_30_384 VPWR VGND sg13cmos5l_decap_8
X_1834_ _2613_/A _1834_/A VPWR VGND sg13cmos5l_inv_1
Xhold525 hold525/X _3272_/Q VPWR VGND sg13cmos5l_dlygate4sd3_1
Xhold536 hold536/X _3273_/Q VPWR VGND sg13cmos5l_dlygate4sd3_1
Xhold514 hold514/X _3289_/Q VPWR VGND sg13cmos5l_dlygate4sd3_1
X_3504_ _3504_/Q _3504_/CLK _3504_/D _3504_/RESET_B VPWR VGND sg13cmos5l_dfrbpq_1
Xhold503 _1808_/A _3431_/Q VPWR VGND sg13cmos5l_dlygate4sd3_1
Xhold547 hold547/X _3100_/Y VPWR VGND sg13cmos5l_dlygate4sd3_1
Xhold558 _1830_/A _3508_/Q VPWR VGND sg13cmos5l_dlygate4sd3_1
Xhold569 _1795_/A _3496_/Q VPWR VGND sg13cmos5l_dlygate4sd3_1
X_3435_ _3435_/Q _3444_/CLK _3435_/D _3435_/RESET_B VPWR VGND sg13cmos5l_dfrbpq_1
X_3366_ _3366_/Q _3463_/CLK _3366_/D _3366_/RESET_B VPWR VGND sg13cmos5l_dfrbpq_1
X_3297_ _3297_/Q clkload6/A _3297_/D _3297_/RESET_B VPWR VGND sg13cmos5l_dfrbpq_1
X_2317_ _2542_/A _3412_/Q _2318_/B VPWR VGND sg13cmos5l_xnor2_1
X_2248_ _2248_/X _2239_/B _2396_/B _2248_/S VPWR VGND sg13cmos5l_mux2_1
XFILLER_39_996 VPWR VGND sg13cmos5l_decap_8
XFILLER_38_462 VPWR VGND sg13cmos5l_fill_1
XFILLER_38_451 VPWR VGND sg13cmos5l_decap_8
XFILLER_26_624 VPWR VGND sg13cmos5l_fill_2
X_2179_ _2179_/Y _2419_/B _2179_/B VPWR VGND sg13cmos5l_nand2b_1
XFILLER_14_819 VPWR VGND sg13cmos5l_decap_8
XFILLER_25_145 VPWR VGND sg13cmos5l_decap_8
XFILLER_40_115 VPWR VGND sg13cmos5l_decap_4
XFILLER_40_148 VPWR VGND sg13cmos5l_decap_8
XFILLER_15_79 VPWR VGND sg13cmos5l_decap_4
XFILLER_31_67 VPWR VGND sg13cmos5l_fill_1
XFILLER_0_222 VPWR VGND sg13cmos5l_decap_8
XFILLER_1_767 VPWR VGND sg13cmos5l_decap_8
X_3267__148 _3267_/RESET_B VPWR VGND sg13cmos5l_tiehi
XFILLER_45_900 VPWR VGND sg13cmos5l_decap_8
XFILLER_16_101 VPWR VGND sg13cmos5l_decap_8
XFILLER_29_495 VPWR VGND sg13cmos5l_decap_4
XFILLER_45_977 VPWR VGND sg13cmos5l_decap_8
X_3321__356 _3321_/RESET_B VPWR VGND sg13cmos5l_tiehi
XFILLER_32_616 VPWR VGND sg13cmos5l_fill_1
XFILLER_9_823 VPWR VGND sg13cmos5l_decap_8
XFILLER_12_340 VPWR VGND sg13cmos5l_decap_8
X_3220_ _3220_/Y _3210_/A _3222_/S _3121_/B VPWR VGND sg13cmos5l_o21ai_1
X_3151_ _3172_/B _3483_/Q _3484_/Q VPWR VGND sg13cmos5l_xor2_1
X_2102_ _2226_/A _2214_/A _2216_/A VPWR VGND sg13cmos5l_and2_1
XFILLER_48_782 VPWR VGND sg13cmos5l_decap_8
X_3082_ _3082_/Y _3492_/Q _3535_/Q VPWR VGND sg13cmos5l_nor2_1
XFILLER_47_281 VPWR VGND sg13cmos5l_decap_8
X_2033_ _2033_/Y _2034_/B _2115_/A hold633/X VPWR VGND sg13cmos5l_o21ai_1
XFILLER_36_966 VPWR VGND sg13cmos5l_decap_8
XFILLER_22_115 VPWR VGND sg13cmos5l_decap_8
XFILLER_23_638 VPWR VGND sg13cmos5l_decap_8
XFILLER_35_487 VPWR VGND sg13cmos5l_decap_8
X_2935_ _2935_/Y _3509_/Q _3121_/A VPWR VGND sg13cmos5l_nor2b_1
XFILLER_31_671 VPWR VGND sg13cmos5l_decap_4
X_2866_ _3168_/A _3509_/Q _2868_/B VPWR VGND sg13cmos5l_or2_1
XFILLER_30_181 VPWR VGND sg13cmos5l_decap_8
XFILLER_11_1013 VPWR VGND sg13cmos5l_decap_8
X_1817_ _1817_/Y _2083_/A VPWR VGND sg13cmos5l_inv_1
X_2797_ _2825_/S _2797_/A _2797_/B VPWR VGND sg13cmos5l_nor2_1
X_3418_ _3418_/Q _3453_/CLK _3418_/D _3418_/RESET_B VPWR VGND sg13cmos5l_dfrbpq_1
X_3349_ _3349_/Q _3355_/CLK _3349_/D _3349_/RESET_B VPWR VGND sg13cmos5l_dfrbpq_1
XFILLER_38_281 VPWR VGND sg13cmos5l_decap_4
XFILLER_27_944 VPWR VGND sg13cmos5l_decap_8
XFILLER_42_903 VPWR VGND sg13cmos5l_decap_8
XFILLER_13_104 VPWR VGND sg13cmos5l_decap_8
XFILLER_26_487 VPWR VGND sg13cmos5l_fill_2
XFILLER_41_446 VPWR VGND sg13cmos5l_decap_8
XFILLER_13_148 VPWR VGND sg13cmos5l_decap_8
XFILLER_9_108 VPWR VGND sg13cmos5l_decap_8
XFILLER_10_800 VPWR VGND sg13cmos5l_decap_8
XFILLER_42_77 VPWR VGND sg13cmos5l_decap_8
XFILLER_6_804 VPWR VGND sg13cmos5l_decap_8
XFILLER_10_877 VPWR VGND sg13cmos5l_decap_8
XFILLER_49_513 VPWR VGND sg13cmos5l_fill_2
XFILLER_45_730 VPWR VGND sg13cmos5l_decap_8
XFILLER_44_240 VPWR VGND sg13cmos5l_decap_8
XFILLER_18_988 VPWR VGND sg13cmos5l_decap_8
XFILLER_17_465 VPWR VGND sg13cmos5l_decap_8
XFILLER_32_446 VPWR VGND sg13cmos5l_fill_1
XFILLER_9_620 VPWR VGND sg13cmos5l_decap_8
XFILLER_9_642 VPWR VGND sg13cmos5l_decap_8
XFILLER_12_170 VPWR VGND sg13cmos5l_fill_1
X_2720_ _2720_/X _3442_/Q _2720_/B VPWR VGND sg13cmos5l_or2_1
X_2651_ _2651_/Y _2651_/A _2651_/B VPWR VGND sg13cmos5l_nor2_1
X_2582_ _2582_/Y _2787_/A _3445_/Q VPWR VGND sg13cmos5l_nor2_1
X_3367__301 _3367_/RESET_B VPWR VGND sg13cmos5l_tiehi
X_3203_ _3203_/Y _3149_/Y _3194_/X _3210_/A _3210_/B VPWR VGND sg13cmos5l_a22oi_1
XFILLER_41_1028 VPWR VGND sg13cmos5l_fill_1
XFILLER_41_1017 VPWR VGND sg13cmos5l_decap_8
X_3134_ _3201_/A _3200_/A _3200_/B _3200_/C VPWR VGND sg13cmos5l_a21oi_1
X_3065_ _3511_/D _3223_/A _3187_/A VPWR VGND sg13cmos5l_nor2_1
XFILLER_36_741 VPWR VGND sg13cmos5l_decap_8
XFILLER_24_903 VPWR VGND sg13cmos5l_decap_8
X_2016_ _2016_/Y _2015_/Y _2018_/A VPWR VGND sg13cmos5l_nand2b_1
XFILLER_24_914 VPWR VGND sg13cmos5l_fill_1
XFILLER_24_947 VPWR VGND sg13cmos5l_decap_8
XFILLER_35_284 VPWR VGND sg13cmos5l_decap_8
X_2918_ _3009_/B _2978_/B VPWR VGND sg13cmos5l_inv_1
XFILLER_12_25 VPWR VGND sg13cmos5l_decap_4
X_2849_ _2849_/Y _2879_/A VPWR VGND sg13cmos5l_inv_1
XFILLER_3_807 VPWR VGND sg13cmos5l_decap_8
XFILLER_2_1022 VPWR VGND sg13cmos5l_decap_8
XFILLER_18_229 VPWR VGND sg13cmos5l_decap_4
XFILLER_14_413 VPWR VGND sg13cmos5l_fill_1
XFILLER_27_774 VPWR VGND sg13cmos5l_decap_4
XFILLER_27_785 VPWR VGND sg13cmos5l_decap_8
XFILLER_27_796 VPWR VGND sg13cmos5l_fill_1
XFILLER_42_744 VPWR VGND sg13cmos5l_decap_8
XFILLER_41_232 VPWR VGND sg13cmos5l_decap_8
XFILLER_41_221 VPWR VGND sg13cmos5l_fill_2
XFILLER_41_210 VPWR VGND sg13cmos5l_decap_8
XFILLER_14_424 VPWR VGND sg13cmos5l_decap_8
XFILLER_30_906 VPWR VGND sg13cmos5l_decap_8
XFILLER_41_254 VPWR VGND sg13cmos5l_fill_1
XFILLER_30_928 VPWR VGND sg13cmos5l_fill_2
XFILLER_41_276 VPWR VGND sg13cmos5l_decap_8
Xclkbuf_leaf_21_clk clkload6/A clkbuf_leaf_2_clk/A VPWR VGND sg13cmos5l_buf_8
XFILLER_5_144 VPWR VGND sg13cmos5l_decap_8
XFILLER_5_177 VPWR VGND sg13cmos5l_fill_2
XFILLER_5_166 VPWR VGND sg13cmos5l_decap_8
XFILLER_2_840 VPWR VGND sg13cmos5l_decap_8
XFILLER_49_332 VPWR VGND sg13cmos5l_decap_8
XFILLER_1_394 VPWR VGND sg13cmos5l_fill_1
XFILLER_49_376 VPWR VGND sg13cmos5l_decap_8
XFILLER_18_741 VPWR VGND sg13cmos5l_decap_8
XFILLER_33_766 VPWR VGND sg13cmos5l_fill_1
XFILLER_32_298 VPWR VGND sg13cmos5l_decap_8
Xclkbuf_leaf_12_clk _3442_/CLK clkload1/A VPWR VGND sg13cmos5l_buf_8
X_2703_ _3447_/D _2839_/A _2703_/B VPWR VGND sg13cmos5l_nor2_1
XFILLER_9_494 VPWR VGND sg13cmos5l_decap_8
X_2634_ _2649_/A _2648_/A _2648_/B _2648_/C VPWR VGND sg13cmos5l_a21oi_1
X_2565_ _2655_/B _2537_/X _2548_/B _2349_/Y VPWR VGND sg13cmos5l_o21ai_1
X_2496_ _2522_/A _3417_/Q _2498_/A VPWR VGND sg13cmos5l_xor2_1
XFILLER_4_92 VPWR VGND sg13cmos5l_decap_4
XFILLER_4_81 VPWR VGND sg13cmos5l_fill_1
X_3117_ _3117_/Y hold519/X _3117_/A2 _2427_/A VPWR VGND sg13cmos5l_o21ai_1
X_3048_ _3054_/B _3535_/Q _3049_/B VPWR VGND sg13cmos5l_nor2b_1
XFILLER_24_744 VPWR VGND sg13cmos5l_decap_8
XFILLER_24_766 VPWR VGND sg13cmos5l_decap_8
XFILLER_11_449 VPWR VGND sg13cmos5l_decap_8
XFILLER_20_994 VPWR VGND sg13cmos5l_decap_8
XFILLER_2_136 VPWR VGND sg13cmos5l_decap_8
XFILLER_48_65 VPWR VGND sg13cmos5l_decap_4
XFILLER_47_836 VPWR VGND sg13cmos5l_decap_8
XFILLER_19_516 VPWR VGND sg13cmos5l_decap_8
XFILLER_0_39 VPWR VGND sg13cmos5l_decap_8
XFILLER_0_28 VPWR VGND sg13cmos5l_decap_8
XFILLER_15_700 VPWR VGND sg13cmos5l_fill_1
XFILLER_15_733 VPWR VGND sg13cmos5l_decap_8
XFILLER_15_755 VPWR VGND sg13cmos5l_fill_2
XFILLER_42_541 VPWR VGND sg13cmos5l_decap_8
XFILLER_14_243 VPWR VGND sg13cmos5l_fill_1
XFILLER_30_703 VPWR VGND sg13cmos5l_decap_8
XFILLER_11_950 VPWR VGND sg13cmos5l_decap_8
XFILLER_7_976 VPWR VGND sg13cmos5l_decap_8
XFILLER_10_493 VPWR VGND sg13cmos5l_decap_8
XFILLER_6_486 VPWR VGND sg13cmos5l_decap_8
X_2350_ _2350_/Y _2350_/A _2350_/B VPWR VGND sg13cmos5l_nor2_1
XFILLER_9_1028 VPWR VGND sg13cmos5l_fill_1
X_2281_ _2282_/C _2283_/D _2281_/B VPWR VGND sg13cmos5l_and2_1
Xclkbuf_leaf_1_clk clkload2/A clkbuf_leaf_2_clk/A VPWR VGND sg13cmos5l_buf_8
XFILLER_49_173 VPWR VGND sg13cmos5l_decap_4
XFILLER_37_324 VPWR VGND sg13cmos5l_fill_2
XFILLER_37_302 VPWR VGND sg13cmos5l_fill_2
XFILLER_49_195 VPWR VGND sg13cmos5l_decap_8
XFILLER_38_869 VPWR VGND sg13cmos5l_fill_2
XFILLER_18_560 VPWR VGND sg13cmos5l_decap_8
XFILLER_25_508 VPWR VGND sg13cmos5l_decap_8
XFILLER_25_519 VPWR VGND sg13cmos5l_fill_2
XFILLER_21_769 VPWR VGND sg13cmos5l_decap_8
X_1996_ _1996_/Y _1996_/A _1996_/B _1996_/C VPWR VGND sg13cmos5l_nand3_1
X_2617_ _2617_/Y _2617_/A _2617_/B _2617_/C _2617_/D VPWR VGND sg13cmos5l_nand4_1
XFILLER_0_629 VPWR VGND sg13cmos5l_decap_8
X_2548_ _2550_/B _2548_/A _2548_/B VPWR VGND sg13cmos5l_nor2_1
X_3445__103 _3445_/D VPWR VGND sg13cmos5l_tielo
X_2479_ _3411_/D _2479_/A _2479_/B VPWR VGND sg13cmos5l_nor2_1
XFILLER_18_35 VPWR VGND sg13cmos5l_decap_8
XFILLER_28_346 VPWR VGND sg13cmos5l_decap_8
XFILLER_44_839 VPWR VGND sg13cmos5l_decap_8
XFILLER_43_349 VPWR VGND sg13cmos5l_fill_2
XFILLER_24_530 VPWR VGND sg13cmos5l_fill_2
XFILLER_34_56 VPWR VGND sg13cmos5l_decap_8
XFILLER_34_67 VPWR VGND sg13cmos5l_fill_2
XFILLER_34_89 VPWR VGND sg13cmos5l_fill_2
XFILLER_11_224 VPWR VGND sg13cmos5l_decap_8
XFILLER_11_279 VPWR VGND sg13cmos5l_decap_8
Xclkload0 clkload0/X clkload0/A VPWR VGND sg13cmos5l_buf_8
XFILLER_4_924 VPWR VGND sg13cmos5l_decap_8
XFILLER_3_434 VPWR VGND sg13cmos5l_decap_8
XFILLER_3_489 VPWR VGND sg13cmos5l_fill_2
XFILLER_46_110 VPWR VGND sg13cmos5l_decap_8
XFILLER_47_677 VPWR VGND sg13cmos5l_decap_4
XFILLER_35_828 VPWR VGND sg13cmos5l_decap_8
XFILLER_35_839 VPWR VGND sg13cmos5l_fill_2
X_1850_ _2237_/B _1850_/A VPWR VGND sg13cmos5l_inv_1
X_3520_ _3520_/Q clkload5/A _3520_/D _3520_/RESET_B VPWR VGND sg13cmos5l_dfrbpq_1
Xhold707 _2378_/A _3380_/Q VPWR VGND sg13cmos5l_dlygate4sd3_1
XFILLER_6_250 VPWR VGND sg13cmos5l_decap_8
Xhold718 _2056_/B _2055_/Y VPWR VGND sg13cmos5l_dlygate4sd3_1
X_3451_ _3451_/Q _3485_/CLK _3451_/D _3451_/RESET_B VPWR VGND sg13cmos5l_dfrbpq_1
Xhold729 _2854_/A _3479_/Q VPWR VGND sg13cmos5l_dlygate4sd3_1
X_3382_ _3382_/Q _3409_/CLK _3382_/D _3382_/RESET_B VPWR VGND sg13cmos5l_dfrbpq_1
X_2402_ _2402_/Y _3394_/Q _2412_/A _2409_/A _3393_/Q VPWR VGND sg13cmos5l_a22oi_1
X_2333_ _2341_/A _2333_/A _2333_/B _2333_/C VPWR VGND sg13cmos5l_nor3_1
X_2264_ _3377_/D _2264_/A _2264_/B VPWR VGND sg13cmos5l_and2_1
X_2195_ _2200_/S _2189_/Y _2194_/Y _2181_/Y VPWR VGND sg13cmos5l_o21ai_1
XFILLER_1_60 VPWR VGND sg13cmos5l_decap_4
XFILLER_19_891 VPWR VGND sg13cmos5l_decap_8
XFILLER_34_861 VPWR VGND sg13cmos5l_decap_8
XFILLER_33_371 VPWR VGND sg13cmos5l_fill_2
XFILLER_21_533 VPWR VGND sg13cmos5l_decap_8
XFILLER_14_1000 VPWR VGND sg13cmos5l_decap_8
X_1979_ _3306_/D _1800_/Y _1983_/A2 _1978_/Y VPWR VGND sg13cmos5l_a21oi_1
XFILLER_1_949 VPWR VGND sg13cmos5l_decap_8
XFILLER_0_459 VPWR VGND sg13cmos5l_decap_8
XFILLER_29_56 VPWR VGND sg13cmos5l_decap_8
XFILLER_29_611 VPWR VGND sg13cmos5l_decap_8
XFILLER_21_1004 VPWR VGND sg13cmos5l_decap_8
XFILLER_17_817 VPWR VGND sg13cmos5l_decap_8
XFILLER_16_349 VPWR VGND sg13cmos5l_decap_8
XFILLER_28_187 VPWR VGND sg13cmos5l_decap_8
XFILLER_44_669 VPWR VGND sg13cmos5l_fill_2
XFILLER_43_135 VPWR VGND sg13cmos5l_decap_8
XFILLER_25_850 VPWR VGND sg13cmos5l_fill_1
XFILLER_43_179 VPWR VGND sg13cmos5l_decap_8
XFILLER_25_883 VPWR VGND sg13cmos5l_decap_8
XFILLER_8_504 VPWR VGND sg13cmos5l_decap_8
XFILLER_12_555 VPWR VGND sg13cmos5l_fill_1
XFILLER_12_577 VPWR VGND sg13cmos5l_decap_8
XFILLER_3_231 VPWR VGND sg13cmos5l_fill_1
XFILLER_4_798 VPWR VGND sg13cmos5l_decap_8
XFILLER_48_964 VPWR VGND sg13cmos5l_decap_8
XFILLER_47_452 VPWR VGND sg13cmos5l_decap_8
XFILLER_19_154 VPWR VGND sg13cmos5l_decap_4
XFILLER_37_1000 VPWR VGND sg13cmos5l_decap_8
XFILLER_34_146 VPWR VGND sg13cmos5l_decap_4
X_2951_ _2951_/Y _3492_/Q _2951_/B VPWR VGND sg13cmos5l_nor2_1
XFILLER_22_308 VPWR VGND sg13cmos5l_fill_2
X_1902_ _1948_/A _1966_/A _1902_/B VPWR VGND sg13cmos5l_nand2_1
X_2882_ _2884_/B _2863_/X _2882_/B VPWR VGND sg13cmos5l_nand2b_1
XFILLER_30_363 VPWR VGND sg13cmos5l_fill_1
X_1833_ _2025_/C _3316_/Q VPWR VGND sg13cmos5l_inv_1
Xhold526 hold526/X _3264_/Q VPWR VGND sg13cmos5l_dlygate4sd3_1
XFILLER_7_581 VPWR VGND sg13cmos5l_decap_8
X_3503_ _3503_/Q _3504_/CLK _3503_/D _3503_/RESET_B VPWR VGND sg13cmos5l_dfrbpq_1
Xhold504 _3431_/D _2605_/Y VPWR VGND sg13cmos5l_dlygate4sd3_1
Xhold515 hold515/X _3261_/Q VPWR VGND sg13cmos5l_dlygate4sd3_1
Xhold537 hold537/X _3291_/Q VPWR VGND sg13cmos5l_dlygate4sd3_1
Xhold548 _1951_/A _3305_/Q VPWR VGND sg13cmos5l_dlygate4sd3_1
Xhold559 _2957_/B _3461_/Q VPWR VGND sg13cmos5l_dlygate4sd3_1
X_3434_ _3434_/Q _3472_/CLK _3434_/D _3434_/RESET_B VPWR VGND sg13cmos5l_dfrbpq_1
XFILLER_44_1015 VPWR VGND sg13cmos5l_decap_8
X_3365_ _3365_/Q _3408_/CLK _3365_/D _3365_/RESET_B VPWR VGND sg13cmos5l_dfrbpq_1
X_3296_ _3296_/Q clkload6/A _3296_/D _3296_/RESET_B VPWR VGND sg13cmos5l_dfrbpq_1
X_2316_ _2330_/B _3411_/Q _3410_/Q _3412_/Q VPWR VGND sg13cmos5l_nor3_1
X_2247_ _3364_/D _2307_/A _2247_/B VPWR VGND sg13cmos5l_nor2_1
XFILLER_39_975 VPWR VGND sg13cmos5l_decap_8
XFILLER_38_474 VPWR VGND sg13cmos5l_decap_8
XFILLER_26_603 VPWR VGND sg13cmos5l_decap_8
X_2178_ _2264_/B _3543_/D _2419_/B VPWR VGND sg13cmos5l_nor2_1
XFILLER_15_25 VPWR VGND sg13cmos5l_fill_2
XFILLER_22_842 VPWR VGND sg13cmos5l_fill_1
XFILLER_22_853 VPWR VGND sg13cmos5l_fill_1
XFILLER_34_691 VPWR VGND sg13cmos5l_decap_8
XFILLER_21_352 VPWR VGND sg13cmos5l_fill_1
XFILLER_22_864 VPWR VGND sg13cmos5l_decap_4
XFILLER_1_746 VPWR VGND sg13cmos5l_decap_8
XFILLER_45_956 VPWR VGND sg13cmos5l_decap_8
XFILLER_44_411 VPWR VGND sg13cmos5l_fill_2
XFILLER_16_157 VPWR VGND sg13cmos5l_fill_2
XFILLER_17_669 VPWR VGND sg13cmos5l_decap_8
XFILLER_44_499 VPWR VGND sg13cmos5l_decap_8
XFILLER_44_477 VPWR VGND sg13cmos5l_decap_8
XFILLER_13_820 VPWR VGND sg13cmos5l_decap_8
XFILLER_9_802 VPWR VGND sg13cmos5l_decap_8
XFILLER_13_853 VPWR VGND sg13cmos5l_decap_8
XFILLER_31_127 VPWR VGND sg13cmos5l_decap_8
XFILLER_40_650 VPWR VGND sg13cmos5l_decap_8
XFILLER_8_301 VPWR VGND sg13cmos5l_decap_8
XFILLER_8_345 VPWR VGND sg13cmos5l_decap_8
XFILLER_8_367 VPWR VGND sg13cmos5l_decap_8
XFILLER_9_879 VPWR VGND sg13cmos5l_decap_8
X_3150_ _3157_/B _3483_/Q _3484_/Q VPWR VGND sg13cmos5l_nor2_1
X_2101_ _2216_/A _3355_/Q _2101_/B VPWR VGND sg13cmos5l_xnor2_1
X_3081_ _3081_/Y _3076_/Y _3078_/Y _3080_/Y VPWR VGND sg13cmos5l_o21ai_1
XFILLER_48_761 VPWR VGND sg13cmos5l_decap_8
X_2032_ _2032_/Y _2032_/A _3317_/Q VPWR VGND sg13cmos5l_nor2b_1
XFILLER_11_4 VPWR VGND sg13cmos5l_decap_8
XFILLER_36_945 VPWR VGND sg13cmos5l_decap_8
XFILLER_35_433 VPWR VGND sg13cmos5l_fill_1
X_2934_ _2934_/X _3456_/Q _2934_/B VPWR VGND sg13cmos5l_and2_1
XFILLER_31_650 VPWR VGND sg13cmos5l_decap_8
X_2865_ _2865_/Y _3509_/Q _2868_/B VPWR VGND sg13cmos5l_nor2_1
XFILLER_30_193 VPWR VGND sg13cmos5l_decap_8
X_1816_ _1816_/Y _2082_/A VPWR VGND sg13cmos5l_inv_1
XFILLER_8_890 VPWR VGND sg13cmos5l_decap_8
X_2796_ _2797_/B _2828_/A _2796_/B VPWR VGND sg13cmos5l_nor2_1
X_3417_ _3417_/Q _3453_/CLK _3417_/D _3417_/RESET_B VPWR VGND sg13cmos5l_dfrbpq_1
X_3348_ _3348_/Q _3378_/CLK _3348_/D _3348_/RESET_B VPWR VGND sg13cmos5l_dfrbpq_1
X_3279_ _3279_/Q clkload8/A _3279_/D _3279_/RESET_B VPWR VGND sg13cmos5l_dfrbpq_1
XFILLER_39_783 VPWR VGND sg13cmos5l_fill_2
XFILLER_26_13 VPWR VGND sg13cmos5l_decap_8
XFILLER_14_617 VPWR VGND sg13cmos5l_fill_2
XFILLER_42_959 VPWR VGND sg13cmos5l_decap_8
XFILLER_21_171 VPWR VGND sg13cmos5l_decap_8
XFILLER_10_856 VPWR VGND sg13cmos5l_decap_8
X_3273__142 _3273_/RESET_B VPWR VGND sg13cmos5l_tiehi
XFILLER_27_1021 VPWR VGND sg13cmos5l_decap_8
XFILLER_1_587 VPWR VGND sg13cmos5l_fill_1
XFILLER_49_547 VPWR VGND sg13cmos5l_fill_2
XFILLER_37_709 VPWR VGND sg13cmos5l_decap_8
XFILLER_17_400 VPWR VGND sg13cmos5l_decap_4
X_3280__135 _3280_/RESET_B VPWR VGND sg13cmos5l_tiehi
XFILLER_18_967 VPWR VGND sg13cmos5l_decap_8
XFILLER_29_293 VPWR VGND sg13cmos5l_decap_8
XFILLER_45_786 VPWR VGND sg13cmos5l_decap_8
XFILLER_33_959 VPWR VGND sg13cmos5l_decap_8
XFILLER_34_1025 VPWR VGND sg13cmos5l_decap_4
XFILLER_8_153 VPWR VGND sg13cmos5l_fill_2
X_2650_ _2650_/Y _2650_/A VPWR VGND sg13cmos5l_inv_1
XFILLER_9_698 VPWR VGND sg13cmos5l_decap_8
X_2581_ _2581_/Y _3397_/Q _2581_/B VPWR VGND sg13cmos5l_nor2_1
XFILLER_5_882 VPWR VGND sg13cmos5l_decap_8
XFILLER_4_392 VPWR VGND sg13cmos5l_decap_4
X_3202_ _3210_/B _3186_/B _3068_/B _3202_/S VPWR VGND sg13cmos5l_mux2_1
X_3133_ _3200_/C _3528_/Q _3143_/B VPWR VGND sg13cmos5l_xnor2_1
X_3064_ _3187_/A _3036_/X _3063_/Y _3070_/A VPWR VGND sg13cmos5l_mux2_1
X_2015_ _2015_/Y _2014_/B _1869_/C hold592/X VPWR VGND sg13cmos5l_a21oi_1
XFILLER_36_775 VPWR VGND sg13cmos5l_fill_2
XFILLER_24_926 VPWR VGND sg13cmos5l_decap_8
XFILLER_35_263 VPWR VGND sg13cmos5l_decap_8
X_3304__385 _3304_/RESET_B VPWR VGND sg13cmos5l_tiehi
X_2917_ _2978_/B _2917_/A _2917_/B VPWR VGND sg13cmos5l_nor2_1
XFILLER_32_992 VPWR VGND sg13cmos5l_decap_8
X_2848_ _2879_/A _3506_/Q _3507_/Q VPWR VGND sg13cmos5l_xnor2_1
X_2779_ _2779_/Y hold509/X _3118_/A2 _2427_/A VPWR VGND sg13cmos5l_o21ai_1
XFILLER_37_56 VPWR VGND sg13cmos5l_decap_8
XFILLER_2_1001 VPWR VGND sg13cmos5l_decap_8
XFILLER_42_712 VPWR VGND sg13cmos5l_decap_8
XFILLER_42_756 VPWR VGND sg13cmos5l_decap_4
XFILLER_15_959 VPWR VGND sg13cmos5l_decap_8
XFILLER_18_1009 VPWR VGND sg13cmos5l_decap_8
XFILLER_42_767 VPWR VGND sg13cmos5l_fill_1
XFILLER_41_288 VPWR VGND sg13cmos5l_decap_8
XFILLER_22_480 VPWR VGND sg13cmos5l_decap_8
XFILLER_10_631 VPWR VGND sg13cmos5l_fill_2
XFILLER_6_635 VPWR VGND sg13cmos5l_decap_4
XFILLER_6_646 VPWR VGND sg13cmos5l_decap_8
XFILLER_10_697 VPWR VGND sg13cmos5l_decap_8
XFILLER_2_896 VPWR VGND sg13cmos5l_decap_8
XFILLER_45_561 VPWR VGND sg13cmos5l_decap_8
XFILLER_18_797 VPWR VGND sg13cmos5l_decap_8
XFILLER_33_723 VPWR VGND sg13cmos5l_fill_1
XFILLER_33_734 VPWR VGND sg13cmos5l_fill_2
XFILLER_32_255 VPWR VGND sg13cmos5l_decap_8
XFILLER_33_778 VPWR VGND sg13cmos5l_decap_8
XFILLER_20_439 VPWR VGND sg13cmos5l_decap_4
XFILLER_32_277 VPWR VGND sg13cmos5l_decap_8
X_2702_ _2702_/Y _2703_/B VPWR VGND sg13cmos5l_inv_1
XFILLER_13_480 VPWR VGND sg13cmos5l_decap_8
XFILLER_9_473 VPWR VGND sg13cmos5l_decap_8
X_2633_ _2648_/C _3438_/Q _2645_/B VPWR VGND sg13cmos5l_xnor2_1
X_2564_ _3421_/D _2673_/A _2651_/A VPWR VGND sg13cmos5l_nor2_1
X_2495_ _2505_/B _3417_/Q _2498_/A VPWR VGND sg13cmos5l_nor2_1
X_3116_ _3116_/Y _1797_/Y _3119_/A2 _3115_/Y VPWR VGND sg13cmos5l_a21oi_1
XFILLER_28_517 VPWR VGND sg13cmos5l_decap_8
X_3263__152 _3263_/RESET_B VPWR VGND sg13cmos5l_tiehi
X_3047_ _3047_/Y _3042_/A _3045_/Y _3046_/Y VPWR VGND sg13cmos5l_a21oi_1
XFILLER_24_723 VPWR VGND sg13cmos5l_decap_8
XFILLER_12_929 VPWR VGND sg13cmos5l_decap_8
XFILLER_11_428 VPWR VGND sg13cmos5l_decap_8
XFILLER_23_14 VPWR VGND sg13cmos5l_decap_8
XFILLER_20_973 VPWR VGND sg13cmos5l_decap_8
XFILLER_3_627 VPWR VGND sg13cmos5l_decap_8
X_3270__145 _3270_/RESET_B VPWR VGND sg13cmos5l_tiehi
XFILLER_2_115 VPWR VGND sg13cmos5l_decap_8
XFILLER_47_815 VPWR VGND sg13cmos5l_decap_8
XFILLER_24_1024 VPWR VGND sg13cmos5l_decap_4
XFILLER_19_539 VPWR VGND sg13cmos5l_decap_8
XFILLER_15_712 VPWR VGND sg13cmos5l_decap_8
X_3461__197 _3461_/RESET_B VPWR VGND sg13cmos5l_tiehi
XFILLER_27_561 VPWR VGND sg13cmos5l_decap_8
XFILLER_42_520 VPWR VGND sg13cmos5l_decap_8
XFILLER_30_726 VPWR VGND sg13cmos5l_decap_8
XFILLER_30_737 VPWR VGND sg13cmos5l_fill_1
Xfanout70 _2784_/A _2427_/A VPWR VGND sg13cmos5l_buf_1
XFILLER_7_955 VPWR VGND sg13cmos5l_decap_8
XFILLER_2_682 VPWR VGND sg13cmos5l_fill_1
X_2280_ _2299_/A _2285_/B _2287_/A _2280_/C VPWR VGND sg13cmos5l_nor3_1
XFILLER_49_152 VPWR VGND sg13cmos5l_decap_8
XFILLER_46_892 VPWR VGND sg13cmos5l_decap_8
XFILLER_33_542 VPWR VGND sg13cmos5l_fill_1
XFILLER_33_586 VPWR VGND sg13cmos5l_decap_8
X_1995_ _1996_/C _3546_/Q _1995_/B VPWR VGND sg13cmos5l_nor2_1
XFILLER_9_270 VPWR VGND sg13cmos5l_decap_8
XFILLER_9_281 VPWR VGND sg13cmos5l_fill_2
X_2616_ _2616_/X _2621_/A _2655_/B VPWR VGND sg13cmos5l_or2_1
XFILLER_0_608 VPWR VGND sg13cmos5l_decap_8
X_2547_ _2557_/B _2534_/X _2541_/X _2545_/Y VPWR VGND sg13cmos5l_o21ai_1
X_2478_ _2479_/B _2466_/Y _2474_/A _2477_/Y VPWR VGND sg13cmos5l_o21ai_1
XFILLER_18_25 VPWR VGND sg13cmos5l_fill_1
XFILLER_44_818 VPWR VGND sg13cmos5l_decap_8
XFILLER_34_35 VPWR VGND sg13cmos5l_decap_8
XFILLER_12_715 VPWR VGND sg13cmos5l_fill_1
XFILLER_8_719 VPWR VGND sg13cmos5l_fill_2
Xclkload1 clkload1/X clkload1/A VPWR VGND sg13cmos5l_buf_8
XFILLER_20_781 VPWR VGND sg13cmos5l_decap_8
XFILLER_4_903 VPWR VGND sg13cmos5l_decap_8
XFILLER_3_413 VPWR VGND sg13cmos5l_decap_8
XFILLER_47_634 VPWR VGND sg13cmos5l_decap_8
XFILLER_19_336 VPWR VGND sg13cmos5l_decap_4
XFILLER_35_807 VPWR VGND sg13cmos5l_decap_8
XFILLER_43_895 VPWR VGND sg13cmos5l_decap_8
XFILLER_15_575 VPWR VGND sg13cmos5l_decap_8
XFILLER_30_556 VPWR VGND sg13cmos5l_fill_2
XFILLER_11_770 VPWR VGND sg13cmos5l_decap_8
XFILLER_30_567 VPWR VGND sg13cmos5l_decap_8
Xhold708 _2381_/B _2380_/X VPWR VGND sg13cmos5l_dlygate4sd3_1
Xhold719 _2080_/A _2083_/B VPWR VGND sg13cmos5l_dlygate4sd3_1
XFILLER_6_295 VPWR VGND sg13cmos5l_fill_1
XFILLER_6_284 VPWR VGND sg13cmos5l_decap_8
X_3450_ _3450_/Q _3485_/CLK _3450_/D _3450_/RESET_B VPWR VGND sg13cmos5l_dfrbpq_1
XFILLER_41_4 VPWR VGND sg13cmos5l_decap_8
X_3381_ _3381_/Q _3408_/CLK _3381_/D _3381_/RESET_B VPWR VGND sg13cmos5l_dfrbpq_1
X_2401_ _2409_/A _2399_/C _2400_/Y _2399_/Y VPWR VGND sg13cmos5l_a21oi_1
X_2332_ _2333_/C _2349_/A _2350_/B VPWR VGND sg13cmos5l_nor2_1
X_2263_ _3376_/D _2263_/A _2307_/A VPWR VGND sg13cmos5l_nor2_1
XFILLER_38_601 VPWR VGND sg13cmos5l_decap_4
X_2194_ _2194_/Y _2183_/Y _2202_/A _2199_/B VPWR VGND sg13cmos5l_o21ai_1
XFILLER_38_645 VPWR VGND sg13cmos5l_decap_8
XFILLER_19_881 VPWR VGND sg13cmos5l_fill_2
X_3260__155 _3260_/RESET_B VPWR VGND sg13cmos5l_tiehi
XFILLER_34_840 VPWR VGND sg13cmos5l_decap_8
XFILLER_21_501 VPWR VGND sg13cmos5l_fill_2
XFILLER_21_512 VPWR VGND sg13cmos5l_decap_8
X_1978_ _1978_/Y _1983_/A2 hold476/X _3028_/B VPWR VGND sg13cmos5l_o21ai_1
XFILLER_0_427 VPWR VGND sg13cmos5l_decap_4
XFILLER_1_928 VPWR VGND sg13cmos5l_decap_8
XFILLER_0_438 VPWR VGND sg13cmos5l_decap_8
XFILLER_28_133 VPWR VGND sg13cmos5l_fill_1
XFILLER_28_166 VPWR VGND sg13cmos5l_decap_8
XFILLER_44_648 VPWR VGND sg13cmos5l_decap_8
XFILLER_16_339 VPWR VGND sg13cmos5l_decap_4
XFILLER_28_177 VPWR VGND sg13cmos5l_fill_2
XFILLER_25_862 VPWR VGND sg13cmos5l_decap_8
XFILLER_24_372 VPWR VGND sg13cmos5l_decap_8
XFILLER_8_549 VPWR VGND sg13cmos5l_decap_8
XFILLER_6_39 VPWR VGND sg13cmos5l_decap_8
XFILLER_6_28 VPWR VGND sg13cmos5l_fill_2
XFILLER_3_210 VPWR VGND sg13cmos5l_fill_1
XFILLER_3_287 VPWR VGND sg13cmos5l_decap_8
XFILLER_3_276 VPWR VGND sg13cmos5l_fill_1
XFILLER_48_943 VPWR VGND sg13cmos5l_decap_8
XFILLER_0_994 VPWR VGND sg13cmos5l_decap_8
XFILLER_19_100 VPWR VGND sg13cmos5l_decap_8
XFILLER_19_144 VPWR VGND sg13cmos5l_fill_1
X_2950_ _2950_/Y _2950_/A _2950_/B VPWR VGND sg13cmos5l_nor2_1
XFILLER_16_873 VPWR VGND sg13cmos5l_decap_8
XFILLER_42_191 VPWR VGND sg13cmos5l_fill_1
X_2881_ _3480_/D _2970_/B _2881_/B VPWR VGND sg13cmos5l_and2_1
X_1901_ _1914_/A _1901_/A _2018_/A VPWR VGND sg13cmos5l_nand2_1
XFILLER_31_854 VPWR VGND sg13cmos5l_decap_8
X_1832_ _3253_/A _3114_/A VPWR VGND sg13cmos5l_inv_1
XFILLER_7_560 VPWR VGND sg13cmos5l_decap_8
Xhold505 _2052_/B _3263_/Q VPWR VGND sg13cmos5l_dlygate4sd3_1
Xhold516 _2043_/B _3288_/Q VPWR VGND sg13cmos5l_dlygate4sd3_1
X_3502_ _3502_/Q _3504_/CLK _3502_/D _3502_/RESET_B VPWR VGND sg13cmos5l_dfrbpq_1
Xhold527 hold527/X _3259_/Q VPWR VGND sg13cmos5l_dlygate4sd3_1
Xhold538 _3291_/D _1941_/X VPWR VGND sg13cmos5l_dlygate4sd3_1
Xhold549 hold549/X _1976_/Y VPWR VGND sg13cmos5l_dlygate4sd3_1
X_3433_ _3433_/Q clkload3/A _3433_/D _3433_/RESET_B VPWR VGND sg13cmos5l_dfrbpq_1
X_3364_ _3364_/Q _3408_/CLK _3364_/D _3364_/RESET_B VPWR VGND sg13cmos5l_dfrbpq_1
X_3295_ _3295_/Q clkload2/A _3295_/D _3295_/RESET_B VPWR VGND sg13cmos5l_dfrbpq_1
X_2315_ _2318_/B _3411_/Q _3410_/Q VPWR VGND sg13cmos5l_nor2_1
XFILLER_39_954 VPWR VGND sg13cmos5l_decap_8
X_2246_ _2246_/X _2240_/B _2399_/B _2248_/S VPWR VGND sg13cmos5l_mux2_1
X_2177_ _3354_/D _2147_/B _2161_/B _3332_/D VPWR VGND sg13cmos5l_a21o_1
XFILLER_25_103 VPWR VGND sg13cmos5l_decap_4
XFILLER_26_626 VPWR VGND sg13cmos5l_fill_1
XFILLER_25_125 VPWR VGND sg13cmos5l_fill_2
XFILLER_15_48 VPWR VGND sg13cmos5l_decap_8
XFILLER_25_169 VPWR VGND sg13cmos5l_decap_8
XFILLER_15_59 VPWR VGND sg13cmos5l_fill_1
XFILLER_21_364 VPWR VGND sg13cmos5l_decap_8
XFILLER_33_191 VPWR VGND sg13cmos5l_decap_4
XFILLER_31_25 VPWR VGND sg13cmos5l_fill_1
XFILLER_5_508 VPWR VGND sg13cmos5l_fill_1
Xoutput14 uo_out[0] _3293_/Q VPWR VGND sg13cmos5l_buf_1
XFILLER_1_725 VPWR VGND sg13cmos5l_decap_8
XFILLER_49_729 VPWR VGND sg13cmos5l_decap_8
XFILLER_0_279 VPWR VGND sg13cmos5l_decap_8
XFILLER_45_935 VPWR VGND sg13cmos5l_decap_8
XFILLER_17_626 VPWR VGND sg13cmos5l_decap_4
XFILLER_44_456 VPWR VGND sg13cmos5l_decap_8
XFILLER_31_106 VPWR VGND sg13cmos5l_fill_1
XFILLER_25_692 VPWR VGND sg13cmos5l_decap_4
XFILLER_8_324 VPWR VGND sg13cmos5l_decap_8
XFILLER_8_313 VPWR VGND sg13cmos5l_decap_4
XFILLER_9_858 VPWR VGND sg13cmos5l_decap_8
XFILLER_12_386 VPWR VGND sg13cmos5l_decap_4
XFILLER_13_898 VPWR VGND sg13cmos5l_decap_8
XFILLER_4_552 VPWR VGND sg13cmos5l_decap_8
XFILLER_21_91 VPWR VGND sg13cmos5l_fill_2
XFILLER_4_596 VPWR VGND sg13cmos5l_decap_8
X_2100_ _2100_/Y _2265_/A _2264_/A VPWR VGND sg13cmos5l_nand2_1
XFILLER_0_791 VPWR VGND sg13cmos5l_decap_8
X_3080_ _3080_/Y _3491_/Q _3096_/A _3536_/Q _3079_/Y VPWR VGND sg13cmos5l_a22oi_1
XFILLER_48_740 VPWR VGND sg13cmos5l_decap_8
X_2031_ _3315_/D _2087_/A _2031_/B VPWR VGND sg13cmos5l_nor2_1
XFILLER_36_924 VPWR VGND sg13cmos5l_decap_8
XFILLER_35_401 VPWR VGND sg13cmos5l_fill_2
XFILLER_35_412 VPWR VGND sg13cmos5l_fill_1
XFILLER_23_629 VPWR VGND sg13cmos5l_decap_4
X_2933_ _2933_/Y _2948_/B _2947_/A VPWR VGND sg13cmos5l_nor2_1
XFILLER_31_640 VPWR VGND sg13cmos5l_decap_4
X_2864_ _2864_/Y _2852_/X _2857_/Y _3166_/A _2863_/X _2858_/X VPWR VGND sg13cmos5l_a221oi_1
X_2795_ _2797_/A _2828_/A _2796_/B _2792_/Y _2793_/Y _2794_/Y VPWR VGND sg13cmos5l_a221oi_1
X_1815_ _2084_/A _1815_/A VPWR VGND sg13cmos5l_inv_1
X_3416_ _3416_/Q _3453_/CLK _3416_/D _3416_/RESET_B VPWR VGND sg13cmos5l_dfrbpq_1
X_3347_ _3347_/Q _3463_/CLK _3347_/D _3347_/RESET_B VPWR VGND sg13cmos5l_dfrbpq_1
XFILLER_39_762 VPWR VGND sg13cmos5l_decap_8
X_3278_ _3278_/Q clkload8/A _3278_/D _3278_/RESET_B VPWR VGND sg13cmos5l_dfrbpq_1
XFILLER_27_902 VPWR VGND sg13cmos5l_fill_1
X_2229_ _2229_/Y _2359_/A _2237_/B _2235_/B _3379_/Q VPWR VGND sg13cmos5l_a22oi_1
XFILLER_38_294 VPWR VGND sg13cmos5l_fill_2
XFILLER_27_979 VPWR VGND sg13cmos5l_decap_8
XFILLER_42_938 VPWR VGND sg13cmos5l_decap_8
XFILLER_26_467 VPWR VGND sg13cmos5l_decap_8
XFILLER_42_24 VPWR VGND sg13cmos5l_decap_4
XFILLER_10_835 VPWR VGND sg13cmos5l_decap_8
XFILLER_21_150 VPWR VGND sg13cmos5l_decap_8
XFILLER_22_673 VPWR VGND sg13cmos5l_decap_8
XFILLER_21_194 VPWR VGND sg13cmos5l_fill_2
XFILLER_6_839 VPWR VGND sg13cmos5l_decap_8
XFILLER_5_338 VPWR VGND sg13cmos5l_decap_8
XFILLER_3_29 VPWR VGND sg13cmos5l_decap_4
XFILLER_3_18 VPWR VGND sg13cmos5l_decap_8
XFILLER_27_1000 VPWR VGND sg13cmos5l_decap_8
XFILLER_1_555 VPWR VGND sg13cmos5l_fill_1
XFILLER_49_526 VPWR VGND sg13cmos5l_decap_8
XFILLER_17_412 VPWR VGND sg13cmos5l_fill_2
XFILLER_18_946 VPWR VGND sg13cmos5l_decap_8
XFILLER_44_220 VPWR VGND sg13cmos5l_fill_2
XFILLER_17_423 VPWR VGND sg13cmos5l_decap_4
XFILLER_33_905 VPWR VGND sg13cmos5l_decap_4
XFILLER_45_765 VPWR VGND sg13cmos5l_decap_8
XFILLER_32_404 VPWR VGND sg13cmos5l_fill_2
XFILLER_33_927 VPWR VGND sg13cmos5l_decap_4
XFILLER_13_651 VPWR VGND sg13cmos5l_decap_8
XFILLER_34_1004 VPWR VGND sg13cmos5l_decap_8
XFILLER_41_982 VPWR VGND sg13cmos5l_decap_8
XFILLER_12_150 VPWR VGND sg13cmos5l_decap_4
XFILLER_13_673 VPWR VGND sg13cmos5l_decap_8
XFILLER_8_132 VPWR VGND sg13cmos5l_decap_8
XFILLER_9_677 VPWR VGND sg13cmos5l_decap_8
XFILLER_12_183 VPWR VGND sg13cmos5l_decap_8
XFILLER_8_176 VPWR VGND sg13cmos5l_fill_1
XFILLER_8_165 VPWR VGND sg13cmos5l_decap_8
X_2580_ _2580_/Y _2586_/A _2596_/A VPWR VGND sg13cmos5l_nand2_1
XFILLER_5_861 VPWR VGND sg13cmos5l_decap_8
X_3201_ _3210_/A _3201_/A _3201_/B _3201_/C VPWR VGND sg13cmos5l_nor3_1
X_3132_ _3200_/B _3525_/Q _3499_/Q _3527_/Q VPWR VGND sg13cmos5l_nand3_1
XFILLER_36_721 VPWR VGND sg13cmos5l_fill_2
X_3063_ _3063_/Y _3063_/A _3069_/B VPWR VGND sg13cmos5l_nand2_1
XFILLER_27_209 VPWR VGND sg13cmos5l_decap_8
X_2014_ _2014_/Y hold592/X _2014_/B VPWR VGND sg13cmos5l_nand2b_1
XFILLER_35_220 VPWR VGND sg13cmos5l_decap_4
XFILLER_36_787 VPWR VGND sg13cmos5l_fill_1
X_2916_ _2917_/B _2916_/A _2916_/B VPWR VGND sg13cmos5l_nor2_1
XFILLER_31_470 VPWR VGND sg13cmos5l_fill_1
XFILLER_32_971 VPWR VGND sg13cmos5l_decap_8
X_2847_ _2847_/Y hold738/X _3114_/A VPWR VGND sg13cmos5l_nand2b_1
X_2778_ _3462_/D _1809_/Y _3117_/A2 _2777_/Y VPWR VGND sg13cmos5l_a21oi_1
XFILLER_2_319 VPWR VGND sg13cmos5l_decap_8
XFILLER_37_35 VPWR VGND sg13cmos5l_decap_8
XFILLER_27_765 VPWR VGND sg13cmos5l_fill_1
XFILLER_15_938 VPWR VGND sg13cmos5l_decap_8
XFILLER_26_297 VPWR VGND sg13cmos5l_fill_2
XFILLER_42_779 VPWR VGND sg13cmos5l_decap_8
XFILLER_41_245 VPWR VGND sg13cmos5l_decap_8
XFILLER_10_610 VPWR VGND sg13cmos5l_decap_8
XFILLER_23_982 VPWR VGND sg13cmos5l_decap_8
XFILLER_6_614 VPWR VGND sg13cmos5l_fill_2
XFILLER_5_113 VPWR VGND sg13cmos5l_decap_8
XFILLER_5_124 VPWR VGND sg13cmos5l_fill_2
XFILLER_2_875 VPWR VGND sg13cmos5l_decap_8
XFILLER_1_374 VPWR VGND sg13cmos5l_fill_1
XFILLER_18_732 VPWR VGND sg13cmos5l_decap_4
XFILLER_45_540 VPWR VGND sg13cmos5l_decap_8
XFILLER_18_776 VPWR VGND sg13cmos5l_fill_2
XFILLER_45_595 VPWR VGND sg13cmos5l_fill_1
XFILLER_45_584 VPWR VGND sg13cmos5l_decap_8
XFILLER_21_919 VPWR VGND sg13cmos5l_fill_1
XFILLER_14_993 VPWR VGND sg13cmos5l_decap_8
X_2701_ _2703_/B hold702/X _2700_/Y _2701_/S VPWR VGND sg13cmos5l_mux2_1
X_2632_ _2648_/B _3432_/Q _3404_/Q _3437_/Q VPWR VGND sg13cmos5l_nand3_1
X_2563_ _2651_/A _2345_/Y _2550_/Y _2562_/Y VPWR VGND sg13cmos5l_a21o_1
XFILLER_4_61 VPWR VGND sg13cmos5l_decap_4
X_2494_ _2521_/A _2500_/B _2494_/B VPWR VGND sg13cmos5l_nand2b_1
XFILLER_4_72 VPWR VGND sg13cmos5l_decap_8
X_3115_ _3115_/Y _3523_/Q _3119_/A2 _2776_/A VPWR VGND sg13cmos5l_o21ai_1
XFILLER_49_890 VPWR VGND sg13cmos5l_decap_8
X_3046_ _3046_/Y _3045_/B _3033_/C _3066_/A VPWR VGND sg13cmos5l_a21oi_1
XFILLER_24_702 VPWR VGND sg13cmos5l_decap_8
XFILLER_36_540 VPWR VGND sg13cmos5l_fill_1
XFILLER_36_595 VPWR VGND sg13cmos5l_decap_4
XFILLER_36_573 VPWR VGND sg13cmos5l_decap_4
XFILLER_23_223 VPWR VGND sg13cmos5l_decap_8
XFILLER_12_908 VPWR VGND sg13cmos5l_decap_8
XFILLER_20_930 VPWR VGND sg13cmos5l_decap_8
XFILLER_48_34 VPWR VGND sg13cmos5l_decap_4
XFILLER_24_1003 VPWR VGND sg13cmos5l_decap_8
XFILLER_27_540 VPWR VGND sg13cmos5l_decap_8
XFILLER_42_576 VPWR VGND sg13cmos5l_decap_4
XFILLER_14_289 VPWR VGND sg13cmos5l_decap_8
Xfanout60 _3543_/D _3253_/A VPWR VGND sg13cmos5l_buf_1
XFILLER_30_749 VPWR VGND sg13cmos5l_decap_8
Xfanout71 _2427_/A _2610_/A VPWR VGND sg13cmos5l_buf_1
XFILLER_7_934 VPWR VGND sg13cmos5l_decap_8
XFILLER_11_985 VPWR VGND sg13cmos5l_decap_8
XFILLER_6_433 VPWR VGND sg13cmos5l_decap_8
XFILLER_6_477 VPWR VGND sg13cmos5l_fill_2
XFILLER_43_8 VPWR VGND sg13cmos5l_fill_1
XFILLER_9_1019 VPWR VGND sg13cmos5l_decap_8
XFILLER_2_661 VPWR VGND sg13cmos5l_decap_8
XFILLER_49_142 VPWR VGND sg13cmos5l_fill_1
XFILLER_38_827 VPWR VGND sg13cmos5l_decap_8
XFILLER_38_849 VPWR VGND sg13cmos5l_fill_2
XFILLER_46_871 VPWR VGND sg13cmos5l_decap_8
XFILLER_20_204 VPWR VGND sg13cmos5l_decap_8
XFILLER_33_565 VPWR VGND sg13cmos5l_decap_4
XFILLER_20_215 VPWR VGND sg13cmos5l_fill_2
XFILLER_20_248 VPWR VGND sg13cmos5l_decap_4
X_1994_ _1999_/A _1876_/A _1886_/A _1993_/Y _3551_/Q _1987_/A VPWR VGND sg13cmos5l_a221oi_1
XFILLER_9_293 VPWR VGND sg13cmos5l_decap_8
X_2615_ _3440_/D _2615_/A _2615_/B VPWR VGND sg13cmos5l_and2_1
XFILLER_47_1025 VPWR VGND sg13cmos5l_decap_4
X_2546_ _2550_/A _2535_/Y _2540_/Y _2548_/B _2548_/A _2542_/Y VPWR VGND sg13cmos5l_a221oi_1
X_2477_ _2477_/Y _2470_/A _2470_/B _2463_/A VPWR VGND sg13cmos5l_o21ai_1
XFILLER_18_15 VPWR VGND sg13cmos5l_fill_1
XFILLER_29_838 VPWR VGND sg13cmos5l_fill_2
X_3525__195 _3525_/RESET_B VPWR VGND sg13cmos5l_tiehi
XFILLER_37_882 VPWR VGND sg13cmos5l_fill_2
X_3029_ _3066_/A _3533_/Q _3532_/Q VPWR VGND sg13cmos5l_xnor2_1
XFILLER_24_543 VPWR VGND sg13cmos5l_decap_8
Xclkload2 clkload2/Y clkload2/A VPWR VGND sg13cmos5l_inv_1
X_3317__363 _3317_/RESET_B VPWR VGND sg13cmos5l_tiehi
XFILLER_4_959 VPWR VGND sg13cmos5l_decap_8
XFILLER_3_469 VPWR VGND sg13cmos5l_decap_4
XFILLER_47_613 VPWR VGND sg13cmos5l_decap_8
XFILLER_46_167 VPWR VGND sg13cmos5l_fill_2
XFILLER_19_359 VPWR VGND sg13cmos5l_decap_8
XFILLER_43_830 VPWR VGND sg13cmos5l_fill_1
XFILLER_15_554 VPWR VGND sg13cmos5l_decap_8
XFILLER_43_874 VPWR VGND sg13cmos5l_decap_8
XFILLER_42_384 VPWR VGND sg13cmos5l_decap_8
XFILLER_30_535 VPWR VGND sg13cmos5l_decap_8
XFILLER_24_91 VPWR VGND sg13cmos5l_fill_2
X_3515__353 _3515_/RESET_B VPWR VGND sg13cmos5l_tiehi
Xhold709 _1828_/A _3506_/Q VPWR VGND sg13cmos5l_dlygate4sd3_1
XFILLER_6_263 VPWR VGND sg13cmos5l_decap_8
X_2400_ _2400_/Y _3413_/Q _3409_/Q VPWR VGND sg13cmos5l_nor2b_1
X_3380_ _3380_/Q _3408_/CLK _3380_/D _3380_/RESET_B VPWR VGND sg13cmos5l_dfrbpq_1
X_2331_ _2333_/B _2350_/A _2349_/B VPWR VGND sg13cmos5l_nor2_1
X_2262_ _3375_/D _2262_/A _2264_/B VPWR VGND sg13cmos5l_and2_1
XFILLER_38_613 VPWR VGND sg13cmos5l_decap_8
X_2193_ _2199_/B _3382_/Q _2373_/C VPWR VGND sg13cmos5l_xnor2_1
XFILLER_26_808 VPWR VGND sg13cmos5l_decap_8
XFILLER_46_690 VPWR VGND sg13cmos5l_decap_4
XFILLER_18_381 VPWR VGND sg13cmos5l_decap_8
XFILLER_34_885 VPWR VGND sg13cmos5l_decap_8
XFILLER_33_384 VPWR VGND sg13cmos5l_decap_8
XFILLER_21_568 VPWR VGND sg13cmos5l_decap_8
X_1977_ _1977_/Y _1801_/Y _3027_/A hold549/X VPWR VGND sg13cmos5l_a21oi_1
XFILLER_20_38 VPWR VGND sg13cmos5l_decap_4
XFILLER_1_907 VPWR VGND sg13cmos5l_decap_8
XFILLER_0_406 VPWR VGND sg13cmos5l_decap_8
X_2529_ _2535_/A _2529_/A _2538_/B _2529_/C VPWR VGND sg13cmos5l_nand3_1
XFILLER_29_36 VPWR VGND sg13cmos5l_decap_4
XFILLER_28_145 VPWR VGND sg13cmos5l_decap_8
XFILLER_28_156 VPWR VGND sg13cmos5l_fill_1
XFILLER_44_627 VPWR VGND sg13cmos5l_fill_2
XFILLER_43_159 VPWR VGND sg13cmos5l_decap_8
XFILLER_25_841 VPWR VGND sg13cmos5l_decap_8
XFILLER_40_811 VPWR VGND sg13cmos5l_decap_8
XFILLER_40_844 VPWR VGND sg13cmos5l_decap_8
XFILLER_12_513 VPWR VGND sg13cmos5l_decap_8
XFILLER_12_546 VPWR VGND sg13cmos5l_decap_8
XFILLER_40_888 VPWR VGND sg13cmos5l_decap_8
XFILLER_6_18 VPWR VGND sg13cmos5l_decap_4
XFILLER_4_712 VPWR VGND sg13cmos5l_fill_1
XFILLER_3_222 VPWR VGND sg13cmos5l_decap_8
XFILLER_10_71 VPWR VGND sg13cmos5l_decap_8
XFILLER_3_266 VPWR VGND sg13cmos5l_decap_4
XFILLER_48_922 VPWR VGND sg13cmos5l_decap_8
XFILLER_0_973 VPWR VGND sg13cmos5l_decap_8
XFILLER_19_80 VPWR VGND sg13cmos5l_fill_2
XFILLER_48_999 VPWR VGND sg13cmos5l_decap_8
XFILLER_47_487 VPWR VGND sg13cmos5l_decap_8
XFILLER_35_616 VPWR VGND sg13cmos5l_decap_4
XFILLER_16_863 VPWR VGND sg13cmos5l_decap_4
XFILLER_16_885 VPWR VGND sg13cmos5l_decap_8
X_2880_ _2881_/B _2878_/Y _2880_/B VPWR VGND sg13cmos5l_nand2b_1
X_1900_ _3549_/D _3547_/D _3548_/D _3546_/D VPWR VGND sg13cmos5l_or3_1
XFILLER_31_833 VPWR VGND sg13cmos5l_decap_8
X_1831_ _3125_/A _2867_/A VPWR VGND sg13cmos5l_inv_1
XFILLER_30_332 VPWR VGND sg13cmos5l_fill_1
XFILLER_31_888 VPWR VGND sg13cmos5l_decap_8
Xhold506 hold506/X _3277_/Q VPWR VGND sg13cmos5l_dlygate4sd3_1
X_3501_ _3501_/Q _3504_/CLK _3501_/D _3501_/RESET_B VPWR VGND sg13cmos5l_dfrbpq_1
Xhold517 hold517/X _3286_/Q VPWR VGND sg13cmos5l_dlygate4sd3_1
X_3432_ _3432_/Q _3444_/CLK _3432_/D _3432_/RESET_B VPWR VGND sg13cmos5l_dfrbpq_1
Xhold528 hold528/X _3267_/Q VPWR VGND sg13cmos5l_dlygate4sd3_1
Xhold539 _2082_/A _3322_/Q VPWR VGND sg13cmos5l_dlygate4sd3_1
X_3363_ _3363_/Q _3409_/CLK _3363_/D _3363_/RESET_B VPWR VGND sg13cmos5l_dfrbpq_1
X_2314_ _2350_/A _3387_/Q _2314_/B VPWR VGND sg13cmos5l_xor2_1
X_3294_ _3294_/Q _3539_/CLK _3294_/D _3294_/RESET_B VPWR VGND sg13cmos5l_dfrbpq_1
XFILLER_39_933 VPWR VGND sg13cmos5l_decap_8
XFILLER_38_421 VPWR VGND sg13cmos5l_decap_8
X_2245_ _2248_/S _3367_/Q _2245_/B VPWR VGND sg13cmos5l_nor2_1
X_2176_ _3353_/D _2176_/A _2176_/B _2176_/C VPWR VGND sg13cmos5l_nor3_1
XFILLER_41_619 VPWR VGND sg13cmos5l_decap_4
XFILLER_34_671 VPWR VGND sg13cmos5l_decap_4
XFILLER_40_129 VPWR VGND sg13cmos5l_fill_2
XFILLER_22_833 VPWR VGND sg13cmos5l_decap_8
XFILLER_31_48 VPWR VGND sg13cmos5l_decap_8
Xoutput15 uo_out[1] _3294_/Q VPWR VGND sg13cmos5l_buf_1
X_3314__366 _3314_/RESET_B VPWR VGND sg13cmos5l_tiehi
XFILLER_1_704 VPWR VGND sg13cmos5l_decap_8
XFILLER_0_236 VPWR VGND sg13cmos5l_decap_8
XFILLER_49_708 VPWR VGND sg13cmos5l_decap_8
XFILLER_0_258 VPWR VGND sg13cmos5l_decap_8
XFILLER_5_1022 VPWR VGND sg13cmos5l_decap_8
XFILLER_29_432 VPWR VGND sg13cmos5l_decap_8
XFILLER_45_914 VPWR VGND sg13cmos5l_decap_8
XFILLER_44_413 VPWR VGND sg13cmos5l_fill_1
XFILLER_44_435 VPWR VGND sg13cmos5l_decap_8
XFILLER_16_115 VPWR VGND sg13cmos5l_fill_2
XFILLER_25_671 VPWR VGND sg13cmos5l_decap_8
XFILLER_24_192 VPWR VGND sg13cmos5l_decap_8
XFILLER_9_837 VPWR VGND sg13cmos5l_decap_8
XFILLER_12_365 VPWR VGND sg13cmos5l_decap_8
XFILLER_4_575 VPWR VGND sg13cmos5l_decap_8
XFILLER_0_770 VPWR VGND sg13cmos5l_decap_8
X_2030_ _2031_/B _2030_/A _2026_/Y VPWR VGND sg13cmos5l_nor2b_1
XFILLER_36_903 VPWR VGND sg13cmos5l_decap_8
XFILLER_48_796 VPWR VGND sg13cmos5l_decap_8
XFILLER_47_295 VPWR VGND sg13cmos5l_fill_1
XFILLER_35_424 VPWR VGND sg13cmos5l_decap_8
XFILLER_35_446 VPWR VGND sg13cmos5l_decap_8
XFILLER_44_980 VPWR VGND sg13cmos5l_decap_8
X_2932_ _2947_/A _2931_/C _2930_/Y _2931_/Y VPWR VGND sg13cmos5l_o21ai_1
XFILLER_15_170 VPWR VGND sg13cmos5l_decap_8
X_2863_ _2863_/X _3481_/Q _2863_/B VPWR VGND sg13cmos5l_xor2_1
XFILLER_31_685 VPWR VGND sg13cmos5l_decap_8
XFILLER_31_696 VPWR VGND sg13cmos5l_fill_1
X_1814_ _2399_/B _2240_/A VPWR VGND sg13cmos5l_inv_1
X_2794_ _2794_/Y _2794_/A _2794_/B VPWR VGND sg13cmos5l_nor2_1
XFILLER_7_72 VPWR VGND sg13cmos5l_decap_8
XFILLER_11_1027 VPWR VGND sg13cmos5l_fill_2
X_3415_ _3415_/Q _3453_/CLK _3415_/D _3415_/RESET_B VPWR VGND sg13cmos5l_dfrbpq_1
X_3346_ _3346_/Q _3378_/CLK _3346_/D _3346_/RESET_B VPWR VGND sg13cmos5l_dfrbpq_1
X_3277_ _3277_/Q clkload8/A _3277_/D _3277_/RESET_B VPWR VGND sg13cmos5l_dfrbpq_1
XFILLER_39_741 VPWR VGND sg13cmos5l_decap_8
X_2228_ _2228_/Y _2431_/A _3340_/Q VPWR VGND sg13cmos5l_nand2_1
X_2159_ _2159_/Y _2164_/B _2166_/A _2159_/C VPWR VGND sg13cmos5l_nor3_1
XFILLER_27_958 VPWR VGND sg13cmos5l_decap_8
XFILLER_42_917 VPWR VGND sg13cmos5l_decap_8
XFILLER_41_427 VPWR VGND sg13cmos5l_decap_8
XFILLER_13_118 VPWR VGND sg13cmos5l_fill_2
XFILLER_6_818 VPWR VGND sg13cmos5l_decap_8
XFILLER_5_317 VPWR VGND sg13cmos5l_decap_8
XFILLER_45_700 VPWR VGND sg13cmos5l_fill_1
XFILLER_18_925 VPWR VGND sg13cmos5l_decap_8
XFILLER_45_744 VPWR VGND sg13cmos5l_decap_8
XFILLER_44_265 VPWR VGND sg13cmos5l_decap_8
XFILLER_44_287 VPWR VGND sg13cmos5l_decap_8
XFILLER_44_276 VPWR VGND sg13cmos5l_fill_1
XFILLER_41_961 VPWR VGND sg13cmos5l_decap_8
XFILLER_8_100 VPWR VGND sg13cmos5l_decap_4
XFILLER_9_656 VPWR VGND sg13cmos5l_decap_8
XFILLER_8_155 VPWR VGND sg13cmos5l_fill_1
XFILLER_5_840 VPWR VGND sg13cmos5l_decap_8
XFILLER_4_350 VPWR VGND sg13cmos5l_decap_8
XFILLER_4_372 VPWR VGND sg13cmos5l_decap_8
X_3200_ _3201_/C _3200_/A _3200_/B _3200_/C VPWR VGND sg13cmos5l_and3_1
X_3131_ _3200_/A _3526_/Q _3143_/B VPWR VGND sg13cmos5l_nand2_1
XFILLER_48_571 VPWR VGND sg13cmos5l_decap_4
X_3062_ _3510_/D _3125_/B _3062_/B VPWR VGND sg13cmos5l_nor2_1
X_3523__260 _3523_/RESET_B VPWR VGND sg13cmos5l_tiehi
X_2013_ _2013_/Y _3257_/A _2013_/B _2013_/C VPWR VGND sg13cmos5l_nor3_1
XFILLER_36_777 VPWR VGND sg13cmos5l_fill_1
XFILLER_35_243 VPWR VGND sg13cmos5l_decap_8
XFILLER_23_438 VPWR VGND sg13cmos5l_fill_2
XFILLER_35_298 VPWR VGND sg13cmos5l_fill_2
Xclkbuf_leaf_15_clk _3453_/CLK clkbuf_2_2__f_clk/X VPWR VGND sg13cmos5l_buf_8
XFILLER_32_950 VPWR VGND sg13cmos5l_decap_8
X_2915_ _3485_/D _2971_/B _3005_/A VPWR VGND sg13cmos5l_nor2_1
X_2846_ _2846_/Y _3543_/D _3114_/B VPWR VGND sg13cmos5l_nor2_1
XFILLER_12_39 VPWR VGND sg13cmos5l_decap_8
X_2777_ _2777_/Y hold484/X _3117_/A2 _2608_/A VPWR VGND sg13cmos5l_o21ai_1
X_3329_ _3329_/Q _3355_/CLK _3329_/D _3329_/RESET_B VPWR VGND sg13cmos5l_dfrbpq_1
XFILLER_26_265 VPWR VGND sg13cmos5l_decap_4
XFILLER_14_449 VPWR VGND sg13cmos5l_decap_8
XFILLER_23_961 VPWR VGND sg13cmos5l_decap_8
XFILLER_10_600 VPWR VGND sg13cmos5l_fill_1
XFILLER_10_644 VPWR VGND sg13cmos5l_decap_8
XFILLER_10_655 VPWR VGND sg13cmos5l_fill_1
XFILLER_2_854 VPWR VGND sg13cmos5l_decap_8
XFILLER_49_313 VPWR VGND sg13cmos5l_decap_8
XFILLER_49_346 VPWR VGND sg13cmos5l_decap_8
XFILLER_37_519 VPWR VGND sg13cmos5l_decap_8
XFILLER_18_700 VPWR VGND sg13cmos5l_decap_8
XFILLER_18_711 VPWR VGND sg13cmos5l_fill_2
XFILLER_18_755 VPWR VGND sg13cmos5l_decap_8
XFILLER_33_736 VPWR VGND sg13cmos5l_fill_1
XFILLER_32_235 VPWR VGND sg13cmos5l_fill_2
XFILLER_14_972 VPWR VGND sg13cmos5l_decap_8
XFILLER_41_780 VPWR VGND sg13cmos5l_decap_8
X_2700_ _2700_/Y _2968_/A _2708_/B VPWR VGND sg13cmos5l_nand2_1
X_2631_ _2646_/A _2648_/A VPWR VGND sg13cmos5l_inv_1
X_2562_ _2562_/Y _2528_/Y _2556_/B _2557_/B _2557_/C VPWR VGND sg13cmos5l_a22oi_1
XFILLER_4_180 VPWR VGND sg13cmos5l_fill_1
X_2493_ _2494_/B _3442_/Q _3443_/Q _3444_/Q VPWR VGND sg13cmos5l_o21ai_1
Xclkbuf_leaf_4_clk clkload7/A clkload0/A VPWR VGND sg13cmos5l_buf_8
X_3114_ _3522_/D _3114_/A _3114_/B VPWR VGND sg13cmos5l_and2_1
X_3045_ _3045_/Y _3513_/Q _3045_/B VPWR VGND sg13cmos5l_xnor2_1
XFILLER_23_202 VPWR VGND sg13cmos5l_fill_2
XFILLER_23_246 VPWR VGND sg13cmos5l_decap_8
X_2829_ _2830_/B _3471_/Q _2829_/B VPWR VGND sg13cmos5l_xor2_1
XFILLER_3_8 VPWR VGND sg13cmos5l_decap_4
XFILLER_27_585 VPWR VGND sg13cmos5l_fill_2
XFILLER_42_555 VPWR VGND sg13cmos5l_decap_8
XFILLER_9_18 VPWR VGND sg13cmos5l_decap_8
XFILLER_14_235 VPWR VGND sg13cmos5l_decap_4
XFILLER_15_769 VPWR VGND sg13cmos5l_decap_8
XFILLER_14_257 VPWR VGND sg13cmos5l_fill_2
XFILLER_14_268 VPWR VGND sg13cmos5l_decap_8
X_3357__314 _3357_/RESET_B VPWR VGND sg13cmos5l_tiehi
Xfanout61 _3028_/B _3114_/A VPWR VGND sg13cmos5l_buf_1
Xfanout50 _2063_/A _3552_/Q VPWR VGND sg13cmos5l_buf_1
Xfanout72 _2610_/A fanout74/X VPWR VGND sg13cmos5l_buf_1
XFILLER_7_913 VPWR VGND sg13cmos5l_decap_8
XFILLER_11_964 VPWR VGND sg13cmos5l_decap_8
XFILLER_22_290 VPWR VGND sg13cmos5l_fill_2
XFILLER_31_1008 VPWR VGND sg13cmos5l_decap_8
XFILLER_6_412 VPWR VGND sg13cmos5l_decap_8
XFILLER_10_463 VPWR VGND sg13cmos5l_fill_2
XFILLER_13_82 VPWR VGND sg13cmos5l_fill_2
XFILLER_6_456 VPWR VGND sg13cmos5l_decap_8
X_3364__307 _3364_/RESET_B VPWR VGND sg13cmos5l_tiehi
XFILLER_37_338 VPWR VGND sg13cmos5l_decap_8
XFILLER_18_574 VPWR VGND sg13cmos5l_decap_8
XFILLER_45_393 VPWR VGND sg13cmos5l_decap_4
XFILLER_21_706 VPWR VGND sg13cmos5l_decap_8
XFILLER_21_717 VPWR VGND sg13cmos5l_fill_1
XFILLER_21_728 VPWR VGND sg13cmos5l_fill_1
X_1993_ _1993_/Y _1996_/B _1993_/B VPWR VGND sg13cmos5l_nand2_1
X_2614_ _3439_/D _2614_/A _2615_/B VPWR VGND sg13cmos5l_and2_1
XFILLER_47_1004 VPWR VGND sg13cmos5l_decap_8
X_2545_ _2545_/Y _2349_/A _2537_/X _2548_/B _2349_/B VPWR VGND sg13cmos5l_a22oi_1
X_2476_ _3410_/D _2479_/A _2476_/B _2476_/C VPWR VGND sg13cmos5l_nor3_1
XFILLER_29_806 VPWR VGND sg13cmos5l_decap_8
XFILLER_29_817 VPWR VGND sg13cmos5l_fill_1
XFILLER_18_49 VPWR VGND sg13cmos5l_decap_8
XFILLER_37_861 VPWR VGND sg13cmos5l_decap_8
X_3028_ _3028_/Y _3027_/A _3028_/B VPWR VGND sg13cmos5l_nand2b_1
X_3456__202 _3456_/RESET_B VPWR VGND sg13cmos5l_tiehi
XFILLER_12_728 VPWR VGND sg13cmos5l_decap_8
XFILLER_24_566 VPWR VGND sg13cmos5l_decap_4
XFILLER_7_209 VPWR VGND sg13cmos5l_decap_8
Xclkload3 clkload3/Y clkload3/A VPWR VGND sg13cmos5l_inv_1
XFILLER_4_938 VPWR VGND sg13cmos5l_decap_8
XFILLER_3_448 VPWR VGND sg13cmos5l_decap_8
XFILLER_47_603 VPWR VGND sg13cmos5l_decap_4
X_3508__372 _3508_/RESET_B VPWR VGND sg13cmos5l_tiehi
XFILLER_28_883 VPWR VGND sg13cmos5l_fill_2
XFILLER_27_393 VPWR VGND sg13cmos5l_decap_8
XFILLER_42_363 VPWR VGND sg13cmos5l_decap_8
XFILLER_30_514 VPWR VGND sg13cmos5l_decap_8
XFILLER_11_761 VPWR VGND sg13cmos5l_decap_4
XFILLER_24_70 VPWR VGND sg13cmos5l_decap_8
XFILLER_6_220 VPWR VGND sg13cmos5l_decap_4
XFILLER_3_982 VPWR VGND sg13cmos5l_decap_8
X_2330_ _2548_/A _3413_/Q _2330_/B VPWR VGND sg13cmos5l_xnor2_1
XFILLER_2_481 VPWR VGND sg13cmos5l_decap_8
X_2261_ _3374_/D _2610_/A _2261_/B VPWR VGND sg13cmos5l_and2_1
X_2192_ _2364_/A _2432_/A _2373_/C VPWR VGND sg13cmos5l_xnor2_1
XFILLER_37_113 VPWR VGND sg13cmos5l_fill_1
XFILLER_1_96 VPWR VGND sg13cmos5l_decap_8
XFILLER_19_883 VPWR VGND sg13cmos5l_fill_1
XFILLER_45_190 VPWR VGND sg13cmos5l_decap_4
XFILLER_21_547 VPWR VGND sg13cmos5l_decap_8
XFILLER_14_1014 VPWR VGND sg13cmos5l_decap_8
X_1976_ _1976_/Y _3027_/A _1951_/A _3028_/B VPWR VGND sg13cmos5l_o21ai_1
X_2528_ _2528_/Y _2538_/B _2529_/C VPWR VGND sg13cmos5l_nand2_1
X_2459_ _2459_/X _2459_/A _2459_/B VPWR VGND sg13cmos5l_xor2_1
X_3347__324 _3347_/RESET_B VPWR VGND sg13cmos5l_tiehi
XFILLER_21_1018 VPWR VGND sg13cmos5l_decap_8
XFILLER_28_113 VPWR VGND sg13cmos5l_fill_2
XFILLER_29_625 VPWR VGND sg13cmos5l_fill_2
XFILLER_44_606 VPWR VGND sg13cmos5l_decap_8
XFILLER_28_124 VPWR VGND sg13cmos5l_decap_8
XFILLER_29_658 VPWR VGND sg13cmos5l_fill_1
XFILLER_29_669 VPWR VGND sg13cmos5l_fill_1
XFILLER_25_897 VPWR VGND sg13cmos5l_decap_8
XFILLER_8_518 VPWR VGND sg13cmos5l_decap_8
XFILLER_8_529 VPWR VGND sg13cmos5l_fill_1
X_3354__317 _3354_/RESET_B VPWR VGND sg13cmos5l_tiehi
XFILLER_3_245 VPWR VGND sg13cmos5l_decap_8
XFILLER_48_901 VPWR VGND sg13cmos5l_decap_8
XFILLER_0_952 VPWR VGND sg13cmos5l_decap_8
XFILLER_47_422 VPWR VGND sg13cmos5l_decap_8
XFILLER_48_978 VPWR VGND sg13cmos5l_decap_8
XFILLER_19_124 VPWR VGND sg13cmos5l_decap_8
XFILLER_47_466 VPWR VGND sg13cmos5l_decap_8
XFILLER_35_639 VPWR VGND sg13cmos5l_decap_4
XFILLER_16_842 VPWR VGND sg13cmos5l_decap_8
XFILLER_43_672 VPWR VGND sg13cmos5l_fill_2
XFILLER_37_1014 VPWR VGND sg13cmos5l_decap_8
XFILLER_15_363 VPWR VGND sg13cmos5l_decap_8
X_3398__266 _3398_/RESET_B VPWR VGND sg13cmos5l_tiehi
XFILLER_35_80 VPWR VGND sg13cmos5l_fill_1
X_1830_ _3124_/A _1830_/A VPWR VGND sg13cmos5l_inv_1
XFILLER_30_377 VPWR VGND sg13cmos5l_decap_8
X_3500_ _3500_/Q _3504_/CLK _3500_/D _3500_/RESET_B VPWR VGND sg13cmos5l_dfrbpq_1
Xhold507 hold507/X _3278_/Q VPWR VGND sg13cmos5l_dlygate4sd3_1
Xhold518 hold518/X _3276_/Q VPWR VGND sg13cmos5l_dlygate4sd3_1
Xhold529 hold529/X _3268_/Q VPWR VGND sg13cmos5l_dlygate4sd3_1
XFILLER_7_595 VPWR VGND sg13cmos5l_decap_8
X_3431_ _3431_/Q _3463_/CLK _3431_/D _3431_/RESET_B VPWR VGND sg13cmos5l_dfrbpq_1
X_3362_ _3362_/Q _3409_/CLK _3362_/D _3362_/RESET_B VPWR VGND sg13cmos5l_dfrbpq_1
X_2313_ _2314_/B _3385_/Q _3386_/Q _3383_/Q _3384_/Q VPWR VGND sg13cmos5l_nor4_1
X_3293_ _3293_/Q _3539_/CLK _3293_/D _3293_/RESET_B VPWR VGND sg13cmos5l_dfrbpq_1
X_3446__212 _3446_/RESET_B VPWR VGND sg13cmos5l_tiehi
X_2244_ _2245_/B _2250_/B _2241_/Y _2243_/Y VPWR VGND sg13cmos5l_o21ai_1
X_2175_ _2176_/C _2175_/A _2174_/A VPWR VGND sg13cmos5l_nor2b_1
XFILLER_38_444 VPWR VGND sg13cmos5l_decap_8
XFILLER_39_989 VPWR VGND sg13cmos5l_decap_8
XFILLER_38_488 VPWR VGND sg13cmos5l_fill_2
XFILLER_26_617 VPWR VGND sg13cmos5l_decap_8
XFILLER_25_127 VPWR VGND sg13cmos5l_fill_1
XFILLER_25_138 VPWR VGND sg13cmos5l_decap_8
XFILLER_40_119 VPWR VGND sg13cmos5l_fill_2
XFILLER_21_300 VPWR VGND sg13cmos5l_decap_8
XFILLER_33_171 VPWR VGND sg13cmos5l_decap_4
X_3453__205 _3453_/RESET_B VPWR VGND sg13cmos5l_tiehi
XFILLER_21_388 VPWR VGND sg13cmos5l_fill_1
X_1959_ _1959_/Y _3298_/Q _1951_/B _1943_/Y hold456/X VPWR VGND sg13cmos5l_a22oi_1
Xoutput16 uo_out[2] _3295_/Q VPWR VGND sg13cmos5l_buf_1
XFILLER_0_215 VPWR VGND sg13cmos5l_decap_8
XFILLER_0_204 VPWR VGND sg13cmos5l_decap_8
XFILLER_5_1001 VPWR VGND sg13cmos5l_decap_8
XFILLER_29_488 VPWR VGND sg13cmos5l_decap_8
XFILLER_29_499 VPWR VGND sg13cmos5l_fill_2
XFILLER_25_650 VPWR VGND sg13cmos5l_decap_8
XFILLER_25_661 VPWR VGND sg13cmos5l_fill_2
XFILLER_24_171 VPWR VGND sg13cmos5l_decap_8
XFILLER_9_816 VPWR VGND sg13cmos5l_decap_8
XFILLER_12_333 VPWR VGND sg13cmos5l_decap_8
XFILLER_40_664 VPWR VGND sg13cmos5l_fill_2
XFILLER_48_775 VPWR VGND sg13cmos5l_decap_8
XFILLER_47_274 VPWR VGND sg13cmos5l_decap_8
XFILLER_35_403 VPWR VGND sg13cmos5l_fill_1
XFILLER_36_959 VPWR VGND sg13cmos5l_decap_8
XFILLER_46_90 VPWR VGND sg13cmos5l_decap_4
X_2931_ _2931_/Y _3506_/Q _3125_/A _2931_/C VPWR VGND sg13cmos5l_nand3_1
Xclkbuf_0_clk clkbuf_0_clk/X clk VPWR VGND sg13cmos5l_buf_8
X_2862_ _2870_/B _3481_/Q _2863_/B VPWR VGND sg13cmos5l_nor2_1
X_3552__126 _3552_/RESET_B VPWR VGND sg13cmos5l_tiehi
XFILLER_30_152 VPWR VGND sg13cmos5l_decap_8
XFILLER_30_163 VPWR VGND sg13cmos5l_fill_2
XFILLER_31_664 VPWR VGND sg13cmos5l_decap_8
X_2793_ _2793_/Y _2702_/Y _2736_/B _2794_/B _2794_/A VPWR VGND sg13cmos5l_a22oi_1
XFILLER_30_174 VPWR VGND sg13cmos5l_decap_8
X_1813_ _2396_/B _1813_/A VPWR VGND sg13cmos5l_inv_1
XFILLER_7_51 VPWR VGND sg13cmos5l_fill_1
XFILLER_11_1006 VPWR VGND sg13cmos5l_decap_8
XFILLER_7_381 VPWR VGND sg13cmos5l_decap_8
XFILLER_7_95 VPWR VGND sg13cmos5l_decap_4
X_3414_ _3414_/Q _3442_/CLK _3414_/D _3414_/RESET_B VPWR VGND sg13cmos5l_dfrbpq_1
X_3345_ _3345_/Q _3355_/CLK _3345_/D _3345_/RESET_B VPWR VGND sg13cmos5l_dfrbpq_1
X_3276_ _3276_/Q clkload7/A _3276_/D _3276_/RESET_B VPWR VGND sg13cmos5l_dfrbpq_1
X_2227_ _3362_/D _2307_/A _2288_/B VPWR VGND sg13cmos5l_nor2_1
X_3524__228 _3524_/RESET_B VPWR VGND sg13cmos5l_tiehi
XFILLER_39_797 VPWR VGND sg13cmos5l_decap_8
XFILLER_27_937 VPWR VGND sg13cmos5l_decap_8
X_2158_ _2159_/C _2158_/A _2158_/B VPWR VGND sg13cmos5l_nor2_1
XFILLER_38_274 VPWR VGND sg13cmos5l_decap_8
X_2089_ _2176_/A _2252_/B _2179_/B VPWR VGND sg13cmos5l_nand2b_1
XFILLER_41_439 VPWR VGND sg13cmos5l_decap_8
XFILLER_21_185 VPWR VGND sg13cmos5l_fill_2
XFILLER_49_506 VPWR VGND sg13cmos5l_decap_8
X_3388__276 _3388_/RESET_B VPWR VGND sg13cmos5l_tiehi
XFILLER_18_904 VPWR VGND sg13cmos5l_decap_8
XFILLER_29_252 VPWR VGND sg13cmos5l_fill_2
XFILLER_45_723 VPWR VGND sg13cmos5l_decap_8
XFILLER_17_458 VPWR VGND sg13cmos5l_decap_8
XFILLER_26_992 VPWR VGND sg13cmos5l_decap_8
XFILLER_41_940 VPWR VGND sg13cmos5l_decap_8
X_3395__269 _3395_/RESET_B VPWR VGND sg13cmos5l_tiehi
X_3436__222 _3436_/RESET_B VPWR VGND sg13cmos5l_tiehi
XFILLER_8_189 VPWR VGND sg13cmos5l_decap_4
XFILLER_5_896 VPWR VGND sg13cmos5l_decap_8
X_3130_ _3212_/B _3130_/A _3143_/B VPWR VGND sg13cmos5l_nor2_1
X_3061_ _3062_/B hold697/X _3060_/Y _3070_/A VPWR VGND sg13cmos5l_mux2_1
X_3443__215 _3443_/RESET_B VPWR VGND sg13cmos5l_tiehi
XFILLER_36_723 VPWR VGND sg13cmos5l_fill_1
X_2012_ _2012_/Y hold470/X _2014_/B _3311_/Q VPWR VGND sg13cmos5l_a21oi_1
XFILLER_17_981 VPWR VGND sg13cmos5l_decap_8
XFILLER_23_406 VPWR VGND sg13cmos5l_fill_2
XFILLER_23_428 VPWR VGND sg13cmos5l_fill_2
XFILLER_35_277 VPWR VGND sg13cmos5l_decap_8
X_2914_ _3005_/A _2705_/X _2904_/Y _2913_/Y VPWR VGND sg13cmos5l_a21oi_1
XFILLER_12_18 VPWR VGND sg13cmos5l_decap_8
X_2845_ _3476_/D _2845_/A _2845_/B VPWR VGND sg13cmos5l_nor2_1
X_3450__208 _3450_/RESET_B VPWR VGND sg13cmos5l_tiehi
XFILLER_12_29 VPWR VGND sg13cmos5l_fill_1
X_2776_ _3461_/D _2776_/A _2776_/B VPWR VGND sg13cmos5l_and2_1
X_3328_ _3328_/Q _3355_/CLK _3328_/D _3328_/RESET_B VPWR VGND sg13cmos5l_dfrbpq_1
XFILLER_27_712 VPWR VGND sg13cmos5l_decap_8
X_3259_ _3259_/Q clkload7/A _3259_/D _3259_/RESET_B VPWR VGND sg13cmos5l_dfrbpq_1
XFILLER_39_583 VPWR VGND sg13cmos5l_decap_4
XFILLER_2_1015 VPWR VGND sg13cmos5l_decap_8
XFILLER_26_222 VPWR VGND sg13cmos5l_decap_8
XFILLER_26_255 VPWR VGND sg13cmos5l_decap_4
XFILLER_27_778 VPWR VGND sg13cmos5l_fill_2
XFILLER_42_726 VPWR VGND sg13cmos5l_decap_8
XFILLER_14_406 VPWR VGND sg13cmos5l_decap_8
XFILLER_14_417 VPWR VGND sg13cmos5l_decap_4
XFILLER_23_940 VPWR VGND sg13cmos5l_decap_8
XFILLER_41_269 VPWR VGND sg13cmos5l_decap_8
XFILLER_22_494 VPWR VGND sg13cmos5l_decap_4
XFILLER_5_137 VPWR VGND sg13cmos5l_decap_8
XFILLER_5_159 VPWR VGND sg13cmos5l_decap_8
XFILLER_2_833 VPWR VGND sg13cmos5l_decap_8
Xhold690 hold690/X _2948_/Y VPWR VGND sg13cmos5l_dlygate4sd3_1
XFILLER_1_387 VPWR VGND sg13cmos5l_decap_8
XFILLER_49_369 VPWR VGND sg13cmos5l_decap_8
XFILLER_40_1021 VPWR VGND sg13cmos5l_decap_8
XFILLER_17_255 VPWR VGND sg13cmos5l_decap_4
XFILLER_14_951 VPWR VGND sg13cmos5l_decap_8
XFILLER_17_299 VPWR VGND sg13cmos5l_fill_2
XFILLER_33_748 VPWR VGND sg13cmos5l_decap_4
XFILLER_43_80 VPWR VGND sg13cmos5l_decap_4
XFILLER_13_494 VPWR VGND sg13cmos5l_decap_8
X_2630_ _2648_/A _2645_/A _2645_/B VPWR VGND sg13cmos5l_nand2_1
XFILLER_9_487 VPWR VGND sg13cmos5l_decap_8
X_2561_ _3420_/D _2673_/A _2561_/B VPWR VGND sg13cmos5l_nor2_1
XFILLER_5_660 VPWR VGND sg13cmos5l_decap_8
X_2492_ _2500_/B _3442_/Q _3443_/Q _3444_/Q VPWR VGND sg13cmos5l_nor3_1
XFILLER_4_85 VPWR VGND sg13cmos5l_decap_8
X_3367__113 _3367_/D VPWR VGND sg13cmos5l_tielo
XFILLER_4_96 VPWR VGND sg13cmos5l_fill_2
X_3113_ _3520_/D hold547/X _3112_/Y _3223_/A VPWR VGND sg13cmos5l_a21oi_1
XFILLER_28_509 VPWR VGND sg13cmos5l_decap_4
X_3044_ _3044_/X _3513_/Q _3045_/B VPWR VGND sg13cmos5l_xor2_1
XFILLER_36_553 VPWR VGND sg13cmos5l_fill_2
XFILLER_24_737 VPWR VGND sg13cmos5l_decap_8
XFILLER_17_1023 VPWR VGND sg13cmos5l_decap_4
XFILLER_23_28 VPWR VGND sg13cmos5l_decap_4
X_3378__286 _3378_/RESET_B VPWR VGND sg13cmos5l_tiehi
X_2828_ _2835_/A _2828_/A _2828_/B VPWR VGND sg13cmos5l_and2_1
XFILLER_20_987 VPWR VGND sg13cmos5l_decap_8
X_2759_ _2759_/Y _2968_/A _2759_/B VPWR VGND sg13cmos5l_nor2_1
XFILLER_2_129 VPWR VGND sg13cmos5l_decap_8
XFILLER_47_829 VPWR VGND sg13cmos5l_decap_8
XFILLER_48_69 VPWR VGND sg13cmos5l_fill_1
X_3385__279 _3385_/RESET_B VPWR VGND sg13cmos5l_tiehi
XFILLER_19_509 VPWR VGND sg13cmos5l_decap_8
XFILLER_39_380 VPWR VGND sg13cmos5l_decap_8
XFILLER_27_520 VPWR VGND sg13cmos5l_fill_1
XFILLER_15_726 VPWR VGND sg13cmos5l_decap_8
XFILLER_42_534 VPWR VGND sg13cmos5l_decap_8
Xfanout40 _2839_/A _2845_/A VPWR VGND sg13cmos5l_buf_1
XFILLER_11_943 VPWR VGND sg13cmos5l_decap_8
Xfanout62 _3114_/A fanout74/X VPWR VGND sg13cmos5l_buf_1
Xfanout73 _2966_/A fanout74/X VPWR VGND sg13cmos5l_buf_1
Xfanout51 _1876_/A hold676/X VPWR VGND sg13cmos5l_buf_1
XFILLER_13_50 VPWR VGND sg13cmos5l_fill_1
X_3433__225 _3433_/RESET_B VPWR VGND sg13cmos5l_tiehi
XFILLER_7_969 VPWR VGND sg13cmos5l_decap_8
XFILLER_6_479 VPWR VGND sg13cmos5l_fill_1
XFILLER_2_630 VPWR VGND sg13cmos5l_decap_8
XFILLER_49_111 VPWR VGND sg13cmos5l_decap_8
XFILLER_1_162 VPWR VGND sg13cmos5l_decap_4
XFILLER_49_166 VPWR VGND sg13cmos5l_decap_8
XFILLER_49_188 VPWR VGND sg13cmos5l_decap_8
XFILLER_18_553 VPWR VGND sg13cmos5l_decap_8
X_3440__218 _3440_/RESET_B VPWR VGND sg13cmos5l_tiehi
XFILLER_45_372 VPWR VGND sg13cmos5l_decap_8
XFILLER_33_501 VPWR VGND sg13cmos5l_decap_8
XFILLER_33_512 VPWR VGND sg13cmos5l_fill_2
X_3520__297 _3520_/RESET_B VPWR VGND sg13cmos5l_tiehi
XFILLER_14_792 VPWR VGND sg13cmos5l_fill_2
X_1992_ _1993_/B _3546_/Q _1988_/B _1876_/A VPWR VGND sg13cmos5l_a21oi_1
Xclkload10 clkload10/X _3355_/CLK VPWR VGND sg13cmos5l_buf_8
X_2613_ _2613_/Y _2613_/A _2667_/A VPWR VGND sg13cmos5l_nor2_1
X_2544_ _2556_/B _3392_/Q _2544_/B VPWR VGND sg13cmos5l_xnor2_1
XFILLER_48_0 VPWR VGND sg13cmos5l_decap_8
X_2475_ _2476_/C _2475_/A _2474_/A VPWR VGND sg13cmos5l_nor2b_1
XFILLER_28_328 VPWR VGND sg13cmos5l_fill_2
XFILLER_28_339 VPWR VGND sg13cmos5l_decap_8
XFILLER_37_895 VPWR VGND sg13cmos5l_decap_8
X_3027_ _3121_/B _3027_/A _3239_/A VPWR VGND sg13cmos5l_nor2_1
XFILLER_24_523 VPWR VGND sg13cmos5l_decap_8
XFILLER_36_394 VPWR VGND sg13cmos5l_decap_4
XFILLER_34_49 VPWR VGND sg13cmos5l_decap_8
XFILLER_11_217 VPWR VGND sg13cmos5l_decap_8
XFILLER_11_239 VPWR VGND sg13cmos5l_decap_4
Xclkload4 clkload4/Y clkload4/A VPWR VGND sg13cmos5l_inv_4
XFILLER_4_917 VPWR VGND sg13cmos5l_decap_8
XFILLER_3_427 VPWR VGND sg13cmos5l_decap_8
XFILLER_46_169 VPWR VGND sg13cmos5l_fill_1
XFILLER_43_821 VPWR VGND sg13cmos5l_decap_8
XFILLER_28_862 VPWR VGND sg13cmos5l_decap_8
XFILLER_15_589 VPWR VGND sg13cmos5l_fill_2
XFILLER_11_740 VPWR VGND sg13cmos5l_decap_8
XFILLER_24_93 VPWR VGND sg13cmos5l_fill_1
XFILLER_10_261 VPWR VGND sg13cmos5l_decap_8
XFILLER_6_243 VPWR VGND sg13cmos5l_decap_8
XFILLER_3_961 VPWR VGND sg13cmos5l_decap_8
XFILLER_2_460 VPWR VGND sg13cmos5l_decap_8
X_2260_ _3373_/D _2427_/A _2260_/B VPWR VGND sg13cmos5l_and2_1
XFILLER_49_90 VPWR VGND sg13cmos5l_decap_8
X_2191_ _2369_/A _3382_/Q _2373_/C VPWR VGND sg13cmos5l_nor2_1
XFILLER_1_64 VPWR VGND sg13cmos5l_fill_1
XFILLER_34_854 VPWR VGND sg13cmos5l_decap_8
XFILLER_33_353 VPWR VGND sg13cmos5l_decap_4
XFILLER_21_526 VPWR VGND sg13cmos5l_fill_2
X_1975_ _1975_/Y _1802_/Y _3027_/A _1974_/Y VPWR VGND sg13cmos5l_a21oi_1
X_3533__400 _3533_/RESET_B VPWR VGND sg13cmos5l_tiehi
X_3375__289 _3375_/RESET_B VPWR VGND sg13cmos5l_tiehi
XFILLER_20_18 VPWR VGND sg13cmos5l_decap_4
X_2527_ _2529_/C _3389_/Q _3388_/Q _3390_/Q VPWR VGND sg13cmos5l_o21ai_1
X_2458_ _2475_/A _2380_/X _2457_/A _2457_/Y VPWR VGND sg13cmos5l_a21oi_1
XFILLER_29_49 VPWR VGND sg13cmos5l_decap_8
XFILLER_29_604 VPWR VGND sg13cmos5l_decap_8
X_2389_ _2389_/Y _2384_/Y _2386_/Y _2388_/Y VPWR VGND sg13cmos5l_o21ai_1
XFILLER_44_629 VPWR VGND sg13cmos5l_fill_1
XFILLER_37_670 VPWR VGND sg13cmos5l_decap_8
XFILLER_43_128 VPWR VGND sg13cmos5l_decap_8
XFILLER_24_331 VPWR VGND sg13cmos5l_fill_2
XFILLER_25_876 VPWR VGND sg13cmos5l_decap_8
XFILLER_10_62 VPWR VGND sg13cmos5l_decap_4
XFILLER_0_931 VPWR VGND sg13cmos5l_decap_8
XFILLER_47_412 VPWR VGND sg13cmos5l_fill_1
XFILLER_19_114 VPWR VGND sg13cmos5l_decap_4
XFILLER_48_957 VPWR VGND sg13cmos5l_decap_8
XFILLER_47_445 VPWR VGND sg13cmos5l_decap_8
XFILLER_19_93 VPWR VGND sg13cmos5l_decap_8
XFILLER_35_629 VPWR VGND sg13cmos5l_fill_1
XFILLER_15_320 VPWR VGND sg13cmos5l_decap_4
XFILLER_34_139 VPWR VGND sg13cmos5l_decap_8
XFILLER_15_342 VPWR VGND sg13cmos5l_decap_8
XFILLER_43_695 VPWR VGND sg13cmos5l_decap_8
XFILLER_42_150 VPWR VGND sg13cmos5l_fill_1
XFILLER_31_868 VPWR VGND sg13cmos5l_fill_2
XFILLER_7_530 VPWR VGND sg13cmos5l_decap_8
Xhold508 hold508/X _3262_/Q VPWR VGND sg13cmos5l_dlygate4sd3_1
XFILLER_7_574 VPWR VGND sg13cmos5l_decap_8
Xhold519 hold519/X _3524_/Q VPWR VGND sg13cmos5l_dlygate4sd3_1
X_3430_ _3430_/Q clkload3/A _3430_/D _3430_/RESET_B VPWR VGND sg13cmos5l_dfrbpq_1
X_3361_ _3361_/Q _3408_/CLK _3361_/D _3361_/RESET_B VPWR VGND sg13cmos5l_dfrbpq_1
XFILLER_44_1008 VPWR VGND sg13cmos5l_decap_8
X_2312_ _2324_/A _3385_/Q _3383_/Q _3384_/Q VPWR VGND sg13cmos5l_or3_1
X_3292_ _3292_/Q clkload7/A _3292_/D _3292_/RESET_B VPWR VGND sg13cmos5l_dfrbpq_1
X_2243_ _2243_/Y _2239_/Y _2240_/Y _2242_/Y VPWR VGND sg13cmos5l_o21ai_1
X_2174_ _2176_/B _2174_/A _2162_/C VPWR VGND sg13cmos5l_nor2b_1
XFILLER_39_968 VPWR VGND sg13cmos5l_decap_8
XFILLER_38_467 VPWR VGND sg13cmos5l_decap_8
XFILLER_47_990 VPWR VGND sg13cmos5l_decap_8
XFILLER_15_18 VPWR VGND sg13cmos5l_decap_8
XFILLER_34_640 VPWR VGND sg13cmos5l_fill_1
XFILLER_34_684 VPWR VGND sg13cmos5l_decap_8
XFILLER_21_323 VPWR VGND sg13cmos5l_fill_1
XFILLER_21_345 VPWR VGND sg13cmos5l_decap_8
XFILLER_22_857 VPWR VGND sg13cmos5l_decap_8
XFILLER_21_378 VPWR VGND sg13cmos5l_decap_4
X_1958_ _3297_/D _3239_/A _1958_/B VPWR VGND sg13cmos5l_nor2_1
X_1889_ _1889_/X _1883_/B _1986_/A _1995_/B VPWR VGND sg13cmos5l_a21o_1
Xoutput17 uo_out[3] _3296_/Q VPWR VGND sg13cmos5l_buf_1
XFILLER_1_739 VPWR VGND sg13cmos5l_decap_8
X_3360__311 _3360_/RESET_B VPWR VGND sg13cmos5l_tiehi
XFILLER_45_949 VPWR VGND sg13cmos5l_decap_8
XFILLER_12_301 VPWR VGND sg13cmos5l_decap_8
XFILLER_13_813 VPWR VGND sg13cmos5l_decap_8
XFILLER_24_150 VPWR VGND sg13cmos5l_fill_1
XFILLER_40_643 VPWR VGND sg13cmos5l_decap_8
XFILLER_13_846 VPWR VGND sg13cmos5l_decap_8
XFILLER_8_338 VPWR VGND sg13cmos5l_decap_8
XFILLER_21_61 VPWR VGND sg13cmos5l_decap_8
XFILLER_4_566 VPWR VGND sg13cmos5l_decap_4
XFILLER_48_754 VPWR VGND sg13cmos5l_decap_8
XFILLER_36_938 VPWR VGND sg13cmos5l_decap_8
X_2930_ _2930_/Y _2930_/A _2930_/B VPWR VGND sg13cmos5l_nand2_1
XFILLER_15_150 VPWR VGND sg13cmos5l_decap_4
X_2861_ _3166_/A _2868_/B _2861_/B VPWR VGND sg13cmos5l_nand2b_1
XFILLER_7_30 VPWR VGND sg13cmos5l_fill_2
X_2792_ _2792_/Y _2702_/Y _2736_/B _2791_/Y VPWR VGND sg13cmos5l_o21ai_1
X_1812_ _1812_/Y _1812_/A VPWR VGND sg13cmos5l_inv_1
XFILLER_8_883 VPWR VGND sg13cmos5l_decap_8
XFILLER_7_360 VPWR VGND sg13cmos5l_decap_8
X_3413_ _3413_/Q _3444_/CLK _3413_/D _3413_/RESET_B VPWR VGND sg13cmos5l_dfrbpq_1
Xheichips26_dna_sequencer_90 uo_out[6] VPWR VGND sg13cmos5l_tielo
X_3344_ _3344_/Q _3551_/CLK _3344_/D _3344_/RESET_B VPWR VGND sg13cmos5l_dfrbpq_1
X_3275_ _3275_/Q clkload7/A _3275_/D _3275_/RESET_B VPWR VGND sg13cmos5l_dfrbpq_1
X_2226_ _2288_/B _2226_/A _2226_/B VPWR VGND sg13cmos5l_nor2_1
XFILLER_39_776 VPWR VGND sg13cmos5l_decap_8
X_2157_ _2166_/A _2164_/B _2156_/Y _2153_/Y VPWR VGND sg13cmos5l_o21ai_1
X_2088_ _2147_/B _3543_/D _2252_/B VPWR VGND sg13cmos5l_nor2_1
XFILLER_35_993 VPWR VGND sg13cmos5l_decap_8
XFILLER_22_643 VPWR VGND sg13cmos5l_decap_4
XFILLER_34_492 VPWR VGND sg13cmos5l_fill_2
XFILLER_22_687 VPWR VGND sg13cmos5l_fill_2
XFILLER_10_849 VPWR VGND sg13cmos5l_decap_8
XFILLER_21_164 VPWR VGND sg13cmos5l_decap_8
XFILLER_27_1014 VPWR VGND sg13cmos5l_decap_8
XFILLER_29_231 VPWR VGND sg13cmos5l_decap_8
XFILLER_29_286 VPWR VGND sg13cmos5l_fill_2
XFILLER_45_779 VPWR VGND sg13cmos5l_decap_8
XFILLER_17_448 VPWR VGND sg13cmos5l_fill_1
XFILLER_26_971 VPWR VGND sg13cmos5l_decap_8
XFILLER_13_621 VPWR VGND sg13cmos5l_decap_8
XFILLER_16_94 VPWR VGND sg13cmos5l_decap_8
XFILLER_40_462 VPWR VGND sg13cmos5l_decap_4
XFILLER_34_1018 VPWR VGND sg13cmos5l_decap_8
XFILLER_41_996 VPWR VGND sg13cmos5l_decap_8
XFILLER_13_687 VPWR VGND sg13cmos5l_fill_2
XFILLER_8_146 VPWR VGND sg13cmos5l_decap_8
XFILLER_12_197 VPWR VGND sg13cmos5l_decap_8
XFILLER_5_875 VPWR VGND sg13cmos5l_decap_8
XFILLER_4_385 VPWR VGND sg13cmos5l_decap_8
XFILLER_4_396 VPWR VGND sg13cmos5l_fill_2
X_3060_ _3060_/Y _3087_/C _3069_/B VPWR VGND sg13cmos5l_nand2_1
X_2011_ _2013_/B _2014_/B _1868_/Y _2008_/A VPWR VGND sg13cmos5l_a21oi_1
XFILLER_36_768 VPWR VGND sg13cmos5l_decap_8
XFILLER_17_960 VPWR VGND sg13cmos5l_decap_8
XFILLER_24_919 VPWR VGND sg13cmos5l_decap_8
XFILLER_16_481 VPWR VGND sg13cmos5l_fill_1
X_2913_ _2913_/Y _2916_/A _2913_/B _2913_/C VPWR VGND sg13cmos5l_nor3_1
XFILLER_31_462 VPWR VGND sg13cmos5l_fill_1
XFILLER_32_985 VPWR VGND sg13cmos5l_decap_8
X_2844_ _2845_/B _2835_/A _2832_/Y _2844_/S VPWR VGND sg13cmos5l_mux2_1
X_2775_ _3459_/D _2763_/Y hold609/X _2675_/Y VPWR VGND sg13cmos5l_a21oi_1
X_3350__321 _3350_/RESET_B VPWR VGND sg13cmos5l_tiehi
X_3327_ _3327_/Q _3355_/CLK _3327_/D _3327_/RESET_B VPWR VGND sg13cmos5l_dfrbpq_1
XFILLER_39_562 VPWR VGND sg13cmos5l_decap_8
XFILLER_37_49 VPWR VGND sg13cmos5l_fill_2
X_3258_ _3258_/Y hold423/X _1962_/A _1871_/Y VPWR VGND sg13cmos5l_a21oi_1
X_2209_ _2209_/Y _2123_/B _3335_/Q VPWR VGND sg13cmos5l_nand2b_1
X_3189_ _3204_/B _3487_/Q _3160_/Y _2884_/C VPWR VGND sg13cmos5l_o21ai_1
XFILLER_26_201 VPWR VGND sg13cmos5l_decap_8
XFILLER_27_735 VPWR VGND sg13cmos5l_fill_2
XFILLER_42_705 VPWR VGND sg13cmos5l_decap_8
XFILLER_27_757 VPWR VGND sg13cmos5l_fill_1
XFILLER_42_738 VPWR VGND sg13cmos5l_fill_1
XFILLER_35_790 VPWR VGND sg13cmos5l_decap_8
XFILLER_22_462 VPWR VGND sg13cmos5l_fill_1
XFILLER_10_624 VPWR VGND sg13cmos5l_decap_8
XFILLER_22_473 VPWR VGND sg13cmos5l_decap_8
XFILLER_23_996 VPWR VGND sg13cmos5l_decap_8
X_3394__270 _3394_/RESET_B VPWR VGND sg13cmos5l_tiehi
XFILLER_6_639 VPWR VGND sg13cmos5l_fill_2
XFILLER_6_628 VPWR VGND sg13cmos5l_decap_8
XFILLER_2_812 VPWR VGND sg13cmos5l_decap_8
XFILLER_1_311 VPWR VGND sg13cmos5l_fill_2
Xhold680 _3490_/D _2954_/Y VPWR VGND sg13cmos5l_dlygate4sd3_1
XFILLER_2_889 VPWR VGND sg13cmos5l_decap_8
Xhold691 _3489_/D _2950_/Y VPWR VGND sg13cmos5l_dlygate4sd3_1
XFILLER_40_1000 VPWR VGND sg13cmos5l_decap_8
XFILLER_17_212 VPWR VGND sg13cmos5l_decap_8
XFILLER_45_554 VPWR VGND sg13cmos5l_decap_8
XFILLER_27_60 VPWR VGND sg13cmos5l_fill_2
Xclkbuf_2_0__f_clk clkbuf_leaf_2_clk/A clkbuf_0_clk/X VPWR VGND sg13cmos5l_buf_8
XFILLER_27_93 VPWR VGND sg13cmos5l_decap_8
XFILLER_33_727 VPWR VGND sg13cmos5l_decap_8
XFILLER_14_930 VPWR VGND sg13cmos5l_decap_8
XFILLER_32_237 VPWR VGND sg13cmos5l_fill_1
XFILLER_32_248 VPWR VGND sg13cmos5l_decap_8
XFILLER_41_760 VPWR VGND sg13cmos5l_fill_1
XFILLER_9_433 VPWR VGND sg13cmos5l_fill_1
XFILLER_13_473 VPWR VGND sg13cmos5l_decap_8
XFILLER_9_466 VPWR VGND sg13cmos5l_decap_8
X_2560_ _2560_/Y _2561_/B VPWR VGND sg13cmos5l_inv_1
X_2491_ _2491_/Y _2488_/Y _2489_/Y _2490_/Y _3442_/Q VPWR VGND sg13cmos5l_a22oi_1
XFILLER_4_193 VPWR VGND sg13cmos5l_decap_8
X_3112_ _3112_/Y _3112_/A _3112_/B VPWR VGND sg13cmos5l_nand2_1
X_3043_ _3051_/B _3513_/Q _3512_/Q _3510_/Q _3511_/Q VPWR VGND sg13cmos5l_nor4_1
XFILLER_24_716 VPWR VGND sg13cmos5l_decap_8
XFILLER_17_1002 VPWR VGND sg13cmos5l_decap_8
XFILLER_32_793 VPWR VGND sg13cmos5l_decap_4
XFILLER_20_966 VPWR VGND sg13cmos5l_decap_8
X_2827_ _2827_/Y _2819_/Y _2822_/X _2826_/Y VPWR VGND sg13cmos5l_o21ai_1
X_2758_ _2758_/Y _3428_/Q _2758_/B VPWR VGND sg13cmos5l_nor2_1
X_2689_ _2708_/A _2694_/B _2689_/B VPWR VGND sg13cmos5l_nand2b_1
XFILLER_24_1017 VPWR VGND sg13cmos5l_decap_8
XFILLER_47_808 VPWR VGND sg13cmos5l_decap_8
XFILLER_24_1028 VPWR VGND sg13cmos5l_fill_1
XFILLER_46_318 VPWR VGND sg13cmos5l_decap_4
XFILLER_27_554 VPWR VGND sg13cmos5l_decap_4
XFILLER_42_513 VPWR VGND sg13cmos5l_decap_8
XFILLER_15_705 VPWR VGND sg13cmos5l_decap_8
Xfanout30 _3143_/B _3129_/Y VPWR VGND sg13cmos5l_buf_1
XFILLER_30_719 VPWR VGND sg13cmos5l_decap_8
XFILLER_11_922 VPWR VGND sg13cmos5l_decap_8
Xfanout52 _1983_/A2 _3027_/A VPWR VGND sg13cmos5l_buf_1
Xfanout41 _2845_/A _2675_/Y VPWR VGND sg13cmos5l_buf_1
Xfanout63 _2018_/A _2009_/B1 VPWR VGND sg13cmos5l_buf_1
Xfanout74 fanout74/X input1/X VPWR VGND sg13cmos5l_buf_1
XFILLER_10_432 VPWR VGND sg13cmos5l_decap_8
XFILLER_10_443 VPWR VGND sg13cmos5l_fill_2
XFILLER_7_948 VPWR VGND sg13cmos5l_decap_8
XFILLER_10_465 VPWR VGND sg13cmos5l_fill_1
XFILLER_11_999 VPWR VGND sg13cmos5l_decap_8
XFILLER_13_62 VPWR VGND sg13cmos5l_fill_1
XFILLER_2_675 VPWR VGND sg13cmos5l_decap_8
XFILLER_1_185 VPWR VGND sg13cmos5l_decap_8
XFILLER_18_532 VPWR VGND sg13cmos5l_decap_8
XFILLER_46_885 VPWR VGND sg13cmos5l_decap_8
XFILLER_18_598 VPWR VGND sg13cmos5l_decap_4
XFILLER_33_535 VPWR VGND sg13cmos5l_decap_8
XFILLER_13_270 VPWR VGND sg13cmos5l_decap_4
XFILLER_14_771 VPWR VGND sg13cmos5l_decap_8
X_1991_ _2040_/A _3228_/A _1991_/B _1991_/C _1991_/D VPWR VGND sg13cmos5l_nand4_1
XFILLER_9_263 VPWR VGND sg13cmos5l_decap_8
Xclkload11 clkload11/Y _3444_/CLK VPWR VGND sg13cmos5l_inv_1
X_2612_ _3437_/D _2612_/A _2667_/A VPWR VGND sg13cmos5l_nor2_1
X_2543_ _2548_/B _3392_/Q _2544_/B VPWR VGND sg13cmos5l_xor2_1
X_2474_ _2476_/B _2474_/A _2456_/Y VPWR VGND sg13cmos5l_nor2b_1
X_3384__280 _3384_/RESET_B VPWR VGND sg13cmos5l_tiehi
X_3341__117 _3341_/D VPWR VGND sg13cmos5l_tielo
X_3026_ _3508_/D _3009_/Y _3017_/Y _3025_/Y VPWR VGND sg13cmos5l_a21oi_1
XFILLER_24_502 VPWR VGND sg13cmos5l_decap_8
XFILLER_36_351 VPWR VGND sg13cmos5l_decap_8
Xclkload5 clkload5/Y clkload5/A VPWR VGND sg13cmos5l_inv_1
XFILLER_32_590 VPWR VGND sg13cmos5l_decap_8
X_3391__273 _3391_/RESET_B VPWR VGND sg13cmos5l_tiehi
XFILLER_3_406 VPWR VGND sg13cmos5l_decap_4
XFILLER_1_7 VPWR VGND sg13cmos5l_decap_8
XFILLER_47_627 VPWR VGND sg13cmos5l_decap_8
XFILLER_28_841 VPWR VGND sg13cmos5l_decap_8
XFILLER_28_896 VPWR VGND sg13cmos5l_decap_8
XFILLER_43_888 VPWR VGND sg13cmos5l_decap_8
XFILLER_42_343 VPWR VGND sg13cmos5l_fill_2
XFILLER_42_332 VPWR VGND sg13cmos5l_decap_8
XFILLER_15_568 VPWR VGND sg13cmos5l_decap_8
XFILLER_30_505 VPWR VGND sg13cmos5l_fill_1
XFILLER_30_549 VPWR VGND sg13cmos5l_decap_8
XFILLER_7_712 VPWR VGND sg13cmos5l_decap_4
XFILLER_6_277 VPWR VGND sg13cmos5l_decap_8
XFILLER_3_940 VPWR VGND sg13cmos5l_decap_8
X_3548__132 _3548_/RESET_B VPWR VGND sg13cmos5l_tiehi
XFILLER_34_7 VPWR VGND sg13cmos5l_fill_1
X_2190_ _2203_/B _2430_/A _3382_/Q VPWR VGND sg13cmos5l_nor2_1
XFILLER_38_605 VPWR VGND sg13cmos5l_fill_2
XFILLER_38_638 VPWR VGND sg13cmos5l_decap_8
XFILLER_38_627 VPWR VGND sg13cmos5l_decap_8
XFILLER_1_21 VPWR VGND sg13cmos5l_decap_4
XFILLER_46_671 VPWR VGND sg13cmos5l_decap_8
XFILLER_19_874 VPWR VGND sg13cmos5l_decap_8
XFILLER_45_170 VPWR VGND sg13cmos5l_fill_2
XFILLER_18_395 VPWR VGND sg13cmos5l_decap_4
XFILLER_34_899 VPWR VGND sg13cmos5l_decap_8
X_1974_ _1974_/Y _3027_/A _3304_/Q _3028_/B VPWR VGND sg13cmos5l_o21ai_1
XFILLER_33_398 VPWR VGND sg13cmos5l_decap_8
X_2526_ _2538_/B _3390_/Q _3389_/Q _3388_/Q VPWR VGND sg13cmos5l_or3_1
X_2457_ _2457_/Y _2457_/A _2344_/B VPWR VGND sg13cmos5l_nor2b_1
X_2388_ _2388_/Y _3413_/Q _2388_/B VPWR VGND sg13cmos5l_nand2_1
XFILLER_45_16 VPWR VGND sg13cmos5l_decap_8
X_3009_ _3009_/Y _3009_/A _3009_/B VPWR VGND sg13cmos5l_nor2_1
XFILLER_25_855 VPWR VGND sg13cmos5l_decap_8
XFILLER_40_825 VPWR VGND sg13cmos5l_decap_4
XFILLER_12_527 VPWR VGND sg13cmos5l_fill_1
XFILLER_24_365 VPWR VGND sg13cmos5l_decap_8
XFILLER_40_858 VPWR VGND sg13cmos5l_fill_2
XFILLER_24_398 VPWR VGND sg13cmos5l_fill_1
XFILLER_10_41 VPWR VGND sg13cmos5l_decap_8
XFILLER_10_85 VPWR VGND sg13cmos5l_fill_2
XFILLER_0_910 VPWR VGND sg13cmos5l_decap_8
XFILLER_48_936 VPWR VGND sg13cmos5l_decap_8
XFILLER_0_987 VPWR VGND sg13cmos5l_decap_8
XFILLER_16_811 VPWR VGND sg13cmos5l_decap_8
XFILLER_43_652 VPWR VGND sg13cmos5l_fill_2
XFILLER_43_674 VPWR VGND sg13cmos5l_fill_1
XFILLER_16_899 VPWR VGND sg13cmos5l_decap_8
XFILLER_30_302 VPWR VGND sg13cmos5l_decap_8
XFILLER_15_398 VPWR VGND sg13cmos5l_decap_8
XFILLER_31_847 VPWR VGND sg13cmos5l_decap_8
XFILLER_7_553 VPWR VGND sg13cmos5l_decap_8
Xhold509 hold509/X _3463_/Q VPWR VGND sg13cmos5l_dlygate4sd3_1
X_3374__290 _3374_/RESET_B VPWR VGND sg13cmos5l_tiehi
X_3360_ _3360_/Q _3408_/CLK _3360_/D _3360_/RESET_B VPWR VGND sg13cmos5l_dfrbpq_1
X_2311_ _2311_/Y _2601_/B _2784_/A VPWR VGND sg13cmos5l_nand2b_1
X_3291_ _3291_/Q clkload9/A _3291_/D _3291_/RESET_B VPWR VGND sg13cmos5l_dfrbpq_1
XFILLER_2_291 VPWR VGND sg13cmos5l_decap_8
XFILLER_32_4 VPWR VGND sg13cmos5l_fill_2
X_2242_ _2242_/Y _3365_/Q _2239_/B _2241_/Y _3366_/Q VPWR VGND sg13cmos5l_a22oi_1
XFILLER_39_947 VPWR VGND sg13cmos5l_decap_8
X_2173_ _3352_/D _2173_/A _2173_/B VPWR VGND sg13cmos5l_nor2_1
X_3381__283 _3381_/RESET_B VPWR VGND sg13cmos5l_tiehi
XFILLER_25_107 VPWR VGND sg13cmos5l_fill_2
XFILLER_25_118 VPWR VGND sg13cmos5l_decap_8
XFILLER_33_184 VPWR VGND sg13cmos5l_decap_8
XFILLER_33_195 VPWR VGND sg13cmos5l_fill_1
XFILLER_21_357 VPWR VGND sg13cmos5l_decap_8
X_1957_ _1957_/Y _1951_/B _3297_/Q _1943_/Y hold451/X VPWR VGND sg13cmos5l_a22oi_1
XFILLER_31_18 VPWR VGND sg13cmos5l_decap_8
X_1888_ _1986_/A _3547_/Q _3546_/Q VPWR VGND sg13cmos5l_or2_1
Xoutput18 uo_out[4] _3297_/Q VPWR VGND sg13cmos5l_buf_1
XFILLER_1_718 VPWR VGND sg13cmos5l_decap_8
X_2509_ _2618_/B hold720/X _2513_/B _2513_/C VPWR VGND sg13cmos5l_nand3b_1
X_3489_ _3489_/Q clkload2/A _3489_/D _3489_/RESET_B VPWR VGND sg13cmos5l_dfrbpq_1
XFILLER_29_402 VPWR VGND sg13cmos5l_fill_2
XFILLER_45_928 VPWR VGND sg13cmos5l_decap_8
XFILLER_44_405 VPWR VGND sg13cmos5l_fill_2
XFILLER_17_619 VPWR VGND sg13cmos5l_decap_8
XFILLER_44_449 VPWR VGND sg13cmos5l_decap_8
XFILLER_25_685 VPWR VGND sg13cmos5l_decap_8
XFILLER_12_379 VPWR VGND sg13cmos5l_decap_8
XFILLER_40_699 VPWR VGND sg13cmos5l_decap_8
XFILLER_21_40 VPWR VGND sg13cmos5l_decap_8
XFILLER_4_589 VPWR VGND sg13cmos5l_decap_8
XFILLER_48_733 VPWR VGND sg13cmos5l_decap_8
XFILLER_0_784 VPWR VGND sg13cmos5l_decap_8
XFILLER_47_232 VPWR VGND sg13cmos5l_fill_2
XFILLER_36_917 VPWR VGND sg13cmos5l_decap_8
XFILLER_44_994 VPWR VGND sg13cmos5l_decap_8
X_2860_ _2861_/B _3506_/Q _3507_/Q _3508_/Q VPWR VGND sg13cmos5l_o21ai_1
XFILLER_15_184 VPWR VGND sg13cmos5l_decap_8
XFILLER_15_195 VPWR VGND sg13cmos5l_decap_8
XFILLER_31_633 VPWR VGND sg13cmos5l_decap_8
XFILLER_31_644 VPWR VGND sg13cmos5l_fill_2
X_1811_ _1811_/Y _1811_/A VPWR VGND sg13cmos5l_inv_1
X_2791_ _2791_/Y _2731_/A _2731_/B _2698_/X VPWR VGND sg13cmos5l_o21ai_1
XFILLER_12_880 VPWR VGND sg13cmos5l_decap_8
XFILLER_8_862 VPWR VGND sg13cmos5l_decap_8
XFILLER_7_42 VPWR VGND sg13cmos5l_decap_8
XFILLER_7_86 VPWR VGND sg13cmos5l_decap_4
X_3412_ _3412_/Q _3444_/CLK _3412_/D _3412_/RESET_B VPWR VGND sg13cmos5l_dfrbpq_1
Xheichips26_dna_sequencer_91 uo_out[7] VPWR VGND sg13cmos5l_tielo
Xheichips26_dna_sequencer_80 uio_oe[6] VPWR VGND sg13cmos5l_tielo
X_3343_ _3343_/Q _3551_/CLK _3343_/D _3343_/RESET_B VPWR VGND sg13cmos5l_dfrbpq_1
X_3274_ _3274_/Q clkload9/A _3274_/D _3274_/RESET_B VPWR VGND sg13cmos5l_dfrbpq_1
XFILLER_39_711 VPWR VGND sg13cmos5l_fill_1
XFILLER_39_700 VPWR VGND sg13cmos5l_decap_8
X_2225_ _2226_/B _2214_/B _2214_/C _2221_/A VPWR VGND sg13cmos5l_a21oi_1
XFILLER_38_221 VPWR VGND sg13cmos5l_decap_8
XFILLER_39_755 VPWR VGND sg13cmos5l_decap_8
X_3344__329 _3344_/RESET_B VPWR VGND sg13cmos5l_tiehi
X_2156_ _2156_/Y _2160_/A _2160_/B VPWR VGND sg13cmos5l_nand2_1
XFILLER_26_29 VPWR VGND sg13cmos5l_fill_2
X_2087_ _3328_/D _2087_/A _2087_/B VPWR VGND sg13cmos5l_nor2_1
Xclkbuf_leaf_18_clk _3527_/CLK clkbuf_2_2__f_clk/X VPWR VGND sg13cmos5l_buf_8
XFILLER_35_972 VPWR VGND sg13cmos5l_decap_8
XFILLER_42_17 VPWR VGND sg13cmos5l_decap_8
XFILLER_22_622 VPWR VGND sg13cmos5l_decap_8
XFILLER_34_482 VPWR VGND sg13cmos5l_fill_1
XFILLER_42_28 VPWR VGND sg13cmos5l_fill_1
XFILLER_21_143 VPWR VGND sg13cmos5l_decap_8
X_2989_ _3004_/A _3003_/A _3003_/B _3003_/C VPWR VGND sg13cmos5l_a21oi_1
XFILLER_49_519 VPWR VGND sg13cmos5l_decap_8
XFILLER_29_210 VPWR VGND sg13cmos5l_decap_8
XFILLER_45_714 VPWR VGND sg13cmos5l_decap_4
XFILLER_17_427 VPWR VGND sg13cmos5l_fill_2
XFILLER_18_939 VPWR VGND sg13cmos5l_decap_8
XFILLER_45_758 VPWR VGND sg13cmos5l_decap_8
XFILLER_26_950 VPWR VGND sg13cmos5l_decap_8
XFILLER_33_909 VPWR VGND sg13cmos5l_fill_2
XFILLER_16_62 VPWR VGND sg13cmos5l_fill_1
XFILLER_13_644 VPWR VGND sg13cmos5l_decap_8
XFILLER_41_975 VPWR VGND sg13cmos5l_decap_8
XFILLER_12_143 VPWR VGND sg13cmos5l_decap_8
XFILLER_12_154 VPWR VGND sg13cmos5l_fill_2
XFILLER_13_666 VPWR VGND sg13cmos5l_decap_8
XFILLER_8_125 VPWR VGND sg13cmos5l_decap_8
XFILLER_12_176 VPWR VGND sg13cmos5l_decap_8
XFILLER_5_854 VPWR VGND sg13cmos5l_decap_8
X_2010_ _3310_/D _1868_/B _2014_/B _2009_/Y VPWR VGND sg13cmos5l_a21oi_1
XFILLER_36_714 VPWR VGND sg13cmos5l_fill_2
XFILLER_35_257 VPWR VGND sg13cmos5l_fill_2
XFILLER_44_791 VPWR VGND sg13cmos5l_decap_8
X_2912_ _3484_/D _2968_/B _2912_/B VPWR VGND sg13cmos5l_nor2_1
XFILLER_16_493 VPWR VGND sg13cmos5l_decap_8
XFILLER_32_964 VPWR VGND sg13cmos5l_decap_8
X_2843_ _3475_/D _2833_/A _2844_/S _2842_/Y VPWR VGND sg13cmos5l_a21oi_1
X_2774_ _2774_/Y _2930_/A _2774_/B VPWR VGND sg13cmos5l_nand2_1
Xclkbuf_leaf_7_clk _3355_/CLK clkload0/A VPWR VGND sg13cmos5l_buf_8
X_3326_ _3326_/Q _3551_/CLK _3326_/D _3326_/RESET_B VPWR VGND sg13cmos5l_dfrbpq_1
XFILLER_39_541 VPWR VGND sg13cmos5l_decap_8
X_3257_ _3542_/D _3257_/A _3257_/B VPWR VGND sg13cmos5l_nor2_1
X_2208_ _2208_/X _2214_/B _2214_/C _2214_/A VPWR VGND sg13cmos5l_a21o_1
X_3188_ _3188_/Y _3182_/Y _3188_/B _3188_/C VPWR VGND sg13cmos5l_nand3b_1
X_2139_ _2139_/Y _3344_/Q _3119_/A2 _2601_/A VPWR VGND sg13cmos5l_o21ai_1
XFILLER_22_441 VPWR VGND sg13cmos5l_decap_8
XFILLER_23_975 VPWR VGND sg13cmos5l_decap_8
Xhold681 _2152_/A _3351_/Q VPWR VGND sg13cmos5l_dlygate4sd3_1
Xhold670 _1813_/A _3365_/Q VPWR VGND sg13cmos5l_dlygate4sd3_1
Xhold692 _2373_/B _3382_/Q VPWR VGND sg13cmos5l_dlygate4sd3_1
XFILLER_2_868 VPWR VGND sg13cmos5l_decap_8
XFILLER_1_345 VPWR VGND sg13cmos5l_decap_4
XFILLER_18_725 VPWR VGND sg13cmos5l_decap_8
XFILLER_18_736 VPWR VGND sg13cmos5l_fill_1
XFILLER_45_533 VPWR VGND sg13cmos5l_decap_8
XFILLER_45_522 VPWR VGND sg13cmos5l_decap_4
XFILLER_18_769 VPWR VGND sg13cmos5l_decap_8
XFILLER_27_72 VPWR VGND sg13cmos5l_decap_8
XFILLER_14_920 VPWR VGND sg13cmos5l_fill_2
XFILLER_41_794 VPWR VGND sg13cmos5l_decap_8
XFILLER_9_423 VPWR VGND sg13cmos5l_fill_1
XFILLER_14_986 VPWR VGND sg13cmos5l_decap_8
XFILLER_4_10 VPWR VGND sg13cmos5l_decap_4
X_2490_ _2490_/Y _3415_/Q _3414_/Q _3441_/Q VPWR VGND sg13cmos5l_nand3b_1
XFILLER_5_695 VPWR VGND sg13cmos5l_decap_8
XFILLER_4_65 VPWR VGND sg13cmos5l_fill_2
XFILLER_4_54 VPWR VGND sg13cmos5l_decap_8
X_3111_ _3519_/D _3223_/A _3111_/B VPWR VGND sg13cmos5l_nor2_1
XFILLER_49_883 VPWR VGND sg13cmos5l_decap_8
X_3042_ _3069_/A _3042_/A VPWR VGND sg13cmos5l_inv_1
XFILLER_36_500 VPWR VGND sg13cmos5l_fill_1
XFILLER_36_533 VPWR VGND sg13cmos5l_decap_8
XFILLER_36_588 VPWR VGND sg13cmos5l_decap_8
XFILLER_36_566 VPWR VGND sg13cmos5l_decap_8
XFILLER_36_599 VPWR VGND sg13cmos5l_fill_1
XFILLER_23_216 VPWR VGND sg13cmos5l_decap_8
X_3495__402 _3495_/RESET_B VPWR VGND sg13cmos5l_tiehi
XFILLER_32_772 VPWR VGND sg13cmos5l_decap_8
X_2826_ _2826_/Y _2819_/A _2819_/B _2833_/A _2833_/B VPWR VGND sg13cmos5l_a22oi_1
X_2757_ _2757_/Y _2922_/B _2757_/B VPWR VGND sg13cmos5l_nand2_1
X_2688_ _2689_/B _3475_/Q _3474_/Q _3476_/Q VPWR VGND sg13cmos5l_o21ai_1
X_3309_ _3309_/Q clkload2/A _3309_/D _3309_/RESET_B VPWR VGND sg13cmos5l_dfrbpq_1
XFILLER_27_533 VPWR VGND sg13cmos5l_decap_8
XFILLER_14_205 VPWR VGND sg13cmos5l_fill_2
XFILLER_42_569 VPWR VGND sg13cmos5l_decap_8
XFILLER_11_901 VPWR VGND sg13cmos5l_decap_8
Xfanout31 _3000_/B _3015_/B VPWR VGND sg13cmos5l_buf_1
Xfanout20 _2958_/A2 _2962_/A2 VPWR VGND sg13cmos5l_buf_1
Xfanout53 _3027_/A _3522_/Q VPWR VGND sg13cmos5l_buf_1
XFILLER_23_772 VPWR VGND sg13cmos5l_decap_4
Xfanout42 _2673_/A _2667_/A VPWR VGND sg13cmos5l_buf_1
Xfanout64 _2601_/A _2009_/B1 VPWR VGND sg13cmos5l_buf_1
XFILLER_7_927 VPWR VGND sg13cmos5l_decap_8
XFILLER_6_426 VPWR VGND sg13cmos5l_decap_8
XFILLER_11_978 VPWR VGND sg13cmos5l_decap_8
XFILLER_2_654 VPWR VGND sg13cmos5l_decap_8
XFILLER_37_308 VPWR VGND sg13cmos5l_decap_8
X_3487__97 _3487_/D VPWR VGND sg13cmos5l_tielo
XFILLER_46_864 VPWR VGND sg13cmos5l_decap_8
X_3397__108 _3397_/D VPWR VGND sg13cmos5l_tielo
XFILLER_33_525 VPWR VGND sg13cmos5l_decap_8
X_1990_ _1991_/D _3545_/Q _1995_/B hold688/X VPWR VGND sg13cmos5l_o21ai_1
XFILLER_33_558 VPWR VGND sg13cmos5l_decap_8
XFILLER_33_569 VPWR VGND sg13cmos5l_fill_2
Xclkload12 clkload12/Y _3453_/CLK VPWR VGND sg13cmos5l_inv_4
X_2611_ _3436_/D _2611_/A _2615_/B VPWR VGND sg13cmos5l_and2_1
X_2542_ _2542_/Y _2542_/A _2542_/B VPWR VGND sg13cmos5l_nor2_1
XFILLER_47_1018 VPWR VGND sg13cmos5l_decap_8
XFILLER_6_993 VPWR VGND sg13cmos5l_decap_8
X_2473_ _3409_/D _2473_/A _2472_/Y VPWR VGND sg13cmos5l_nor2b_1
XFILLER_37_853 VPWR VGND sg13cmos5l_decap_4
XFILLER_37_820 VPWR VGND sg13cmos5l_fill_1
X_3025_ _3025_/Y _3012_/Y _3017_/Y _2846_/Y VPWR VGND sg13cmos5l_o21ai_1
XFILLER_37_875 VPWR VGND sg13cmos5l_decap_8
XFILLER_24_536 VPWR VGND sg13cmos5l_decap_8
X_3499__390 _3499_/RESET_B VPWR VGND sg13cmos5l_tiehi
Xclkload6 clkload6/Y clkload6/A VPWR VGND sg13cmos5l_inv_8
XFILLER_20_764 VPWR VGND sg13cmos5l_decap_8
X_2809_ _2810_/A _3471_/Q _2820_/B _2830_/A VPWR VGND sg13cmos5l_o21ai_1
XFILLER_30_1011 VPWR VGND sg13cmos5l_decap_8
XFILLER_8_1023 VPWR VGND sg13cmos5l_decap_4
XFILLER_46_105 VPWR VGND sg13cmos5l_fill_1
XFILLER_42_311 VPWR VGND sg13cmos5l_decap_8
XFILLER_43_867 VPWR VGND sg13cmos5l_decap_8
XFILLER_15_547 VPWR VGND sg13cmos5l_decap_8
XFILLER_42_377 VPWR VGND sg13cmos5l_decap_8
XFILLER_30_528 VPWR VGND sg13cmos5l_decap_8
XFILLER_24_84 VPWR VGND sg13cmos5l_decap_8
X_3300__393 _3300_/RESET_B VPWR VGND sg13cmos5l_tiehi
XFILLER_40_61 VPWR VGND sg13cmos5l_decap_8
XFILLER_10_296 VPWR VGND sg13cmos5l_decap_8
XFILLER_3_996 VPWR VGND sg13cmos5l_decap_8
XFILLER_2_495 VPWR VGND sg13cmos5l_decap_8
XFILLER_27_7 VPWR VGND sg13cmos5l_decap_8
XFILLER_46_661 VPWR VGND sg13cmos5l_fill_1
XFILLER_46_694 VPWR VGND sg13cmos5l_fill_2
XFILLER_18_363 VPWR VGND sg13cmos5l_fill_2
XFILLER_18_374 VPWR VGND sg13cmos5l_decap_8
XFILLER_33_300 VPWR VGND sg13cmos5l_decap_8
XFILLER_34_878 VPWR VGND sg13cmos5l_decap_8
XFILLER_21_528 VPWR VGND sg13cmos5l_fill_1
XFILLER_33_377 VPWR VGND sg13cmos5l_decap_8
X_1973_ _1973_/Y _3089_/A _1983_/A2 _1972_/Y VPWR VGND sg13cmos5l_a21oi_1
XFILLER_14_1028 VPWR VGND sg13cmos5l_fill_1
XFILLER_6_790 VPWR VGND sg13cmos5l_decap_8
X_2525_ _3417_/D _2673_/A _2621_/A VPWR VGND sg13cmos5l_nor2_1
X_2456_ _2456_/Y _2455_/Y _2465_/B VPWR VGND sg13cmos5l_nand2b_1
X_2387_ _2388_/B _3367_/Q _3412_/Q VPWR VGND sg13cmos5l_nand2_1
XFILLER_28_138 VPWR VGND sg13cmos5l_decap_8
X_3008_ _3008_/Y _3004_/Y _3006_/Y _3007_/Y VPWR VGND sg13cmos5l_o21ai_1
XFILLER_25_834 VPWR VGND sg13cmos5l_decap_8
XFILLER_12_506 VPWR VGND sg13cmos5l_decap_8
XFILLER_24_388 VPWR VGND sg13cmos5l_fill_1
XFILLER_12_539 VPWR VGND sg13cmos5l_decap_8
XFILLER_4_705 VPWR VGND sg13cmos5l_decap_8
XFILLER_3_215 VPWR VGND sg13cmos5l_decap_8
XFILLER_3_259 VPWR VGND sg13cmos5l_decap_8
XFILLER_0_966 VPWR VGND sg13cmos5l_decap_8
X_3428__104 _3428_/D VPWR VGND sg13cmos5l_tielo
XFILLER_48_915 VPWR VGND sg13cmos5l_decap_8
XFILLER_19_40 VPWR VGND sg13cmos5l_fill_2
XFILLER_47_436 VPWR VGND sg13cmos5l_decap_4
XFILLER_35_609 VPWR VGND sg13cmos5l_decap_8
XFILLER_15_300 VPWR VGND sg13cmos5l_decap_8
XFILLER_28_683 VPWR VGND sg13cmos5l_fill_1
XFILLER_28_694 VPWR VGND sg13cmos5l_fill_2
XFILLER_34_108 VPWR VGND sg13cmos5l_decap_4
XFILLER_16_856 VPWR VGND sg13cmos5l_fill_2
XFILLER_16_867 VPWR VGND sg13cmos5l_fill_2
XFILLER_27_193 VPWR VGND sg13cmos5l_fill_2
XFILLER_42_163 VPWR VGND sg13cmos5l_decap_8
XFILLER_37_1028 VPWR VGND sg13cmos5l_fill_1
XFILLER_15_377 VPWR VGND sg13cmos5l_decap_4
XFILLER_31_826 VPWR VGND sg13cmos5l_decap_8
X_3290_ _3290_/Q clkload8/A _3290_/D _3290_/RESET_B VPWR VGND sg13cmos5l_dfrbpq_1
X_2310_ _3381_/D _2303_/B hold723/X _2309_/A VPWR VGND sg13cmos5l_a21oi_1
X_2241_ _2241_/Y _2432_/A _1845_/A _2134_/A _2134_/B VPWR VGND sg13cmos5l_a22oi_1
XFILLER_3_793 VPWR VGND sg13cmos5l_decap_8
XFILLER_39_926 VPWR VGND sg13cmos5l_decap_8
X_2172_ _2173_/B _2163_/Y _2174_/A _2147_/B VPWR VGND sg13cmos5l_o21ai_1
XFILLER_38_458 VPWR VGND sg13cmos5l_decap_4
XFILLER_19_694 VPWR VGND sg13cmos5l_fill_1
XFILLER_21_314 VPWR VGND sg13cmos5l_fill_1
X_1956_ _3296_/D _3239_/A _1956_/B VPWR VGND sg13cmos5l_nor2_1
X_1887_ _2006_/B _3547_/Q _3546_/Q VPWR VGND sg13cmos5l_nor2_1
Xoutput19 uo_out[5] _3298_/Q VPWR VGND sg13cmos5l_buf_1
X_2508_ _2618_/A _2513_/B _2513_/C _2507_/Y VPWR VGND sg13cmos5l_a21o_1
XFILLER_0_229 VPWR VGND sg13cmos5l_decap_8
X_3488_ _3488_/Q clkload3/A _3488_/D _3488_/RESET_B VPWR VGND sg13cmos5l_dfrbpq_1
X_2439_ _2439_/X _2434_/A _2376_/B _2457_/A VPWR VGND sg13cmos5l_mux2_1
XFILLER_5_1015 VPWR VGND sg13cmos5l_decap_8
XFILLER_45_907 VPWR VGND sg13cmos5l_decap_8
XFILLER_44_428 VPWR VGND sg13cmos5l_decap_8
XFILLER_38_992 VPWR VGND sg13cmos5l_decap_8
X_3505__378 _3505_/RESET_B VPWR VGND sg13cmos5l_tiehi
XFILLER_16_108 VPWR VGND sg13cmos5l_decap_8
XFILLER_24_141 VPWR VGND sg13cmos5l_decap_8
XFILLER_24_185 VPWR VGND sg13cmos5l_decap_8
XFILLER_12_347 VPWR VGND sg13cmos5l_decap_8
XFILLER_12_358 VPWR VGND sg13cmos5l_decap_8
XFILLER_21_881 VPWR VGND sg13cmos5l_decap_8
XFILLER_43_1021 VPWR VGND sg13cmos5l_decap_8
XFILLER_0_763 VPWR VGND sg13cmos5l_decap_8
XFILLER_47_211 VPWR VGND sg13cmos5l_decap_8
XFILLER_48_789 VPWR VGND sg13cmos5l_decap_8
XFILLER_47_288 VPWR VGND sg13cmos5l_decap_8
XFILLER_35_417 VPWR VGND sg13cmos5l_decap_8
XFILLER_16_642 VPWR VGND sg13cmos5l_decap_8
XFILLER_35_439 VPWR VGND sg13cmos5l_decap_8
XFILLER_44_973 VPWR VGND sg13cmos5l_decap_8
XFILLER_15_163 VPWR VGND sg13cmos5l_decap_8
XFILLER_31_612 VPWR VGND sg13cmos5l_decap_8
X_1810_ _1810_/Y _1810_/A VPWR VGND sg13cmos5l_inv_1
X_3337__337 _3337_/RESET_B VPWR VGND sg13cmos5l_tiehi
XFILLER_8_841 VPWR VGND sg13cmos5l_decap_8
X_2790_ _3472_/D _2790_/A _2845_/A VPWR VGND sg13cmos5l_nor2_1
XFILLER_30_188 VPWR VGND sg13cmos5l_fill_1
XFILLER_7_32 VPWR VGND sg13cmos5l_fill_1
XFILLER_7_65 VPWR VGND sg13cmos5l_decap_8
X_3411_ _3411_/Q _3442_/CLK _3411_/D _3411_/RESET_B VPWR VGND sg13cmos5l_dfrbpq_1
Xheichips26_dna_sequencer_81 uio_oe[7] VPWR VGND sg13cmos5l_tielo
X_3342_ _3342_/Q _3551_/CLK _3342_/D _3342_/RESET_B VPWR VGND sg13cmos5l_dfrbpq_1
X_3273_ _3273_/Q clkload9/A _3273_/D _3273_/RESET_B VPWR VGND sg13cmos5l_dfrbpq_1
X_2224_ _3361_/D _2264_/B _2224_/B VPWR VGND sg13cmos5l_and2_1
XFILLER_39_734 VPWR VGND sg13cmos5l_decap_8
XFILLER_38_200 VPWR VGND sg13cmos5l_decap_8
X_2155_ _2160_/B _2155_/A _2155_/B _2165_/A VPWR VGND sg13cmos5l_nand3_1
X_2086_ _2087_/B _2086_/A _2031_/B VPWR VGND sg13cmos5l_nor2b_1
XFILLER_19_480 VPWR VGND sg13cmos5l_decap_8
XFILLER_35_951 VPWR VGND sg13cmos5l_decap_8
XFILLER_22_601 VPWR VGND sg13cmos5l_decap_8
XFILLER_10_807 VPWR VGND sg13cmos5l_fill_1
X_2988_ _3003_/C _3502_/Q _3000_/B VPWR VGND sg13cmos5l_xnor2_1
X_1939_ _3289_/D input11/X hold514/X _1971_/A VPWR VGND sg13cmos5l_mux2_1
X_3429__232 _3429_/RESET_B VPWR VGND sg13cmos5l_tiehi
XFILLER_45_737 VPWR VGND sg13cmos5l_decap_8
XFILLER_44_247 VPWR VGND sg13cmos5l_fill_2
XFILLER_25_494 VPWR VGND sg13cmos5l_fill_1
XFILLER_41_954 VPWR VGND sg13cmos5l_decap_8
XFILLER_40_442 VPWR VGND sg13cmos5l_decap_8
XFILLER_40_431 VPWR VGND sg13cmos5l_fill_2
XFILLER_8_104 VPWR VGND sg13cmos5l_fill_2
XFILLER_9_627 VPWR VGND sg13cmos5l_decap_8
XFILLER_9_649 VPWR VGND sg13cmos5l_decap_8
XFILLER_13_689 VPWR VGND sg13cmos5l_fill_1
XFILLER_5_833 VPWR VGND sg13cmos5l_decap_8
XFILLER_4_343 VPWR VGND sg13cmos5l_decap_8
XFILLER_4_310 VPWR VGND sg13cmos5l_fill_1
XFILLER_4_365 VPWR VGND sg13cmos5l_decap_8
X_3371__294 _3371_/RESET_B VPWR VGND sg13cmos5l_tiehi
XFILLER_0_560 VPWR VGND sg13cmos5l_fill_1
XFILLER_0_593 VPWR VGND sg13cmos5l_decap_4
XFILLER_36_748 VPWR VGND sg13cmos5l_fill_2
XFILLER_35_236 VPWR VGND sg13cmos5l_decap_8
XFILLER_44_770 VPWR VGND sg13cmos5l_decap_8
X_2911_ _2912_/B _2974_/B _2974_/C VPWR VGND sg13cmos5l_nor2_1
XFILLER_17_995 VPWR VGND sg13cmos5l_decap_8
XFILLER_31_420 VPWR VGND sg13cmos5l_fill_2
XFILLER_32_943 VPWR VGND sg13cmos5l_decap_8
X_2842_ _2842_/Y _2833_/B _2844_/S _2786_/B VPWR VGND sg13cmos5l_o21ai_1
X_2773_ _2773_/Y _2756_/Y _2767_/Y _2772_/Y VPWR VGND sg13cmos5l_a21oi_1
X_3325_ _3325_/Q _3551_/CLK _3325_/D _3325_/RESET_B VPWR VGND sg13cmos5l_dfrbpq_1
X_3528__164 _3528_/RESET_B VPWR VGND sg13cmos5l_tiehi
X_3256_ _3256_/Y _3255_/A _3246_/Y _3255_/Y _1874_/A VPWR VGND sg13cmos5l_a22oi_1
X_2207_ _2214_/C _3334_/Q _3335_/Q hold731/X VPWR VGND sg13cmos5l_o21ai_1
X_3187_ _3188_/C _3187_/A _3187_/B VPWR VGND sg13cmos5l_or2_1
XFILLER_26_236 VPWR VGND sg13cmos5l_fill_2
XFILLER_27_737 VPWR VGND sg13cmos5l_fill_1
X_2138_ _2138_/Y _1817_/Y _2140_/A2 _2137_/Y VPWR VGND sg13cmos5l_a21oi_1
X_2069_ _2069_/Y _2043_/A _3291_/Q _1868_/Y VPWR VGND sg13cmos5l_a21oi_1
XFILLER_26_269 VPWR VGND sg13cmos5l_fill_1
XFILLER_41_239 VPWR VGND sg13cmos5l_fill_2
XFILLER_41_217 VPWR VGND sg13cmos5l_decap_4
XFILLER_23_910 VPWR VGND sg13cmos5l_fill_2
XFILLER_22_420 VPWR VGND sg13cmos5l_decap_8
XFILLER_23_954 VPWR VGND sg13cmos5l_decap_8
XFILLER_10_637 VPWR VGND sg13cmos5l_decap_8
Xhold660 _2459_/A _3405_/Q VPWR VGND sg13cmos5l_dlygate4sd3_1
XFILLER_2_847 VPWR VGND sg13cmos5l_decap_8
XFILLER_1_313 VPWR VGND sg13cmos5l_fill_1
Xhold671 _2249_/B _2248_/X VPWR VGND sg13cmos5l_dlygate4sd3_1
XFILLER_49_306 VPWR VGND sg13cmos5l_decap_8
Xhold693 _2729_/A _3419_/Q VPWR VGND sg13cmos5l_dlygate4sd3_1
Xhold682 _2641_/A _3437_/Q VPWR VGND sg13cmos5l_dlygate4sd3_1
XFILLER_49_339 VPWR VGND sg13cmos5l_decap_8
XFILLER_45_501 VPWR VGND sg13cmos5l_decap_8
X_3327__347 _3327_/RESET_B VPWR VGND sg13cmos5l_tiehi
XFILLER_18_748 VPWR VGND sg13cmos5l_decap_8
XFILLER_32_228 VPWR VGND sg13cmos5l_decap_8
XFILLER_43_50 VPWR VGND sg13cmos5l_decap_4
XFILLER_41_751 VPWR VGND sg13cmos5l_decap_8
XFILLER_14_965 VPWR VGND sg13cmos5l_decap_8
XFILLER_41_773 VPWR VGND sg13cmos5l_decap_8
XFILLER_40_250 VPWR VGND sg13cmos5l_decap_8
XFILLER_13_464 VPWR VGND sg13cmos5l_decap_4
XFILLER_40_294 VPWR VGND sg13cmos5l_decap_4
XFILLER_5_674 VPWR VGND sg13cmos5l_decap_4
XFILLER_4_140 VPWR VGND sg13cmos5l_decap_4
XFILLER_4_173 VPWR VGND sg13cmos5l_decap_8
X_3110_ _3111_/B _3098_/B _1800_/Y _3110_/S VPWR VGND sg13cmos5l_mux2_1
X_3310__373 _3310_/RESET_B VPWR VGND sg13cmos5l_tiehi
XFILLER_49_862 VPWR VGND sg13cmos5l_decap_8
XFILLER_48_350 VPWR VGND sg13cmos5l_decap_8
X_3041_ _3042_/A _3049_/B _3040_/Y VPWR VGND sg13cmos5l_nor2b_1
XFILLER_17_781 VPWR VGND sg13cmos5l_fill_1
XFILLER_16_291 VPWR VGND sg13cmos5l_decap_4
XFILLER_23_239 VPWR VGND sg13cmos5l_decap_8
XFILLER_20_902 VPWR VGND sg13cmos5l_fill_1
X_2825_ _2833_/B _2794_/A _2739_/Y _2825_/S VPWR VGND sg13cmos5l_mux2_1
X_3419__242 _3419_/RESET_B VPWR VGND sg13cmos5l_tiehi
XFILLER_8_490 VPWR VGND sg13cmos5l_decap_8
XFILLER_9_991 VPWR VGND sg13cmos5l_decap_8
X_2756_ _2756_/Y _2757_/B VPWR VGND sg13cmos5l_inv_1
X_2687_ _2694_/B _3475_/Q _3474_/Q _3476_/Q VPWR VGND sg13cmos5l_nor3_1
X_3308_ _3308_/Q _3539_/CLK _3308_/D _3308_/RESET_B VPWR VGND sg13cmos5l_dfrbpq_1
X_3239_ _3539_/D _3239_/A _3239_/B VPWR VGND sg13cmos5l_nor2_1
X_3426__235 _3426_/RESET_B VPWR VGND sg13cmos5l_tiehi
XFILLER_39_394 VPWR VGND sg13cmos5l_decap_4
XFILLER_27_578 VPWR VGND sg13cmos5l_decap_8
XFILLER_14_228 VPWR VGND sg13cmos5l_fill_2
XFILLER_42_548 VPWR VGND sg13cmos5l_decap_8
XFILLER_14_239 VPWR VGND sg13cmos5l_fill_1
Xfanout21 _2963_/A2 _2962_/A2 VPWR VGND sg13cmos5l_buf_1
Xfanout65 _2019_/B _2009_/B1 VPWR VGND sg13cmos5l_buf_1
Xfanout54 _3121_/A hold715/X VPWR VGND sg13cmos5l_buf_1
Xfanout32 _2820_/B _2829_/B VPWR VGND sg13cmos5l_buf_1
Xfanout43 _2667_/A _2482_/Y VPWR VGND sg13cmos5l_buf_1
XFILLER_7_906 VPWR VGND sg13cmos5l_decap_8
XFILLER_11_957 VPWR VGND sg13cmos5l_decap_8
XFILLER_22_272 VPWR VGND sg13cmos5l_fill_2
XFILLER_6_405 VPWR VGND sg13cmos5l_decap_8
XFILLER_10_456 VPWR VGND sg13cmos5l_decap_8
XFILLER_13_75 VPWR VGND sg13cmos5l_decap_8
XFILLER_6_449 VPWR VGND sg13cmos5l_decap_8
XFILLER_13_97 VPWR VGND sg13cmos5l_decap_8
XFILLER_2_600 VPWR VGND sg13cmos5l_decap_8
XFILLER_2_644 VPWR VGND sg13cmos5l_decap_4
Xhold490 _3401_/D _2425_/Y VPWR VGND sg13cmos5l_dlygate4sd3_1
XFILLER_49_125 VPWR VGND sg13cmos5l_decap_4
XFILLER_46_821 VPWR VGND sg13cmos5l_decap_4
XFILLER_45_320 VPWR VGND sg13cmos5l_decap_4
XFILLER_38_94 VPWR VGND sg13cmos5l_decap_8
XFILLER_18_567 VPWR VGND sg13cmos5l_decap_8
XFILLER_45_386 VPWR VGND sg13cmos5l_decap_8
XFILLER_14_751 VPWR VGND sg13cmos5l_fill_2
Xclkload13 clkload13/Y _3485_/CLK VPWR VGND sg13cmos5l_inv_2
X_2610_ _3435_/D _2610_/A _2610_/B VPWR VGND sg13cmos5l_and2_1
XFILLER_6_972 VPWR VGND sg13cmos5l_decap_8
X_2541_ _2541_/X _2542_/A _2542_/B _2539_/Y VPWR VGND sg13cmos5l_a21o_1
X_2472_ _2472_/Y _2439_/X _2474_/A _2383_/A VPWR VGND sg13cmos5l_a21oi_1
XFILLER_5_471 VPWR VGND sg13cmos5l_fill_2
XFILLER_5_460 VPWR VGND sg13cmos5l_decap_8
XFILLER_49_681 VPWR VGND sg13cmos5l_decap_8
XFILLER_37_832 VPWR VGND sg13cmos5l_fill_2
X_3024_ _3507_/D _3006_/Y _3017_/Y _3023_/Y VPWR VGND sg13cmos5l_a21oi_1
XFILLER_24_559 VPWR VGND sg13cmos5l_decap_8
Xclkload7 clkload7/Y clkload7/A VPWR VGND sg13cmos5l_inv_2
X_2808_ _2830_/A _3470_/Q _2820_/B _2824_/A VPWR VGND sg13cmos5l_a21o_1
X_2739_ _2739_/Y _2794_/B VPWR VGND sg13cmos5l_inv_1
XFILLER_8_1002 VPWR VGND sg13cmos5l_decap_8
XFILLER_47_607 VPWR VGND sg13cmos5l_fill_1
XFILLER_46_128 VPWR VGND sg13cmos5l_fill_2
XFILLER_46_117 VPWR VGND sg13cmos5l_decap_8
XFILLER_39_191 VPWR VGND sg13cmos5l_decap_4
XFILLER_28_876 VPWR VGND sg13cmos5l_decap_8
XFILLER_15_526 VPWR VGND sg13cmos5l_decap_8
XFILLER_27_386 VPWR VGND sg13cmos5l_decap_8
XFILLER_43_846 VPWR VGND sg13cmos5l_fill_2
XFILLER_42_356 VPWR VGND sg13cmos5l_decap_8
X_3294__405 _3294_/RESET_B VPWR VGND sg13cmos5l_tiehi
XFILLER_24_63 VPWR VGND sg13cmos5l_decap_8
XFILLER_10_253 VPWR VGND sg13cmos5l_decap_4
XFILLER_11_754 VPWR VGND sg13cmos5l_decap_8
XFILLER_11_765 VPWR VGND sg13cmos5l_fill_1
XFILLER_6_224 VPWR VGND sg13cmos5l_fill_1
XFILLER_6_213 VPWR VGND sg13cmos5l_decap_8
XFILLER_10_275 VPWR VGND sg13cmos5l_decap_8
XFILLER_40_40 VPWR VGND sg13cmos5l_fill_2
XFILLER_7_769 VPWR VGND sg13cmos5l_fill_1
XFILLER_6_257 VPWR VGND sg13cmos5l_fill_1
XFILLER_2_430 VPWR VGND sg13cmos5l_fill_2
XFILLER_3_975 VPWR VGND sg13cmos5l_decap_8
XFILLER_2_474 VPWR VGND sg13cmos5l_decap_8
XFILLER_37_106 VPWR VGND sg13cmos5l_decap_8
X_3368__299 _3368_/RESET_B VPWR VGND sg13cmos5l_tiehi
X_3409__252 _3409_/RESET_B VPWR VGND sg13cmos5l_tiehi
XFILLER_18_342 VPWR VGND sg13cmos5l_decap_8
XFILLER_19_898 VPWR VGND sg13cmos5l_decap_8
XFILLER_45_194 VPWR VGND sg13cmos5l_fill_2
XFILLER_45_183 VPWR VGND sg13cmos5l_decap_8
XFILLER_33_367 VPWR VGND sg13cmos5l_decap_4
X_1972_ _1972_/Y _1983_/A2 _3303_/Q _3028_/B VPWR VGND sg13cmos5l_o21ai_1
XFILLER_14_1007 VPWR VGND sg13cmos5l_decap_8
X_3490__163 _3490_/RESET_B VPWR VGND sg13cmos5l_tiehi
X_3416__245 _3416_/RESET_B VPWR VGND sg13cmos5l_tiehi
XFILLER_46_0 VPWR VGND sg13cmos5l_decap_4
X_2524_ _2655_/A _2621_/A VPWR VGND sg13cmos5l_inv_1
X_2455_ _2455_/Y _3406_/Q _2455_/B VPWR VGND sg13cmos5l_xnor2_1
X_2386_ _2386_/Y _3366_/Q _2613_/A _2612_/A _3365_/Q _2385_/Y VPWR VGND sg13cmos5l_a221oi_1
XFILLER_29_618 VPWR VGND sg13cmos5l_decap_8
XFILLER_28_106 VPWR VGND sg13cmos5l_decap_8
X_3423__238 _3423_/RESET_B VPWR VGND sg13cmos5l_tiehi
XFILLER_37_695 VPWR VGND sg13cmos5l_decap_8
X_3007_ _3007_/Y _2999_/X _3007_/B VPWR VGND sg13cmos5l_nand2b_1
XFILLER_24_312 VPWR VGND sg13cmos5l_fill_1
XFILLER_33_890 VPWR VGND sg13cmos5l_fill_2
XFILLER_0_945 VPWR VGND sg13cmos5l_decap_8
XFILLER_47_459 VPWR VGND sg13cmos5l_decap_8
XFILLER_43_654 VPWR VGND sg13cmos5l_fill_1
XFILLER_43_643 VPWR VGND sg13cmos5l_decap_4
XFILLER_37_1007 VPWR VGND sg13cmos5l_decap_8
XFILLER_27_172 VPWR VGND sg13cmos5l_decap_8
XFILLER_15_356 VPWR VGND sg13cmos5l_decap_8
XFILLER_35_73 VPWR VGND sg13cmos5l_decap_8
XFILLER_42_175 VPWR VGND sg13cmos5l_decap_4
XFILLER_7_500 VPWR VGND sg13cmos5l_fill_2
XFILLER_11_562 VPWR VGND sg13cmos5l_fill_2
XFILLER_7_588 VPWR VGND sg13cmos5l_decap_8
XFILLER_3_772 VPWR VGND sg13cmos5l_decap_8
X_2240_ _2240_/Y _2240_/A _2240_/B VPWR VGND sg13cmos5l_nand2_1
XFILLER_38_437 VPWR VGND sg13cmos5l_decap_8
XFILLER_18_4 VPWR VGND sg13cmos5l_decap_8
X_2171_ _2173_/A _2171_/A _2174_/A VPWR VGND sg13cmos5l_nor2b_1
XFILLER_20_1022 VPWR VGND sg13cmos5l_decap_8
XFILLER_22_805 VPWR VGND sg13cmos5l_fill_1
XFILLER_34_654 VPWR VGND sg13cmos5l_fill_1
XFILLER_34_698 VPWR VGND sg13cmos5l_decap_8
X_1955_ _1955_/Y _1951_/B _3296_/Q _1943_/Y hold476/X VPWR VGND sg13cmos5l_a22oi_1
XFILLER_30_871 VPWR VGND sg13cmos5l_decap_8
X_1886_ _1995_/B _1886_/A _1876_/A VPWR VGND sg13cmos5l_nor2b_1
X_2507_ _2507_/Y _3441_/Q _2521_/B VPWR VGND sg13cmos5l_nand2_1
X_3487_ _3487_/Q clkload4/A _3487_/D _3487_/RESET_B VPWR VGND sg13cmos5l_dfrbpq_1
X_2438_ _2457_/A _2434_/Y _2436_/Y _2437_/Y VPWR VGND sg13cmos5l_a21oi_1
X_2369_ _2369_/Y _2369_/A _2377_/B VPWR VGND sg13cmos5l_nand2_1
XFILLER_29_404 VPWR VGND sg13cmos5l_fill_1
XFILLER_44_418 VPWR VGND sg13cmos5l_fill_2
XFILLER_44_407 VPWR VGND sg13cmos5l_fill_1
XFILLER_38_971 VPWR VGND sg13cmos5l_decap_8
XFILLER_37_470 VPWR VGND sg13cmos5l_decap_8
XFILLER_25_643 VPWR VGND sg13cmos5l_decap_8
XFILLER_40_602 VPWR VGND sg13cmos5l_decap_8
XFILLER_40_613 VPWR VGND sg13cmos5l_decap_8
XFILLER_9_809 VPWR VGND sg13cmos5l_decap_8
XFILLER_12_315 VPWR VGND sg13cmos5l_decap_4
XFILLER_12_326 VPWR VGND sg13cmos5l_decap_8
XFILLER_13_827 VPWR VGND sg13cmos5l_fill_2
XFILLER_24_164 VPWR VGND sg13cmos5l_decap_8
XFILLER_40_657 VPWR VGND sg13cmos5l_decap_8
XFILLER_8_308 VPWR VGND sg13cmos5l_fill_1
XFILLER_21_871 VPWR VGND sg13cmos5l_decap_4
XFILLER_21_75 VPWR VGND sg13cmos5l_decap_8
XFILLER_21_97 VPWR VGND sg13cmos5l_decap_8
XFILLER_43_1000 VPWR VGND sg13cmos5l_decap_8
XFILLER_0_742 VPWR VGND sg13cmos5l_decap_8
XFILLER_48_768 VPWR VGND sg13cmos5l_decap_8
XFILLER_47_234 VPWR VGND sg13cmos5l_fill_1
XFILLER_47_267 VPWR VGND sg13cmos5l_decap_8
XFILLER_29_993 VPWR VGND sg13cmos5l_decap_8
X_3406__255 _3406_/RESET_B VPWR VGND sg13cmos5l_tiehi
XFILLER_46_94 VPWR VGND sg13cmos5l_fill_2
XFILLER_46_83 VPWR VGND sg13cmos5l_decap_8
XFILLER_44_952 VPWR VGND sg13cmos5l_decap_8
XFILLER_43_451 VPWR VGND sg13cmos5l_decap_4
XFILLER_31_602 VPWR VGND sg13cmos5l_fill_2
XFILLER_16_687 VPWR VGND sg13cmos5l_decap_4
XFILLER_30_101 VPWR VGND sg13cmos5l_fill_2
XFILLER_31_657 VPWR VGND sg13cmos5l_decap_8
XFILLER_8_820 VPWR VGND sg13cmos5l_decap_8
XFILLER_8_897 VPWR VGND sg13cmos5l_decap_8
XFILLER_7_374 VPWR VGND sg13cmos5l_decap_8
X_3410_ _3410_/Q _3442_/CLK _3410_/D _3410_/RESET_B VPWR VGND sg13cmos5l_dfrbpq_1
XFILLER_7_99 VPWR VGND sg13cmos5l_fill_2
X_3413__248 _3413_/RESET_B VPWR VGND sg13cmos5l_tiehi
X_3341_ _3341_/Q _3408_/CLK _3341_/D _3341_/RESET_B VPWR VGND sg13cmos5l_dfrbpq_1
Xheichips26_dna_sequencer_82 uio_out[0] VPWR VGND sg13cmos5l_tielo
X_3272_ _3272_/Q clkload9/A _3272_/D _3272_/RESET_B VPWR VGND sg13cmos5l_dfrbpq_1
X_2223_ _2224_/B _2109_/Y _2215_/Y _2222_/Y VPWR VGND sg13cmos5l_o21ai_1
X_2154_ _2164_/B _2158_/A _2158_/B VPWR VGND sg13cmos5l_and2_1
XFILLER_38_267 VPWR VGND sg13cmos5l_decap_8
X_2085_ _3327_/D _2024_/Y hold555/X _2031_/B _2086_/A _2087_/A VPWR VGND sg13cmos5l_a221oi_1
XFILLER_35_930 VPWR VGND sg13cmos5l_decap_8
X_2987_ _3003_/B _3496_/Q _3467_/Q _3501_/Q VPWR VGND sg13cmos5l_nand3_1
XFILLER_21_178 VPWR VGND sg13cmos5l_decap_8
X_1938_ _3288_/D input10/X _2043_/B _1971_/A VPWR VGND sg13cmos5l_mux2_1
X_1869_ _1870_/B _3312_/Q _2014_/B _1869_/C VPWR VGND sg13cmos5l_nand3_1
X_3539_ _3539_/Q _3539_/CLK _3539_/D _3539_/RESET_B VPWR VGND sg13cmos5l_dfrbpq_1
XFILLER_27_1028 VPWR VGND sg13cmos5l_fill_1
XFILLER_29_245 VPWR VGND sg13cmos5l_decap_8
XFILLER_16_53 VPWR VGND sg13cmos5l_fill_1
XFILLER_25_440 VPWR VGND sg13cmos5l_fill_1
XFILLER_26_985 VPWR VGND sg13cmos5l_decap_8
XFILLER_41_933 VPWR VGND sg13cmos5l_decap_8
XFILLER_40_410 VPWR VGND sg13cmos5l_fill_2
XFILLER_16_86 VPWR VGND sg13cmos5l_decap_4
XFILLER_25_473 VPWR VGND sg13cmos5l_decap_4
XFILLER_12_112 VPWR VGND sg13cmos5l_decap_4
XFILLER_21_690 VPWR VGND sg13cmos5l_decap_4
XFILLER_5_812 VPWR VGND sg13cmos5l_decap_8
XFILLER_32_85 VPWR VGND sg13cmos5l_fill_2
XFILLER_10_1010 VPWR VGND sg13cmos5l_decap_8
XFILLER_5_889 VPWR VGND sg13cmos5l_decap_8
XFILLER_0_572 VPWR VGND sg13cmos5l_decap_8
X_3343__331 _3343_/RESET_B VPWR VGND sg13cmos5l_tiehi
XFILLER_17_974 VPWR VGND sg13cmos5l_decap_8
X_2910_ _2974_/C _2916_/A _2910_/B _2913_/C VPWR VGND sg13cmos5l_nor3_1
XFILLER_32_922 VPWR VGND sg13cmos5l_decap_8
X_2841_ _3474_/D _2819_/A _2844_/S _2840_/Y VPWR VGND sg13cmos5l_a21oi_1
XFILLER_32_999 VPWR VGND sg13cmos5l_decap_8
X_2772_ _2772_/Y _2926_/A _2767_/Y _2786_/B VPWR VGND sg13cmos5l_o21ai_1
XFILLER_31_498 VPWR VGND sg13cmos5l_fill_2
XFILLER_8_683 VPWR VGND sg13cmos5l_fill_1
XFILLER_8_672 VPWR VGND sg13cmos5l_decap_8
X_3487__168 _3487_/RESET_B VPWR VGND sg13cmos5l_tiehi
X_3324_ _3324_/Q _3551_/CLK _3324_/D _3324_/RESET_B VPWR VGND sg13cmos5l_dfrbpq_1
X_3255_ _3255_/Y _3255_/A _3255_/B _3255_/C VPWR VGND sg13cmos5l_nand3_1
X_2206_ _2214_/B _3334_/Q _3335_/Q _3336_/Q VPWR VGND sg13cmos5l_or3_1
XFILLER_39_576 VPWR VGND sg13cmos5l_decap_8
XFILLER_2_1008 VPWR VGND sg13cmos5l_decap_8
X_3186_ _3188_/B _3068_/B _3186_/B VPWR VGND sg13cmos5l_nand2b_1
XFILLER_27_705 VPWR VGND sg13cmos5l_decap_8
XFILLER_26_215 VPWR VGND sg13cmos5l_decap_8
X_2137_ _2137_/Y _3343_/Q _2140_/A2 _2601_/A VPWR VGND sg13cmos5l_o21ai_1
X_2068_ _2068_/Y _2070_/A _3274_/Q VPWR VGND sg13cmos5l_nand2_1
XFILLER_42_719 VPWR VGND sg13cmos5l_decap_8
XFILLER_26_248 VPWR VGND sg13cmos5l_decap_8
XFILLER_26_259 VPWR VGND sg13cmos5l_fill_1
XFILLER_22_487 VPWR VGND sg13cmos5l_decap_8
Xhold661 _2473_/A _2471_/Y VPWR VGND sg13cmos5l_dlygate4sd3_1
XFILLER_2_826 VPWR VGND sg13cmos5l_decap_8
Xhold672 _3000_/A _3500_/Q VPWR VGND sg13cmos5l_dlygate4sd3_1
Xhold650 _2247_/B _2246_/X VPWR VGND sg13cmos5l_dlygate4sd3_1
Xhold694 _2732_/B _2731_/Y VPWR VGND sg13cmos5l_dlygate4sd3_1
Xhold683 hold683/X _2641_/X VPWR VGND sg13cmos5l_dlygate4sd3_1
XFILLER_40_1014 VPWR VGND sg13cmos5l_decap_8
XFILLER_17_226 VPWR VGND sg13cmos5l_fill_2
XFILLER_26_782 VPWR VGND sg13cmos5l_decap_8
X_3403__258 _3403_/RESET_B VPWR VGND sg13cmos5l_tiehi
XFILLER_41_730 VPWR VGND sg13cmos5l_decap_8
XFILLER_14_944 VPWR VGND sg13cmos5l_decap_8
XFILLER_43_73 VPWR VGND sg13cmos5l_decap_8
XFILLER_13_487 VPWR VGND sg13cmos5l_decap_8
XFILLER_5_653 VPWR VGND sg13cmos5l_decap_8
XFILLER_4_130 VPWR VGND sg13cmos5l_fill_1
XFILLER_49_841 VPWR VGND sg13cmos5l_decap_8
XFILLER_0_391 VPWR VGND sg13cmos5l_decap_8
X_3040_ _3040_/Y _3533_/Q _3532_/Q _3534_/Q VPWR VGND sg13cmos5l_o21ai_1
XFILLER_32_741 VPWR VGND sg13cmos5l_decap_8
XFILLER_17_1016 VPWR VGND sg13cmos5l_decap_8
XFILLER_17_1027 VPWR VGND sg13cmos5l_fill_2
X_2824_ _2833_/A _2824_/A _2831_/A _2824_/C VPWR VGND sg13cmos5l_or3_1
XFILLER_31_284 VPWR VGND sg13cmos5l_fill_1
XFILLER_9_970 VPWR VGND sg13cmos5l_decap_8
X_2755_ _2757_/B _3428_/Q _2753_/Y _2754_/Y VPWR VGND sg13cmos5l_o21ai_1
X_2686_ _2686_/Y _3474_/Q _2683_/Y _2685_/Y _2682_/Y VPWR VGND sg13cmos5l_a22oi_1
X_3307_ _3307_/Q clkload6/A _3307_/D _3307_/RESET_B VPWR VGND sg13cmos5l_dfrbpq_1
X_3238_ _3238_/Y _1996_/B _3229_/Y _3237_/Y _1879_/A VPWR VGND sg13cmos5l_a22oi_1
XFILLER_27_502 VPWR VGND sg13cmos5l_decap_8
XFILLER_39_373 VPWR VGND sg13cmos5l_decap_8
X_3169_ _3169_/Y _2884_/A _3165_/A _3183_/B _3168_/A VPWR VGND sg13cmos5l_a22oi_1
XFILLER_15_719 VPWR VGND sg13cmos5l_decap_8
XFILLER_27_568 VPWR VGND sg13cmos5l_fill_1
XFILLER_42_527 VPWR VGND sg13cmos5l_decap_8
Xfanout22 _2962_/A2 _2040_/X VPWR VGND sg13cmos5l_buf_1
Xfanout55 _2359_/A _2378_/A VPWR VGND sg13cmos5l_buf_1
Xfanout44 _2383_/A _2479_/A VPWR VGND sg13cmos5l_buf_1
Xfanout33 _2645_/B _2662_/B VPWR VGND sg13cmos5l_buf_1
XFILLER_11_936 VPWR VGND sg13cmos5l_decap_8
Xfanout66 _2009_/B1 fanout74/X VPWR VGND sg13cmos5l_buf_1
XFILLER_13_43 VPWR VGND sg13cmos5l_decap_8
XFILLER_2_623 VPWR VGND sg13cmos5l_decap_8
X_3333__341 _3333_/RESET_B VPWR VGND sg13cmos5l_tiehi
Xhold480 _1812_/A _3369_/Q VPWR VGND sg13cmos5l_dlygate4sd3_1
XFILLER_49_104 VPWR VGND sg13cmos5l_decap_8
Xhold491 hold491/X _3285_/Q VPWR VGND sg13cmos5l_dlygate4sd3_1
XFILLER_1_166 VPWR VGND sg13cmos5l_fill_1
XFILLER_49_159 VPWR VGND sg13cmos5l_decap_8
XFILLER_46_800 VPWR VGND sg13cmos5l_decap_8
XFILLER_38_62 VPWR VGND sg13cmos5l_fill_1
XFILLER_45_343 VPWR VGND sg13cmos5l_decap_4
XFILLER_18_546 VPWR VGND sg13cmos5l_decap_8
XFILLER_46_899 VPWR VGND sg13cmos5l_decap_8
XFILLER_45_365 VPWR VGND sg13cmos5l_decap_8
X_3340__334 _3340_/RESET_B VPWR VGND sg13cmos5l_tiehi
X_3477__178 _3477_/RESET_B VPWR VGND sg13cmos5l_tiehi
XFILLER_41_593 VPWR VGND sg13cmos5l_fill_2
XFILLER_9_211 VPWR VGND sg13cmos5l_decap_8
XFILLER_14_785 VPWR VGND sg13cmos5l_decap_8
XFILLER_9_277 VPWR VGND sg13cmos5l_decap_4
Xclkload14 clkload14/Y _3504_/CLK VPWR VGND sg13cmos5l_inv_2
XFILLER_6_951 VPWR VGND sg13cmos5l_decap_8
X_2540_ _2540_/Y _2542_/A _2542_/B _2539_/Y VPWR VGND sg13cmos5l_a21oi_1
X_2471_ _2471_/Y _2465_/B _2459_/X _2474_/A VPWR VGND sg13cmos5l_a21oi_1
X_3023_ _3023_/Y _3004_/Y _3017_/Y _2970_/B VPWR VGND sg13cmos5l_o21ai_1
XFILLER_36_310 VPWR VGND sg13cmos5l_decap_8
XFILLER_36_343 VPWR VGND sg13cmos5l_decap_4
XFILLER_37_888 VPWR VGND sg13cmos5l_decap_8
XFILLER_24_516 VPWR VGND sg13cmos5l_decap_8
XFILLER_36_365 VPWR VGND sg13cmos5l_fill_2
XFILLER_36_398 VPWR VGND sg13cmos5l_fill_1
XFILLER_20_711 VPWR VGND sg13cmos5l_decap_8
XFILLER_20_722 VPWR VGND sg13cmos5l_fill_2
XFILLER_32_571 VPWR VGND sg13cmos5l_decap_8
Xclkload8 clkload8/Y clkload8/A VPWR VGND sg13cmos5l_inv_2
X_2807_ _2824_/A _2823_/A _2823_/B _2823_/C VPWR VGND sg13cmos5l_a21oi_1
XFILLER_20_788 VPWR VGND sg13cmos5l_decap_4
X_2738_ _2794_/B _2518_/X _2728_/Y _2737_/Y VPWR VGND sg13cmos5l_a21oi_1
X_2669_ _3442_/D hold684/X _2672_/S _2668_/Y VPWR VGND sg13cmos5l_a21oi_1
X_3287__413 _3287_/RESET_B VPWR VGND sg13cmos5l_tiehi
XFILLER_39_170 VPWR VGND sg13cmos5l_decap_8
XFILLER_27_310 VPWR VGND sg13cmos5l_decap_8
XFILLER_28_855 VPWR VGND sg13cmos5l_decap_8
XFILLER_43_814 VPWR VGND sg13cmos5l_decap_8
XFILLER_43_858 VPWR VGND sg13cmos5l_fill_1
XFILLER_24_42 VPWR VGND sg13cmos5l_decap_8
XFILLER_10_210 VPWR VGND sg13cmos5l_fill_2
XFILLER_11_733 VPWR VGND sg13cmos5l_decap_8
XFILLER_10_232 VPWR VGND sg13cmos5l_decap_8
XFILLER_7_737 VPWR VGND sg13cmos5l_fill_1
XFILLER_11_777 VPWR VGND sg13cmos5l_fill_2
XFILLER_6_236 VPWR VGND sg13cmos5l_decap_8
XFILLER_3_954 VPWR VGND sg13cmos5l_decap_8
XFILLER_2_453 VPWR VGND sg13cmos5l_fill_2
XFILLER_49_61 VPWR VGND sg13cmos5l_decap_8
XFILLER_49_83 VPWR VGND sg13cmos5l_decap_8
XFILLER_46_652 VPWR VGND sg13cmos5l_decap_8
XFILLER_45_140 VPWR VGND sg13cmos5l_decap_8
XFILLER_34_825 VPWR VGND sg13cmos5l_decap_8
XFILLER_33_346 VPWR VGND sg13cmos5l_decap_8
XFILLER_34_847 VPWR VGND sg13cmos5l_decap_8
XFILLER_21_519 VPWR VGND sg13cmos5l_decap_8
XFILLER_33_357 VPWR VGND sg13cmos5l_fill_2
X_1971_ _3302_/D _1971_/A _1971_/B VPWR VGND sg13cmos5l_nand2_1
XFILLER_6_770 VPWR VGND sg13cmos5l_decap_8
X_2523_ _2621_/A _2521_/A _2521_/B _2522_/Y VPWR VGND sg13cmos5l_a21oi_1
XFILLER_5_291 VPWR VGND sg13cmos5l_decap_8
X_2454_ _2455_/B _3405_/Q _2459_/B _2440_/Y VPWR VGND sg13cmos5l_a21oi_1
X_2385_ _2385_/Y _2396_/B _3410_/Q _3409_/Q _2399_/B VPWR VGND sg13cmos5l_a22oi_1
Xinput1 input1/X rst_n VPWR VGND sg13cmos5l_buf_1
XFILLER_37_685 VPWR VGND sg13cmos5l_fill_2
XFILLER_37_663 VPWR VGND sg13cmos5l_decap_8
X_3006_ _3006_/Y _2881_/B _3005_/B _3005_/Y VPWR VGND sg13cmos5l_a21oi_1
XFILLER_24_324 VPWR VGND sg13cmos5l_decap_8
XFILLER_25_869 VPWR VGND sg13cmos5l_decap_8
XFILLER_36_173 VPWR VGND sg13cmos5l_decap_4
XFILLER_10_55 VPWR VGND sg13cmos5l_decap_8
X_3330__344 _3330_/RESET_B VPWR VGND sg13cmos5l_tiehi
XFILLER_0_924 VPWR VGND sg13cmos5l_decap_8
X_3467__188 _3467_/RESET_B VPWR VGND sg13cmos5l_tiehi
XFILLER_19_107 VPWR VGND sg13cmos5l_decap_8
XFILLER_19_118 VPWR VGND sg13cmos5l_fill_2
XFILLER_19_86 VPWR VGND sg13cmos5l_decap_8
XFILLER_16_825 VPWR VGND sg13cmos5l_fill_2
XFILLER_28_663 VPWR VGND sg13cmos5l_fill_2
XFILLER_43_622 VPWR VGND sg13cmos5l_decap_8
XFILLER_42_110 VPWR VGND sg13cmos5l_fill_2
XFILLER_15_335 VPWR VGND sg13cmos5l_decap_8
XFILLER_43_688 VPWR VGND sg13cmos5l_fill_2
XFILLER_30_316 VPWR VGND sg13cmos5l_decap_4
XFILLER_11_541 VPWR VGND sg13cmos5l_decap_8
XFILLER_7_567 VPWR VGND sg13cmos5l_decap_8
XFILLER_3_740 VPWR VGND sg13cmos5l_decap_8
XFILLER_3_751 VPWR VGND sg13cmos5l_decap_8
X_2170_ _2174_/A _2162_/D _2161_/B _2169_/Y VPWR VGND sg13cmos5l_a21o_1
XFILLER_20_1001 VPWR VGND sg13cmos5l_decap_8
XFILLER_47_983 VPWR VGND sg13cmos5l_decap_8
XFILLER_18_151 VPWR VGND sg13cmos5l_decap_4
XFILLER_19_652 VPWR VGND sg13cmos5l_fill_2
X_3307__379 _3307_/RESET_B VPWR VGND sg13cmos5l_tiehi
XFILLER_18_173 VPWR VGND sg13cmos5l_fill_2
XFILLER_14_390 VPWR VGND sg13cmos5l_fill_1
X_1954_ _3295_/D _1954_/A _1954_/B _1954_/C VPWR VGND sg13cmos5l_nor3_1
XFILLER_21_338 VPWR VGND sg13cmos5l_decap_8
XFILLER_30_850 VPWR VGND sg13cmos5l_decap_8
X_1885_ _1885_/Y _3246_/A _3228_/A VPWR VGND sg13cmos5l_nor2_1
XFILLER_30_894 VPWR VGND sg13cmos5l_decap_8
X_3486_ _3486_/Q _3504_/CLK _3486_/D _3486_/RESET_B VPWR VGND sg13cmos5l_dfrbpq_1
X_2506_ _2519_/S _2506_/A _2522_/B VPWR VGND sg13cmos5l_nor2_1
X_2437_ _2437_/Y _2348_/B _2382_/Y _2468_/A VPWR VGND sg13cmos5l_o21ai_1
X_2368_ _2368_/Y _2369_/A _2372_/B VPWR VGND sg13cmos5l_nand2b_1
X_3284__416 _3284_/RESET_B VPWR VGND sg13cmos5l_tiehi
X_2299_ _2299_/X _2299_/A _2299_/B _2299_/C VPWR VGND sg13cmos5l_or3_1
XFILLER_38_950 VPWR VGND sg13cmos5l_decap_8
XFILLER_25_622 VPWR VGND sg13cmos5l_decap_8
XFILLER_13_806 VPWR VGND sg13cmos5l_decap_8
XFILLER_24_121 VPWR VGND sg13cmos5l_decap_8
XFILLER_40_636 VPWR VGND sg13cmos5l_decap_8
XFILLER_13_839 VPWR VGND sg13cmos5l_decap_8
XFILLER_25_699 VPWR VGND sg13cmos5l_decap_8
XFILLER_21_850 VPWR VGND sg13cmos5l_decap_8
X_3291__409 _3291_/RESET_B VPWR VGND sg13cmos5l_tiehi
XFILLER_21_54 VPWR VGND sg13cmos5l_decap_8
XFILLER_4_559 VPWR VGND sg13cmos5l_decap_8
XFILLER_21_87 VPWR VGND sg13cmos5l_decap_4
XFILLER_0_721 VPWR VGND sg13cmos5l_decap_8
XFILLER_0_798 VPWR VGND sg13cmos5l_decap_8
XFILLER_48_747 VPWR VGND sg13cmos5l_decap_8
XFILLER_29_972 VPWR VGND sg13cmos5l_decap_8
XFILLER_35_408 VPWR VGND sg13cmos5l_decap_4
XFILLER_46_62 VPWR VGND sg13cmos5l_decap_8
XFILLER_44_931 VPWR VGND sg13cmos5l_decap_8
XFILLER_16_622 VPWR VGND sg13cmos5l_decap_8
XFILLER_15_143 VPWR VGND sg13cmos5l_decap_8
XFILLER_12_894 VPWR VGND sg13cmos5l_decap_8
XFILLER_8_876 VPWR VGND sg13cmos5l_decap_8
XFILLER_7_397 VPWR VGND sg13cmos5l_decap_8
X_3340_ _3340_/Q _3408_/CLK _3340_/D _3340_/RESET_B VPWR VGND sg13cmos5l_dfrbpq_1
Xheichips26_dna_sequencer_83 uio_out[1] VPWR VGND sg13cmos5l_tielo
X_3271_ _3271_/Q clkload8/A _3271_/D _3271_/RESET_B VPWR VGND sg13cmos5l_dfrbpq_1
X_2222_ _2222_/Y _2215_/Y _2216_/Y _2221_/Y VPWR VGND sg13cmos5l_o21ai_1
XFILLER_39_769 VPWR VGND sg13cmos5l_decap_8
X_2153_ _2153_/Y _3351_/Q _2158_/B VPWR VGND sg13cmos5l_nand2_1
XFILLER_38_246 VPWR VGND sg13cmos5l_decap_8
XFILLER_47_780 VPWR VGND sg13cmos5l_decap_8
X_2084_ _2086_/A _2084_/A _2084_/B _2084_/C _2084_/D VPWR VGND sg13cmos5l_nor4_1
X_3504__380 _3504_/RESET_B VPWR VGND sg13cmos5l_tiehi
XFILLER_35_986 VPWR VGND sg13cmos5l_decap_8
XFILLER_22_636 VPWR VGND sg13cmos5l_fill_2
XFILLER_22_647 VPWR VGND sg13cmos5l_fill_2
X_2986_ _3003_/A _3000_/A _3000_/B VPWR VGND sg13cmos5l_nand2_1
XFILLER_21_157 VPWR VGND sg13cmos5l_decap_8
X_1937_ _3287_/D input9/X hold524/X _1971_/A VPWR VGND sg13cmos5l_mux2_1
XFILLER_30_691 VPWR VGND sg13cmos5l_fill_1
X_1868_ _1868_/Y _3311_/Q _1868_/B VPWR VGND sg13cmos5l_nand2_1
X_1799_ _1799_/Y _3112_/B VPWR VGND sg13cmos5l_inv_1
X_3511__362 _3511_/RESET_B VPWR VGND sg13cmos5l_tiehi
X_3538_ _3538_/Q clkload2/A _3538_/D _3538_/RESET_B VPWR VGND sg13cmos5l_dfrbpq_1
XFILLER_27_1007 VPWR VGND sg13cmos5l_decap_8
X_3469_ _3469_/Q _3472_/CLK _3469_/D _3469_/RESET_B VPWR VGND sg13cmos5l_dfrbpq_1
XFILLER_29_224 VPWR VGND sg13cmos5l_decap_8
XFILLER_17_408 VPWR VGND sg13cmos5l_decap_4
XFILLER_29_279 VPWR VGND sg13cmos5l_decap_8
XFILLER_44_216 VPWR VGND sg13cmos5l_decap_4
XFILLER_44_249 VPWR VGND sg13cmos5l_fill_1
XFILLER_25_452 VPWR VGND sg13cmos5l_fill_1
XFILLER_26_964 VPWR VGND sg13cmos5l_decap_8
XFILLER_41_912 VPWR VGND sg13cmos5l_decap_8
XFILLER_13_614 VPWR VGND sg13cmos5l_decap_8
XFILLER_40_433 VPWR VGND sg13cmos5l_fill_1
XFILLER_13_636 VPWR VGND sg13cmos5l_decap_4
XFILLER_13_658 VPWR VGND sg13cmos5l_decap_4
XFILLER_41_989 VPWR VGND sg13cmos5l_decap_8
XFILLER_40_466 VPWR VGND sg13cmos5l_fill_1
XFILLER_40_455 VPWR VGND sg13cmos5l_decap_8
XFILLER_12_168 VPWR VGND sg13cmos5l_fill_2
XFILLER_8_139 VPWR VGND sg13cmos5l_decap_8
XFILLER_4_301 VPWR VGND sg13cmos5l_decap_8
XFILLER_5_868 VPWR VGND sg13cmos5l_decap_8
XFILLER_0_551 VPWR VGND sg13cmos5l_decap_8
XFILLER_36_706 VPWR VGND sg13cmos5l_fill_1
XFILLER_29_780 VPWR VGND sg13cmos5l_decap_8
XFILLER_29_791 VPWR VGND sg13cmos5l_fill_2
XFILLER_35_227 VPWR VGND sg13cmos5l_decap_4
XFILLER_16_441 VPWR VGND sg13cmos5l_decap_4
XFILLER_17_953 VPWR VGND sg13cmos5l_decap_8
XFILLER_32_901 VPWR VGND sg13cmos5l_decap_8
X_2840_ _2840_/Y _2819_/B _2844_/S _2786_/B VPWR VGND sg13cmos5l_o21ai_1
XFILLER_31_422 VPWR VGND sg13cmos5l_fill_1
XFILLER_32_978 VPWR VGND sg13cmos5l_decap_8
XFILLER_8_640 VPWR VGND sg13cmos5l_fill_1
XFILLER_12_691 VPWR VGND sg13cmos5l_fill_2
X_2771_ _2771_/Y _2760_/Y _2767_/Y _2770_/Y VPWR VGND sg13cmos5l_a21oi_1
XFILLER_8_651 VPWR VGND sg13cmos5l_decap_8
X_3323_ _3323_/Q clkload8/A _3323_/D _3323_/RESET_B VPWR VGND sg13cmos5l_dfrbpq_1
XFILLER_39_511 VPWR VGND sg13cmos5l_decap_8
X_3254_ _3255_/C _3541_/Q _3540_/Q _3548_/Q VPWR VGND sg13cmos5l_o21ai_1
X_2205_ _3358_/D _2307_/A _2289_/B VPWR VGND sg13cmos5l_nor2_1
XFILLER_39_555 VPWR VGND sg13cmos5l_decap_8
X_3185_ _3185_/Y _3186_/B VPWR VGND sg13cmos5l_inv_1
XFILLER_27_728 VPWR VGND sg13cmos5l_decap_8
X_2136_ _3342_/D _2601_/A _2136_/B VPWR VGND sg13cmos5l_and2_1
X_2067_ _2067_/Y _3311_/Q _2067_/B VPWR VGND sg13cmos5l_nor2_1
XFILLER_26_238 VPWR VGND sg13cmos5l_fill_1
XFILLER_23_912 VPWR VGND sg13cmos5l_fill_1
XFILLER_35_783 VPWR VGND sg13cmos5l_decap_8
XFILLER_22_411 VPWR VGND sg13cmos5l_decap_4
XFILLER_10_617 VPWR VGND sg13cmos5l_decap_8
XFILLER_22_455 VPWR VGND sg13cmos5l_decap_8
XFILLER_23_989 VPWR VGND sg13cmos5l_decap_8
X_2969_ _2969_/Y _2969_/A _2971_/B VPWR VGND sg13cmos5l_nor2_1
XFILLER_33_1022 VPWR VGND sg13cmos5l_decap_8
XFILLER_2_805 VPWR VGND sg13cmos5l_decap_8
Xhold651 _2021_/A _3316_/Q VPWR VGND sg13cmos5l_dlygate4sd3_1
Xhold662 _2165_/A _3350_/Q VPWR VGND sg13cmos5l_dlygate4sd3_1
Xhold640 hold640/X _3394_/Q VPWR VGND sg13cmos5l_dlygate4sd3_1
XFILLER_1_359 VPWR VGND sg13cmos5l_fill_1
Xhold673 _2815_/A _3469_/Q VPWR VGND sg13cmos5l_dlygate4sd3_1
Xhold695 _1838_/A _3442_/Q VPWR VGND sg13cmos5l_dlygate4sd3_1
Xhold684 hold684/X _2653_/A VPWR VGND sg13cmos5l_dlygate4sd3_1
XFILLER_17_205 VPWR VGND sg13cmos5l_decap_8
XFILLER_27_42 VPWR VGND sg13cmos5l_decap_8
XFILLER_45_547 VPWR VGND sg13cmos5l_decap_8
XFILLER_26_750 VPWR VGND sg13cmos5l_decap_8
XFILLER_27_86 VPWR VGND sg13cmos5l_decap_8
XFILLER_14_901 VPWR VGND sg13cmos5l_decap_8
XFILLER_25_260 VPWR VGND sg13cmos5l_decap_8
XFILLER_26_761 VPWR VGND sg13cmos5l_decap_8
XFILLER_32_219 VPWR VGND sg13cmos5l_decap_4
XFILLER_41_720 VPWR VGND sg13cmos5l_decap_4
XFILLER_25_293 VPWR VGND sg13cmos5l_decap_4
XFILLER_5_632 VPWR VGND sg13cmos5l_decap_8
XFILLER_4_186 VPWR VGND sg13cmos5l_decap_8
XFILLER_4_79 VPWR VGND sg13cmos5l_fill_2
XFILLER_49_820 VPWR VGND sg13cmos5l_decap_8
XFILLER_0_370 VPWR VGND sg13cmos5l_decap_8
XFILLER_1_893 VPWR VGND sg13cmos5l_decap_8
XFILLER_49_897 VPWR VGND sg13cmos5l_decap_8
XFILLER_36_514 VPWR VGND sg13cmos5l_decap_8
XFILLER_17_750 VPWR VGND sg13cmos5l_decap_4
XFILLER_24_709 VPWR VGND sg13cmos5l_decap_8
XFILLER_31_241 VPWR VGND sg13cmos5l_decap_8
X_2823_ _2824_/C _2823_/A _2823_/B _2823_/C VPWR VGND sg13cmos5l_and3_1
XFILLER_20_937 VPWR VGND sg13cmos5l_fill_2
XFILLER_32_786 VPWR VGND sg13cmos5l_decap_8
X_2754_ _2754_/Y _2754_/A _2971_/A _2754_/C VPWR VGND sg13cmos5l_nand3_1
X_2685_ _2685_/Y _3446_/Q _3447_/Q VPWR VGND sg13cmos5l_xnor2_1
X_3306_ _3306_/Q _3539_/CLK _3306_/D _3306_/RESET_B VPWR VGND sg13cmos5l_dfrbpq_1
X_3237_ _3237_/Y _3237_/A _3237_/B VPWR VGND sg13cmos5l_nand2_1
XFILLER_39_363 VPWR VGND sg13cmos5l_decap_4
X_3168_ _3168_/Y _3168_/A _3183_/B VPWR VGND sg13cmos5l_nand2_1
X_2119_ _2119_/Y _3319_/Q _2265_/A _2123_/B _1818_/Y _2118_/Y VPWR VGND sg13cmos5l_a221oi_1
XFILLER_27_547 VPWR VGND sg13cmos5l_decap_8
XFILLER_42_506 VPWR VGND sg13cmos5l_decap_8
X_3099_ _3099_/Y _1801_/Y _3093_/A _3094_/Y _3090_/Y _3098_/Y VPWR VGND sg13cmos5l_a221oi_1
Xfanout56 _2123_/B hold706/X VPWR VGND sg13cmos5l_buf_1
XFILLER_11_915 VPWR VGND sg13cmos5l_decap_8
Xfanout45 _2479_/A _2432_/B VPWR VGND sg13cmos5l_buf_1
Xfanout23 _2140_/A2 _3119_/A2 VPWR VGND sg13cmos5l_buf_1
Xfanout34 _2349_/B _2548_/A VPWR VGND sg13cmos5l_buf_1
XFILLER_13_11 VPWR VGND sg13cmos5l_decap_4
XFILLER_22_285 VPWR VGND sg13cmos5l_fill_1
Xfanout67 _2776_/A _2179_/B VPWR VGND sg13cmos5l_buf_1
XFILLER_13_55 VPWR VGND sg13cmos5l_decap_8
XFILLER_8_4 VPWR VGND sg13cmos5l_decap_4
Xhold481 _3399_/D _2421_/Y VPWR VGND sg13cmos5l_dlygate4sd3_1
Xhold470 hold470/X _3310_/Q VPWR VGND sg13cmos5l_dlygate4sd3_1
XFILLER_2_668 VPWR VGND sg13cmos5l_decap_8
Xhold492 _2966_/B _3467_/Q VPWR VGND sg13cmos5l_dlygate4sd3_1
XFILLER_18_525 VPWR VGND sg13cmos5l_decap_8
XFILLER_46_878 VPWR VGND sg13cmos5l_decap_8
XFILLER_45_333 VPWR VGND sg13cmos5l_fill_1
XFILLER_14_731 VPWR VGND sg13cmos5l_decap_8
XFILLER_14_742 VPWR VGND sg13cmos5l_fill_1
XFILLER_14_753 VPWR VGND sg13cmos5l_fill_1
XFILLER_14_764 VPWR VGND sg13cmos5l_decap_8
XFILLER_13_263 VPWR VGND sg13cmos5l_decap_8
XFILLER_13_274 VPWR VGND sg13cmos5l_fill_1
XFILLER_9_256 VPWR VGND sg13cmos5l_decap_8
XFILLER_6_930 VPWR VGND sg13cmos5l_decap_8
Xclkload15 clkload15/Y _3527_/CLK VPWR VGND sg13cmos5l_inv_2
X_2470_ _2474_/A _2470_/A _2470_/B VPWR VGND sg13cmos5l_or2_1
XFILLER_1_690 VPWR VGND sg13cmos5l_decap_8
XFILLER_49_661 VPWR VGND sg13cmos5l_decap_4
XFILLER_23_1010 VPWR VGND sg13cmos5l_decap_8
X_3022_ _3506_/D _2999_/X _3017_/Y _3021_/Y VPWR VGND sg13cmos5l_a21oi_1
XFILLER_17_591 VPWR VGND sg13cmos5l_decap_8
XFILLER_32_583 VPWR VGND sg13cmos5l_decap_8
Xclkload9 clkload9/Y clkload9/A VPWR VGND sg13cmos5l_inv_2
XFILLER_9_790 VPWR VGND sg13cmos5l_decap_8
X_2806_ _2823_/C _2806_/A _2820_/B VPWR VGND sg13cmos5l_xnor2_1
XFILLER_30_1025 VPWR VGND sg13cmos5l_decap_4
X_2737_ _2737_/Y _2737_/A _2737_/B _2737_/C VPWR VGND sg13cmos5l_nor3_1
X_2668_ _2668_/Y _2653_/B _2672_/S _2615_/B VPWR VGND sg13cmos5l_o21ai_1
X_2599_ _2599_/Y _2599_/A _2599_/B VPWR VGND sg13cmos5l_nand2_1
XFILLER_28_834 VPWR VGND sg13cmos5l_decap_8
XFILLER_28_889 VPWR VGND sg13cmos5l_decap_8
XFILLER_43_848 VPWR VGND sg13cmos5l_fill_1
XFILLER_42_325 VPWR VGND sg13cmos5l_decap_8
XFILLER_24_32 VPWR VGND sg13cmos5l_fill_1
XFILLER_7_716 VPWR VGND sg13cmos5l_fill_1
XFILLER_7_705 VPWR VGND sg13cmos5l_decap_8
XFILLER_40_42 VPWR VGND sg13cmos5l_fill_1
XFILLER_3_933 VPWR VGND sg13cmos5l_decap_8
XFILLER_2_432 VPWR VGND sg13cmos5l_fill_1
XFILLER_1_14 VPWR VGND sg13cmos5l_decap_8
XFILLER_1_25 VPWR VGND sg13cmos5l_fill_1
X_3483__172 _3483_/RESET_B VPWR VGND sg13cmos5l_tiehi
XFILLER_18_300 VPWR VGND sg13cmos5l_decap_8
XFILLER_46_642 VPWR VGND sg13cmos5l_decap_4
XFILLER_19_867 VPWR VGND sg13cmos5l_decap_8
XFILLER_18_388 VPWR VGND sg13cmos5l_decap_8
X_1970_ _1971_/B _1914_/A _1970_/B VPWR VGND sg13cmos5l_nand2b_1
X_2522_ _2522_/Y _2522_/A _2522_/B VPWR VGND sg13cmos5l_nor2_1
XFILLER_5_270 VPWR VGND sg13cmos5l_decap_8
X_2453_ _2465_/B _2448_/A _2459_/B _2452_/Y VPWR VGND sg13cmos5l_a21oi_1
X_2384_ _2384_/Y _3366_/Q _2613_/A VPWR VGND sg13cmos5l_nor2_1
Xinput2 input2/X ui_in[0] VPWR VGND sg13cmos5l_buf_1
XFILLER_37_620 VPWR VGND sg13cmos5l_decap_8
X_3005_ _3005_/Y _3005_/A _3005_/B VPWR VGND sg13cmos5l_nor2_1
X_3323__352 _3323_/RESET_B VPWR VGND sg13cmos5l_tiehi
XFILLER_25_848 VPWR VGND sg13cmos5l_fill_2
XFILLER_40_818 VPWR VGND sg13cmos5l_decap_8
XFILLER_33_892 VPWR VGND sg13cmos5l_fill_1
XFILLER_10_34 VPWR VGND sg13cmos5l_decap_8
XFILLER_3_229 VPWR VGND sg13cmos5l_fill_2
XFILLER_10_78 VPWR VGND sg13cmos5l_decap_8
XFILLER_0_903 VPWR VGND sg13cmos5l_decap_8
XFILLER_48_929 VPWR VGND sg13cmos5l_decap_8
XFILLER_19_76 VPWR VGND sg13cmos5l_decap_4
XFILLER_15_314 VPWR VGND sg13cmos5l_fill_2
XFILLER_35_20 VPWR VGND sg13cmos5l_fill_2
XFILLER_35_53 VPWR VGND sg13cmos5l_decap_4
XFILLER_30_328 VPWR VGND sg13cmos5l_decap_4
XFILLER_11_520 VPWR VGND sg13cmos5l_decap_8
XFILLER_7_502 VPWR VGND sg13cmos5l_fill_1
XFILLER_2_262 VPWR VGND sg13cmos5l_decap_8
XFILLER_38_428 VPWR VGND sg13cmos5l_fill_1
XFILLER_19_642 VPWR VGND sg13cmos5l_decap_4
XFILLER_47_962 VPWR VGND sg13cmos5l_decap_8
XFILLER_34_623 VPWR VGND sg13cmos5l_decap_4
XFILLER_33_155 VPWR VGND sg13cmos5l_decap_4
X_1953_ _1954_/C _1988_/B _1953_/B VPWR VGND sg13cmos5l_nor2_1
XFILLER_30_840 VPWR VGND sg13cmos5l_decap_4
X_1884_ _3228_/A _3545_/Q _1884_/B VPWR VGND sg13cmos5l_nand2_1
X_3485_ _3485_/Q _3485_/CLK _3485_/D _3485_/RESET_B VPWR VGND sg13cmos5l_dfrbpq_1
X_2505_ _2513_/C _3418_/Q _2505_/B VPWR VGND sg13cmos5l_xnor2_1
X_2436_ _2436_/Y _2348_/B _2382_/Y _2435_/Y VPWR VGND sg13cmos5l_a21oi_1
X_2367_ _2367_/Y _2364_/A _2364_/B _2363_/X _2183_/Y VPWR VGND sg13cmos5l_a22oi_1
X_2298_ _2299_/C _2298_/A _2294_/Y VPWR VGND sg13cmos5l_nor2b_1
XFILLER_29_439 VPWR VGND sg13cmos5l_fill_1
XFILLER_25_601 VPWR VGND sg13cmos5l_decap_8
XFILLER_37_494 VPWR VGND sg13cmos5l_fill_2
XFILLER_25_667 VPWR VGND sg13cmos5l_fill_1
XFILLER_25_678 VPWR VGND sg13cmos5l_decap_8
XFILLER_21_840 VPWR VGND sg13cmos5l_fill_1
XFILLER_24_199 VPWR VGND sg13cmos5l_decap_4
XFILLER_21_11 VPWR VGND sg13cmos5l_decap_8
XFILLER_21_895 VPWR VGND sg13cmos5l_fill_1
X_3473__182 _3473_/RESET_B VPWR VGND sg13cmos5l_tiehi
XFILLER_0_700 VPWR VGND sg13cmos5l_decap_8
XFILLER_48_726 VPWR VGND sg13cmos5l_decap_8
XFILLER_0_777 VPWR VGND sg13cmos5l_decap_8
XFILLER_47_225 VPWR VGND sg13cmos5l_decap_8
X_3480__175 _3480_/RESET_B VPWR VGND sg13cmos5l_tiehi
XFILLER_29_951 VPWR VGND sg13cmos5l_decap_8
XFILLER_44_910 VPWR VGND sg13cmos5l_decap_8
XFILLER_16_656 VPWR VGND sg13cmos5l_decap_4
XFILLER_44_987 VPWR VGND sg13cmos5l_decap_8
XFILLER_43_486 VPWR VGND sg13cmos5l_fill_1
XFILLER_43_475 VPWR VGND sg13cmos5l_decap_4
XFILLER_15_177 VPWR VGND sg13cmos5l_decap_8
XFILLER_31_626 VPWR VGND sg13cmos5l_decap_8
XFILLER_30_136 VPWR VGND sg13cmos5l_decap_4
XFILLER_12_851 VPWR VGND sg13cmos5l_decap_8
XFILLER_12_873 VPWR VGND sg13cmos5l_decap_8
XFILLER_8_855 VPWR VGND sg13cmos5l_decap_8
XFILLER_7_79 VPWR VGND sg13cmos5l_decap_8
Xheichips26_dna_sequencer_84 uio_out[2] VPWR VGND sg13cmos5l_tielo
X_3270_ _3270_/Q clkload9/A _3270_/D _3270_/RESET_B VPWR VGND sg13cmos5l_dfrbpq_1
XFILLER_3_582 VPWR VGND sg13cmos5l_decap_8
XFILLER_3_560 VPWR VGND sg13cmos5l_decap_8
X_2221_ _2221_/Y _2221_/A _2211_/Y VPWR VGND sg13cmos5l_nor2b_1
XFILLER_23_4 VPWR VGND sg13cmos5l_decap_4
XFILLER_39_748 VPWR VGND sg13cmos5l_decap_8
X_2152_ _2160_/A _2152_/A _2158_/B VPWR VGND sg13cmos5l_or2_1
XFILLER_38_214 VPWR VGND sg13cmos5l_decap_8
XFILLER_19_450 VPWR VGND sg13cmos5l_decap_4
X_2083_ _2084_/D _2083_/A _2083_/B VPWR VGND sg13cmos5l_xnor2_1
XFILLER_19_494 VPWR VGND sg13cmos5l_decap_8
XFILLER_34_442 VPWR VGND sg13cmos5l_decap_4
XFILLER_35_965 VPWR VGND sg13cmos5l_decap_8
XFILLER_22_615 VPWR VGND sg13cmos5l_decap_8
XFILLER_34_475 VPWR VGND sg13cmos5l_decap_8
XFILLER_21_136 VPWR VGND sg13cmos5l_decap_8
X_2985_ _2994_/A _3504_/Q _3000_/B VPWR VGND sg13cmos5l_nor2_1
X_3418__106 _3418_/D VPWR VGND sg13cmos5l_tielo
X_1936_ _3286_/D input8/X hold517/X _1971_/A VPWR VGND sg13cmos5l_mux2_1
X_3290__410 _3290_/RESET_B VPWR VGND sg13cmos5l_tiehi
X_1867_ _1869_/C _1867_/A _1868_/B VPWR VGND sg13cmos5l_and2_1
X_1798_ _3112_/A _1798_/A VPWR VGND sg13cmos5l_inv_1
X_3537_ _3537_/Q clkload2/A _3537_/D _3537_/RESET_B VPWR VGND sg13cmos5l_dfrbpq_1
X_3468_ _3468_/Q _3472_/CLK _3468_/D _3468_/RESET_B VPWR VGND sg13cmos5l_dfrbpq_1
X_2419_ _3398_/D _2776_/A _2419_/B VPWR VGND sg13cmos5l_and2_1
XFILLER_29_203 VPWR VGND sg13cmos5l_fill_2
X_3399_ _3399_/Q _3551_/CLK _3399_/D _3399_/RESET_B VPWR VGND sg13cmos5l_dfrbpq_1
XFILLER_25_420 VPWR VGND sg13cmos5l_decap_8
XFILLER_26_943 VPWR VGND sg13cmos5l_decap_8
XFILLER_16_77 VPWR VGND sg13cmos5l_decap_4
XFILLER_41_968 VPWR VGND sg13cmos5l_decap_8
XFILLER_40_412 VPWR VGND sg13cmos5l_fill_1
XFILLER_12_136 VPWR VGND sg13cmos5l_decap_8
XFILLER_8_118 VPWR VGND sg13cmos5l_decap_8
XFILLER_32_43 VPWR VGND sg13cmos5l_decap_4
XFILLER_20_180 VPWR VGND sg13cmos5l_decap_8
XFILLER_5_847 VPWR VGND sg13cmos5l_decap_8
XFILLER_4_357 VPWR VGND sg13cmos5l_fill_2
XFILLER_4_379 VPWR VGND sg13cmos5l_fill_2
XFILLER_17_932 VPWR VGND sg13cmos5l_decap_8
XFILLER_44_784 VPWR VGND sg13cmos5l_decap_8
XFILLER_43_294 VPWR VGND sg13cmos5l_fill_2
XFILLER_16_486 VPWR VGND sg13cmos5l_decap_8
XFILLER_32_957 VPWR VGND sg13cmos5l_decap_8
X_2770_ _2770_/Y _2930_/B _2767_/Y _2786_/B VPWR VGND sg13cmos5l_o21ai_1
X_3534__396 _3534_/RESET_B VPWR VGND sg13cmos5l_tiehi
X_3322_ _3322_/Q _3551_/CLK _3322_/D _3322_/RESET_B VPWR VGND sg13cmos5l_dfrbpq_1
X_3253_ _3541_/D _3253_/A _3253_/B VPWR VGND sg13cmos5l_nor2_1
X_2204_ _2289_/B hold730/X _2373_/C _2203_/B _1845_/A _2202_/Y VPWR VGND sg13cmos5l_a221oi_1
XFILLER_39_534 VPWR VGND sg13cmos5l_decap_8
X_3184_ _3186_/B _2849_/Y _3183_/Y _3184_/S VPWR VGND sg13cmos5l_mux2_1
X_2135_ _3340_/D _2100_/Y hold625/X _2176_/A VPWR VGND sg13cmos5l_a21oi_1
X_2066_ _2067_/B _3285_/Q _3268_/Q _3287_/Q _3270_/Q _2063_/A _1868_/B VPWR VGND sg13cmos5l_mux4_1
XFILLER_35_762 VPWR VGND sg13cmos5l_decap_8
X_3539__230 _3539_/RESET_B VPWR VGND sg13cmos5l_tiehi
XFILLER_22_434 VPWR VGND sg13cmos5l_decap_8
XFILLER_23_968 VPWR VGND sg13cmos5l_decap_8
XFILLER_33_1001 VPWR VGND sg13cmos5l_decap_8
X_2968_ _3501_/D _2968_/A _2968_/B VPWR VGND sg13cmos5l_nor2_1
X_1919_ _3271_/D input10/X hold530/X _1923_/S VPWR VGND sg13cmos5l_mux2_1
X_2899_ _2899_/X _2896_/X _2898_/Y _2894_/Y VPWR VGND sg13cmos5l_a21o_1
Xhold630 _1850_/A _3339_/Q VPWR VGND sg13cmos5l_dlygate4sd3_1
X_3470__185 _3470_/RESET_B VPWR VGND sg13cmos5l_tiehi
Xhold663 _2175_/A _2166_/Y VPWR VGND sg13cmos5l_dlygate4sd3_1
Xhold641 _2414_/B _2413_/Y VPWR VGND sg13cmos5l_dlygate4sd3_1
Xhold652 _2645_/A _3436_/Q VPWR VGND sg13cmos5l_dlygate4sd3_1
Xhold696 _1843_/A _3474_/Q VPWR VGND sg13cmos5l_dlygate4sd3_1
Xhold674 _2816_/B _2815_/Y VPWR VGND sg13cmos5l_dlygate4sd3_1
Xhold685 _1987_/B _3543_/Q VPWR VGND sg13cmos5l_dlygate4sd3_1
XFILLER_18_707 VPWR VGND sg13cmos5l_decap_4
XFILLER_18_718 VPWR VGND sg13cmos5l_decap_8
XFILLER_45_526 VPWR VGND sg13cmos5l_fill_2
XFILLER_45_515 VPWR VGND sg13cmos5l_decap_8
XFILLER_27_21 VPWR VGND sg13cmos5l_decap_8
XFILLER_14_913 VPWR VGND sg13cmos5l_decap_8
XFILLER_40_220 VPWR VGND sg13cmos5l_decap_8
XFILLER_40_231 VPWR VGND sg13cmos5l_fill_1
XFILLER_14_979 VPWR VGND sg13cmos5l_decap_8
XFILLER_41_787 VPWR VGND sg13cmos5l_fill_2
XFILLER_4_14 VPWR VGND sg13cmos5l_fill_2
XFILLER_1_872 VPWR VGND sg13cmos5l_decap_8
XFILLER_49_876 VPWR VGND sg13cmos5l_decap_8
XFILLER_36_526 VPWR VGND sg13cmos5l_decap_8
XFILLER_36_559 VPWR VGND sg13cmos5l_decap_8
XFILLER_23_209 VPWR VGND sg13cmos5l_decap_8
XFILLER_44_581 VPWR VGND sg13cmos5l_decap_8
XFILLER_32_765 VPWR VGND sg13cmos5l_decap_8
X_2822_ _2822_/X _2822_/A _2838_/A VPWR VGND sg13cmos5l_or2_1
X_2753_ _2753_/Y _2753_/A _2753_/B VPWR VGND sg13cmos5l_nand2_1
X_2684_ _2684_/X _3446_/Q _2684_/B VPWR VGND sg13cmos5l_xor2_1
X_3305_ _3305_/Q clkload2/A _3305_/D _3305_/RESET_B VPWR VGND sg13cmos5l_dfrbpq_1
XFILLER_39_342 VPWR VGND sg13cmos5l_decap_8
X_3236_ _3538_/D _3257_/A _3236_/B VPWR VGND sg13cmos5l_nor2_1
X_3167_ _3167_/Y _3158_/X _3162_/Y _3165_/Y _2879_/B _3166_/Y VPWR VGND sg13cmos5l_a221oi_1
XFILLER_27_526 VPWR VGND sg13cmos5l_decap_8
X_2118_ _2118_/Y _3317_/Q _2118_/B VPWR VGND sg13cmos5l_nor2_1
X_3098_ _3098_/Y _3519_/Q _3098_/B VPWR VGND sg13cmos5l_nor2_1
X_2049_ _2049_/X _3276_/Q _3259_/Q _3278_/Q _3261_/Q _2063_/A _1868_/B VPWR VGND sg13cmos5l_mux4_1
XFILLER_23_732 VPWR VGND sg13cmos5l_decap_8
Xfanout35 _3223_/A _3028_/Y VPWR VGND sg13cmos5l_buf_1
XFILLER_22_231 VPWR VGND sg13cmos5l_fill_2
XFILLER_23_776 VPWR VGND sg13cmos5l_fill_2
Xfanout46 _2432_/B _2311_/Y VPWR VGND sg13cmos5l_buf_1
Xfanout24 _3119_/A2 _3120_/A2 VPWR VGND sg13cmos5l_buf_1
XFILLER_10_404 VPWR VGND sg13cmos5l_fill_1
Xfanout68 _2608_/A _2179_/B VPWR VGND sg13cmos5l_buf_1
Xfanout57 _1868_/B hold470/X VPWR VGND sg13cmos5l_buf_1
XFILLER_6_419 VPWR VGND sg13cmos5l_decap_8
XFILLER_2_614 VPWR VGND sg13cmos5l_decap_4
XFILLER_1_124 VPWR VGND sg13cmos5l_fill_2
Xhold460 _1945_/A _3309_/Q VPWR VGND sg13cmos5l_dlygate4sd3_1
Xhold471 _2013_/C _2012_/Y VPWR VGND sg13cmos5l_dlygate4sd3_1
Xhold482 _1809_/A _3430_/Q VPWR VGND sg13cmos5l_dlygate4sd3_1
Xhold493 _1987_/A _3544_/Q VPWR VGND sg13cmos5l_dlygate4sd3_1
XFILLER_38_31 VPWR VGND sg13cmos5l_decap_4
XFILLER_46_857 VPWR VGND sg13cmos5l_decap_8
XFILLER_33_518 VPWR VGND sg13cmos5l_decap_8
XFILLER_14_710 VPWR VGND sg13cmos5l_decap_8
XFILLER_26_581 VPWR VGND sg13cmos5l_decap_8
XFILLER_41_595 VPWR VGND sg13cmos5l_fill_1
XFILLER_10_982 VPWR VGND sg13cmos5l_decap_8
Xclkload16 clkload16/Y _3463_/CLK VPWR VGND sg13cmos5l_inv_2
XFILLER_6_986 VPWR VGND sg13cmos5l_decap_8
XFILLER_49_640 VPWR VGND sg13cmos5l_decap_8
XFILLER_0_190 VPWR VGND sg13cmos5l_decap_8
XFILLER_37_813 VPWR VGND sg13cmos5l_decap_8
X_3021_ _3021_/Y _2998_/Y _3017_/Y _2970_/B VPWR VGND sg13cmos5l_o21ai_1
XFILLER_49_695 VPWR VGND sg13cmos5l_decap_4
XFILLER_37_868 VPWR VGND sg13cmos5l_decap_8
XFILLER_37_846 VPWR VGND sg13cmos5l_decap_8
XFILLER_17_581 VPWR VGND sg13cmos5l_fill_2
X_2805_ _2823_/B _3464_/Q _3435_/Q _3469_/Q VPWR VGND sg13cmos5l_nand3_1
XFILLER_20_735 VPWR VGND sg13cmos5l_fill_2
XFILLER_30_1004 VPWR VGND sg13cmos5l_decap_8
X_2736_ _3452_/D _2839_/A _2736_/B VPWR VGND sg13cmos5l_nor2_1
X_2667_ _3441_/D _2667_/A _2667_/B _2667_/C VPWR VGND sg13cmos5l_nor3_1
X_2598_ _2598_/Y _2598_/A _2598_/B VPWR VGND sg13cmos5l_nor2_1
XFILLER_8_1027 VPWR VGND sg13cmos5l_fill_2
XFILLER_8_1016 VPWR VGND sg13cmos5l_decap_8
X_3219_ _3532_/D _3194_/X _3222_/S _3218_/Y VPWR VGND sg13cmos5l_a21oi_1
XFILLER_28_813 VPWR VGND sg13cmos5l_fill_2
XFILLER_24_11 VPWR VGND sg13cmos5l_decap_8
XFILLER_11_702 VPWR VGND sg13cmos5l_decap_4
XFILLER_11_713 VPWR VGND sg13cmos5l_fill_1
XFILLER_23_584 VPWR VGND sg13cmos5l_fill_2
XFILLER_10_212 VPWR VGND sg13cmos5l_fill_1
XFILLER_24_77 VPWR VGND sg13cmos5l_decap_8
XFILLER_11_779 VPWR VGND sg13cmos5l_fill_1
XFILLER_40_54 VPWR VGND sg13cmos5l_decap_8
XFILLER_3_912 VPWR VGND sg13cmos5l_decap_8
XFILLER_46_1011 VPWR VGND sg13cmos5l_decap_8
XFILLER_3_989 VPWR VGND sg13cmos5l_decap_8
XFILLER_2_455 VPWR VGND sg13cmos5l_fill_1
XFILLER_2_488 VPWR VGND sg13cmos5l_decap_8
XFILLER_46_621 VPWR VGND sg13cmos5l_decap_8
XFILLER_18_356 VPWR VGND sg13cmos5l_decap_8
XFILLER_33_315 VPWR VGND sg13cmos5l_decap_4
XFILLER_14_540 VPWR VGND sg13cmos5l_decap_4
XFILLER_42_882 VPWR VGND sg13cmos5l_decap_8
XFILLER_14_573 VPWR VGND sg13cmos5l_fill_2
X_2521_ _2521_/Y _2521_/A _2521_/B VPWR VGND sg13cmos5l_nand2_1
XFILLER_6_783 VPWR VGND sg13cmos5l_decap_8
X_2452_ _2452_/Y _2468_/B _2451_/Y VPWR VGND sg13cmos5l_nor2b_1
X_2383_ _3390_/D _2383_/A hold713/X VPWR VGND sg13cmos5l_nor2b_1
XFILLER_49_492 VPWR VGND sg13cmos5l_decap_8
X_3004_ _3004_/Y _3004_/A _3012_/A _3004_/C VPWR VGND sg13cmos5l_nor3_1
Xinput3 input3/X ui_in[1] VPWR VGND sg13cmos5l_buf_1
XFILLER_36_142 VPWR VGND sg13cmos5l_decap_8
XFILLER_25_827 VPWR VGND sg13cmos5l_decap_8
X_2719_ _2720_/B _3441_/Q _3419_/Q _3420_/Q VPWR VGND sg13cmos5l_nor3_1
XFILLER_48_908 VPWR VGND sg13cmos5l_decap_8
XFILLER_0_959 VPWR VGND sg13cmos5l_decap_8
XFILLER_19_11 VPWR VGND sg13cmos5l_decap_8
XFILLER_19_22 VPWR VGND sg13cmos5l_fill_2
XFILLER_47_429 VPWR VGND sg13cmos5l_decap_8
XFILLER_28_643 VPWR VGND sg13cmos5l_fill_2
XFILLER_28_676 VPWR VGND sg13cmos5l_decap_8
XFILLER_42_112 VPWR VGND sg13cmos5l_fill_1
XFILLER_16_849 VPWR VGND sg13cmos5l_decap_8
XFILLER_27_186 VPWR VGND sg13cmos5l_decap_8
XFILLER_42_134 VPWR VGND sg13cmos5l_fill_2
XFILLER_42_123 VPWR VGND sg13cmos5l_fill_2
XFILLER_42_156 VPWR VGND sg13cmos5l_decap_8
XFILLER_42_189 VPWR VGND sg13cmos5l_fill_2
XFILLER_23_392 VPWR VGND sg13cmos5l_decap_8
XFILLER_13_1010 VPWR VGND sg13cmos5l_decap_8
XFILLER_3_786 VPWR VGND sg13cmos5l_decap_8
XFILLER_39_919 VPWR VGND sg13cmos5l_decap_8
XFILLER_47_941 VPWR VGND sg13cmos5l_decap_8
XFILLER_18_142 VPWR VGND sg13cmos5l_fill_2
XFILLER_46_473 VPWR VGND sg13cmos5l_fill_1
XFILLER_34_602 VPWR VGND sg13cmos5l_decap_8
XFILLER_33_112 VPWR VGND sg13cmos5l_decap_8
XFILLER_15_871 VPWR VGND sg13cmos5l_fill_2
XFILLER_21_307 VPWR VGND sg13cmos5l_decap_8
X_1952_ _1954_/B input4/X hold594/X _3028_/B VPWR VGND sg13cmos5l_o21ai_1
X_1883_ _1996_/A _3545_/Q _1883_/B VPWR VGND sg13cmos5l_nand2_1
XFILLER_30_885 VPWR VGND sg13cmos5l_decap_4
XFILLER_6_591 VPWR VGND sg13cmos5l_decap_4
X_3484_ _3484_/Q _3485_/CLK _3484_/D _3484_/RESET_B VPWR VGND sg13cmos5l_dfrbpq_1
X_2504_ _2522_/B _2504_/A _2505_/B VPWR VGND sg13cmos5l_xor2_1
X_2435_ _2435_/Y _2433_/A _2433_/B _2433_/C _2433_/D VPWR VGND sg13cmos5l_a22oi_1
X_2366_ _2366_/Y _2359_/Y _2361_/Y _2365_/X VPWR VGND sg13cmos5l_o21ai_1
XFILLER_5_1008 VPWR VGND sg13cmos5l_decap_8
X_2297_ _2299_/B _2220_/B _2296_/B _2296_/Y VPWR VGND sg13cmos5l_a21oi_1
XFILLER_2_80 VPWR VGND sg13cmos5l_decap_4
XFILLER_38_985 VPWR VGND sg13cmos5l_decap_8
XFILLER_25_657 VPWR VGND sg13cmos5l_decap_4
XFILLER_24_178 VPWR VGND sg13cmos5l_decap_8
XFILLER_33_690 VPWR VGND sg13cmos5l_fill_1
XFILLER_43_1014 VPWR VGND sg13cmos5l_decap_8
XFILLER_0_756 VPWR VGND sg13cmos5l_decap_8
X_3545__129 _3545_/RESET_B VPWR VGND sg13cmos5l_tiehi
XFILLER_47_204 VPWR VGND sg13cmos5l_decap_8
XFILLER_29_930 VPWR VGND sg13cmos5l_decap_8
XFILLER_46_42 VPWR VGND sg13cmos5l_decap_8
XFILLER_44_966 VPWR VGND sg13cmos5l_decap_8
XFILLER_15_112 VPWR VGND sg13cmos5l_decap_4
X_3306__381 _3306_/RESET_B VPWR VGND sg13cmos5l_tiehi
XFILLER_30_159 VPWR VGND sg13cmos5l_decap_4
XFILLER_8_834 VPWR VGND sg13cmos5l_decap_8
XFILLER_7_300 VPWR VGND sg13cmos5l_decap_8
XFILLER_7_388 VPWR VGND sg13cmos5l_decap_4
Xheichips26_dna_sequencer_85 uio_out[3] VPWR VGND sg13cmos5l_tielo
X_2220_ _3360_/D _2264_/B _2220_/B VPWR VGND sg13cmos5l_and2_1
XFILLER_39_727 VPWR VGND sg13cmos5l_decap_8
XFILLER_16_4 VPWR VGND sg13cmos5l_decap_4
X_2151_ _2158_/B _2149_/Y _2150_/Y _2164_/A VPWR VGND sg13cmos5l_a21oi_1
X_2082_ _2084_/C _2082_/A _2082_/B VPWR VGND sg13cmos5l_xnor2_1
XFILLER_46_270 VPWR VGND sg13cmos5l_decap_8
XFILLER_35_944 VPWR VGND sg13cmos5l_decap_8
X_2984_ _3015_/B _2982_/Y _2983_/Y _2981_/Y VPWR VGND sg13cmos5l_a21oi_1
XFILLER_21_104 VPWR VGND sg13cmos5l_decap_4
X_1935_ _3285_/D input7/X hold491/X _1971_/A VPWR VGND sg13cmos5l_mux2_1
X_1866_ _1988_/B _1966_/A _1866_/B VPWR VGND sg13cmos5l_nor2_1
X_1797_ _1797_/Y _1797_/A VPWR VGND sg13cmos5l_inv_1
X_3536_ _3536_/Q clkload5/A _3536_/D _3536_/RESET_B VPWR VGND sg13cmos5l_dfrbpq_1
X_3467_ _3467_/Q _3527_/CLK _3467_/D _3467_/RESET_B VPWR VGND sg13cmos5l_dfrbpq_1
X_3398_ _3398_/Q clkload3/A _3398_/D _3398_/RESET_B VPWR VGND sg13cmos5l_dfrbpq_1
X_2418_ _2418_/Y _2404_/Y hold600/X _2479_/A VPWR VGND sg13cmos5l_a21oi_1
X_2349_ _2349_/Y _2349_/A _2349_/B VPWR VGND sg13cmos5l_nand2_1
XFILLER_38_771 VPWR VGND sg13cmos5l_decap_8
XFILLER_26_922 VPWR VGND sg13cmos5l_decap_8
XFILLER_16_12 VPWR VGND sg13cmos5l_decap_8
XFILLER_26_999 VPWR VGND sg13cmos5l_decap_8
XFILLER_41_947 VPWR VGND sg13cmos5l_decap_8
XFILLER_25_487 VPWR VGND sg13cmos5l_decap_8
XFILLER_5_826 VPWR VGND sg13cmos5l_decap_8
XFILLER_10_1024 VPWR VGND sg13cmos5l_decap_4
XFILLER_0_586 VPWR VGND sg13cmos5l_decap_8
XFILLER_16_421 VPWR VGND sg13cmos5l_decap_8
XFILLER_28_292 VPWR VGND sg13cmos5l_decap_4
XFILLER_44_763 VPWR VGND sg13cmos5l_decap_8
XFILLER_17_988 VPWR VGND sg13cmos5l_decap_8
XFILLER_43_262 VPWR VGND sg13cmos5l_decap_4
XFILLER_31_413 VPWR VGND sg13cmos5l_decap_8
XFILLER_32_936 VPWR VGND sg13cmos5l_decap_8
XFILLER_31_468 VPWR VGND sg13cmos5l_fill_2
XFILLER_8_631 VPWR VGND sg13cmos5l_decap_8
XFILLER_11_192 VPWR VGND sg13cmos5l_decap_8
X_3321_ _3321_/Q _3551_/CLK _3321_/D _3321_/RESET_B VPWR VGND sg13cmos5l_dfrbpq_1
X_3252_ _3253_/B _3250_/A _3245_/B _3251_/X _3255_/A VPWR VGND sg13cmos5l_a22oi_1
XFILLER_26_1020 VPWR VGND sg13cmos5l_decap_8
X_2203_ _2203_/Y _3381_/Q _2203_/B VPWR VGND sg13cmos5l_nand2_1
X_3183_ _3183_/Y _3183_/A _3183_/B VPWR VGND sg13cmos5l_nand2_1
X_2134_ _2134_/Y _2134_/A _2134_/B VPWR VGND sg13cmos5l_nand2_1
XFILLER_27_719 VPWR VGND sg13cmos5l_fill_1
X_2065_ _2065_/Y _2061_/Y _2062_/Y _2063_/Y _2064_/Y _3312_/Q VPWR VGND sg13cmos5l_a221oi_1
XFILLER_26_229 VPWR VGND sg13cmos5l_decap_8
XFILLER_23_903 VPWR VGND sg13cmos5l_decap_8
XFILLER_23_947 VPWR VGND sg13cmos5l_decap_8
X_2967_ _3500_/D _2967_/A _2970_/B VPWR VGND sg13cmos5l_and2_1
XFILLER_31_980 VPWR VGND sg13cmos5l_decap_8
X_1918_ _3270_/D input9/X hold510/X _1923_/S VPWR VGND sg13cmos5l_mux2_1
X_2898_ _2898_/Y _3473_/Q _3451_/Q _2910_/B VPWR VGND sg13cmos5l_o21ai_1
X_1849_ _1849_/Y _3340_/Q VPWR VGND sg13cmos5l_inv_1
Xhold620 _2448_/A _3408_/Q VPWR VGND sg13cmos5l_dlygate4sd3_1
Xhold631 _3339_/D _2133_/Y VPWR VGND sg13cmos5l_dlygate4sd3_1
Xhold653 _2666_/A _2647_/C VPWR VGND sg13cmos5l_dlygate4sd3_1
Xhold642 _1901_/A _3302_/Q VPWR VGND sg13cmos5l_dlygate4sd3_1
X_3519_ _3519_/Q _3539_/CLK _3519_/D _3519_/RESET_B VPWR VGND sg13cmos5l_dfrbpq_1
Xhold697 hold697/X _3510_/Q VPWR VGND sg13cmos5l_dlygate4sd3_1
Xhold675 _3143_/A _3526_/Q VPWR VGND sg13cmos5l_dlygate4sd3_1
Xhold686 hold686/X _1897_/Y VPWR VGND sg13cmos5l_dlygate4sd3_1
Xhold664 _1862_/A _3395_/Q VPWR VGND sg13cmos5l_dlygate4sd3_1
XFILLER_40_1028 VPWR VGND sg13cmos5l_fill_1
XFILLER_14_958 VPWR VGND sg13cmos5l_decap_8
XFILLER_26_796 VPWR VGND sg13cmos5l_fill_2
XFILLER_43_54 VPWR VGND sg13cmos5l_fill_1
XFILLER_43_43 VPWR VGND sg13cmos5l_decap_8
XFILLER_41_766 VPWR VGND sg13cmos5l_decap_8
XFILLER_41_744 VPWR VGND sg13cmos5l_decap_8
XFILLER_40_243 VPWR VGND sg13cmos5l_decap_8
XFILLER_13_457 VPWR VGND sg13cmos5l_decap_8
XFILLER_13_468 VPWR VGND sg13cmos5l_fill_1
XFILLER_40_287 VPWR VGND sg13cmos5l_decap_8
XFILLER_40_298 VPWR VGND sg13cmos5l_fill_1
Xclkbuf_leaf_20_clk clkload5/A clkbuf_leaf_2_clk/A VPWR VGND sg13cmos5l_buf_8
XFILLER_5_678 VPWR VGND sg13cmos5l_fill_2
XFILLER_5_667 VPWR VGND sg13cmos5l_decap_8
XFILLER_4_166 VPWR VGND sg13cmos5l_decap_8
XFILLER_4_144 VPWR VGND sg13cmos5l_fill_2
XFILLER_1_851 VPWR VGND sg13cmos5l_decap_8
XFILLER_49_855 VPWR VGND sg13cmos5l_decap_8
XFILLER_48_321 VPWR VGND sg13cmos5l_fill_2
XFILLER_48_387 VPWR VGND sg13cmos5l_fill_2
XFILLER_29_590 VPWR VGND sg13cmos5l_decap_4
XFILLER_36_549 VPWR VGND sg13cmos5l_decap_4
XFILLER_17_774 VPWR VGND sg13cmos5l_decap_8
XFILLER_16_273 VPWR VGND sg13cmos5l_fill_2
XFILLER_16_284 VPWR VGND sg13cmos5l_decap_8
XFILLER_32_722 VPWR VGND sg13cmos5l_fill_1
XFILLER_16_295 VPWR VGND sg13cmos5l_fill_1
XFILLER_32_755 VPWR VGND sg13cmos5l_decap_8
X_2821_ _2838_/A _2831_/A _2821_/B VPWR VGND sg13cmos5l_nor2_1
Xclkbuf_leaf_11_clk _3409_/CLK clkload1/A VPWR VGND sg13cmos5l_buf_8
X_2752_ _2752_/Y _2753_/B _2749_/Y _2754_/C _2751_/Y VPWR VGND sg13cmos5l_a22oi_1
XFILLER_8_461 VPWR VGND sg13cmos5l_decap_8
XFILLER_9_984 VPWR VGND sg13cmos5l_decap_8
X_2683_ _2683_/Y _3447_/Q _3446_/Q _3473_/Q VPWR VGND sg13cmos5l_nand3b_1
X_3304_ _3304_/Q _3539_/CLK _3304_/D _3304_/RESET_B VPWR VGND sg13cmos5l_dfrbpq_1
X_3235_ _3235_/Y _1879_/B _3233_/X _3237_/B _3229_/Y VPWR VGND sg13cmos5l_a22oi_1
X_3166_ _3166_/Y _3166_/A _3166_/B VPWR VGND sg13cmos5l_nor2_1
XFILLER_27_516 VPWR VGND sg13cmos5l_decap_4
X_2117_ _2118_/B _1818_/Y _2123_/B _3352_/Q VPWR VGND sg13cmos5l_o21ai_1
XFILLER_39_398 VPWR VGND sg13cmos5l_fill_1
XFILLER_39_387 VPWR VGND sg13cmos5l_decap_8
X_3097_ _3098_/B _3095_/B _3096_/Y _3095_/Y VPWR VGND sg13cmos5l_a21oi_1
X_2048_ _2056_/A _3311_/Q _2041_/X _2047_/Y VPWR VGND sg13cmos5l_o21ai_1
X_3279__136 _3279_/RESET_B VPWR VGND sg13cmos5l_tiehi
Xfanout47 _2307_/A _2179_/Y VPWR VGND sg13cmos5l_buf_1
Xfanout36 _3125_/B _3028_/Y VPWR VGND sg13cmos5l_buf_1
Xfanout25 _3117_/A2 _3120_/A2 VPWR VGND sg13cmos5l_buf_1
Xfanout58 _3239_/A _3257_/A VPWR VGND sg13cmos5l_buf_1
XFILLER_22_265 VPWR VGND sg13cmos5l_decap_8
Xfanout69 _2179_/B _2610_/A VPWR VGND sg13cmos5l_buf_1
XFILLER_10_449 VPWR VGND sg13cmos5l_decap_8
XFILLER_13_68 VPWR VGND sg13cmos5l_decap_8
Xhold450 _3350_/D _2146_/X VPWR VGND sg13cmos5l_dlygate4sd3_1
XFILLER_2_637 VPWR VGND sg13cmos5l_decap_8
XFILLER_1_103 VPWR VGND sg13cmos5l_decap_4
Xhold461 _1985_/B _1984_/Y VPWR VGND sg13cmos5l_dlygate4sd3_1
Xhold472 _3311_/D _2013_/Y VPWR VGND sg13cmos5l_dlygate4sd3_1
Xhold483 _3430_/D _2603_/Y VPWR VGND sg13cmos5l_dlygate4sd3_1
Xhold494 _2001_/C _1999_/A VPWR VGND sg13cmos5l_dlygate4sd3_1
XFILLER_49_118 VPWR VGND sg13cmos5l_decap_8
XFILLER_46_825 VPWR VGND sg13cmos5l_fill_1
XFILLER_46_814 VPWR VGND sg13cmos5l_decap_8
XFILLER_45_313 VPWR VGND sg13cmos5l_decap_8
XFILLER_45_379 VPWR VGND sg13cmos5l_decap_8
XFILLER_33_508 VPWR VGND sg13cmos5l_decap_4
XFILLER_13_232 VPWR VGND sg13cmos5l_decap_8
XFILLER_14_799 VPWR VGND sg13cmos5l_decap_8
Xclkload17 clkload17/X _3408_/CLK VPWR VGND sg13cmos5l_buf_8
XFILLER_10_961 VPWR VGND sg13cmos5l_decap_8
XFILLER_6_965 VPWR VGND sg13cmos5l_decap_8
XFILLER_5_453 VPWR VGND sg13cmos5l_fill_2
XFILLER_5_497 VPWR VGND sg13cmos5l_decap_8
XFILLER_49_674 VPWR VGND sg13cmos5l_decap_8
XFILLER_37_825 VPWR VGND sg13cmos5l_decap_8
X_3020_ _3505_/D _3020_/A _3019_/Y VPWR VGND sg13cmos5l_nor2b_1
Xclkbuf_leaf_0_clk _3539_/CLK clkbuf_leaf_2_clk/A VPWR VGND sg13cmos5l_buf_8
XFILLER_36_324 VPWR VGND sg13cmos5l_fill_1
XFILLER_32_541 VPWR VGND sg13cmos5l_fill_2
X_2804_ _2823_/A _2820_/A _2820_/B VPWR VGND sg13cmos5l_nand2_1
X_2735_ _2736_/B _2512_/X _2728_/Y _2733_/Y VPWR VGND sg13cmos5l_a21oi_1
X_2666_ _2667_/C _2666_/A _2672_/S VPWR VGND sg13cmos5l_nor2b_1
X_2597_ _2598_/B _2753_/A _2594_/S _2615_/B VPWR VGND sg13cmos5l_o21ai_1
XFILLER_39_151 VPWR VGND sg13cmos5l_decap_8
X_3218_ _3218_/Y _3149_/Y _3222_/S _3121_/B VPWR VGND sg13cmos5l_o21ai_1
XFILLER_39_195 VPWR VGND sg13cmos5l_fill_1
X_3149_ _3149_/Y _3201_/B _3149_/B VPWR VGND sg13cmos5l_nor2_1
XFILLER_27_324 VPWR VGND sg13cmos5l_decap_4
XFILLER_27_335 VPWR VGND sg13cmos5l_decap_4
XFILLER_28_869 VPWR VGND sg13cmos5l_decap_8
XFILLER_43_839 VPWR VGND sg13cmos5l_decap_8
XFILLER_43_828 VPWR VGND sg13cmos5l_fill_2
XFILLER_15_519 VPWR VGND sg13cmos5l_decap_8
XFILLER_27_379 VPWR VGND sg13cmos5l_decap_8
XFILLER_42_349 VPWR VGND sg13cmos5l_decap_8
XFILLER_24_56 VPWR VGND sg13cmos5l_decap_8
XFILLER_11_747 VPWR VGND sg13cmos5l_decap_8
XFILLER_6_206 VPWR VGND sg13cmos5l_decap_8
XFILLER_10_246 VPWR VGND sg13cmos5l_decap_8
XFILLER_10_268 VPWR VGND sg13cmos5l_decap_8
XFILLER_40_33 VPWR VGND sg13cmos5l_decap_8
XFILLER_3_968 VPWR VGND sg13cmos5l_decap_8
XFILLER_2_445 VPWR VGND sg13cmos5l_decap_4
XFILLER_49_42 VPWR VGND sg13cmos5l_fill_1
XFILLER_49_31 VPWR VGND sg13cmos5l_decap_8
XFILLER_2_467 VPWR VGND sg13cmos5l_decap_8
XFILLER_49_97 VPWR VGND sg13cmos5l_decap_8
XFILLER_46_600 VPWR VGND sg13cmos5l_decap_8
XFILLER_19_836 VPWR VGND sg13cmos5l_decap_4
XFILLER_45_176 VPWR VGND sg13cmos5l_decap_8
XFILLER_27_891 VPWR VGND sg13cmos5l_decap_8
XFILLER_42_861 VPWR VGND sg13cmos5l_fill_1
XFILLER_14_552 VPWR VGND sg13cmos5l_decap_8
XFILLER_14_596 VPWR VGND sg13cmos5l_decap_8
X_2520_ _3416_/D _2615_/B _2520_/B VPWR VGND sg13cmos5l_and2_1
X_2451_ _2451_/Y _3407_/Q _2459_/B _2468_/C VPWR VGND sg13cmos5l_a21oi_1
X_2382_ _2382_/Y hold712/X _2363_/B _2203_/Y VPWR VGND sg13cmos5l_o21ai_1
X_3269__146 _3269_/RESET_B VPWR VGND sg13cmos5l_tiehi
X_3003_ _3004_/C _3003_/A _3003_/B _3003_/C VPWR VGND sg13cmos5l_and3_1
Xinput4 input4/X ui_in[2] VPWR VGND sg13cmos5l_buf_1
XFILLER_37_677 VPWR VGND sg13cmos5l_decap_4
XFILLER_37_655 VPWR VGND sg13cmos5l_decap_4
XFILLER_24_305 VPWR VGND sg13cmos5l_decap_8
Xclkbuf_2_1__f_clk clkload0/A clkbuf_0_clk/X VPWR VGND sg13cmos5l_buf_8
XFILLER_33_861 VPWR VGND sg13cmos5l_fill_2
XFILLER_33_883 VPWR VGND sg13cmos5l_decap_8
X_3276__139 _3276_/RESET_B VPWR VGND sg13cmos5l_tiehi
X_2718_ _2718_/Y _2717_/A _2717_/B _2518_/A VPWR VGND sg13cmos5l_a21oi_1
X_2649_ _2650_/A _2649_/A _2658_/A _2649_/C VPWR VGND sg13cmos5l_nor3_1
XFILLER_0_938 VPWR VGND sg13cmos5l_decap_8
XFILLER_47_408 VPWR VGND sg13cmos5l_decap_4
XFILLER_28_600 VPWR VGND sg13cmos5l_decap_4
XFILLER_28_622 VPWR VGND sg13cmos5l_decap_8
XFILLER_28_655 VPWR VGND sg13cmos5l_fill_2
XFILLER_43_603 VPWR VGND sg13cmos5l_fill_2
XFILLER_27_165 VPWR VGND sg13cmos5l_decap_8
XFILLER_35_22 VPWR VGND sg13cmos5l_fill_1
XFILLER_43_647 VPWR VGND sg13cmos5l_fill_1
XFILLER_43_636 VPWR VGND sg13cmos5l_decap_8
XFILLER_15_349 VPWR VGND sg13cmos5l_decap_8
XFILLER_35_66 VPWR VGND sg13cmos5l_decap_8
XFILLER_42_146 VPWR VGND sg13cmos5l_decap_4
XFILLER_24_894 VPWR VGND sg13cmos5l_decap_4
X_3298__397 _3298_/RESET_B VPWR VGND sg13cmos5l_tiehi
XFILLER_11_555 VPWR VGND sg13cmos5l_decap_8
XFILLER_7_537 VPWR VGND sg13cmos5l_fill_1
XFILLER_3_765 VPWR VGND sg13cmos5l_decap_8
XFILLER_2_275 VPWR VGND sg13cmos5l_fill_2
XFILLER_47_920 VPWR VGND sg13cmos5l_decap_8
XFILLER_19_622 VPWR VGND sg13cmos5l_fill_1
XFILLER_20_1015 VPWR VGND sg13cmos5l_decap_8
XFILLER_47_997 VPWR VGND sg13cmos5l_decap_8
XFILLER_15_850 VPWR VGND sg13cmos5l_decap_8
XFILLER_21_319 VPWR VGND sg13cmos5l_decap_4
XFILLER_42_691 VPWR VGND sg13cmos5l_decap_8
X_1951_ _1954_/A _1951_/A _1951_/B input2/X VPWR VGND sg13cmos5l_nor3_1
X_3496__398 _3496_/RESET_B VPWR VGND sg13cmos5l_tiehi
X_1882_ _3246_/A _1883_/B VPWR VGND sg13cmos5l_inv_1
XFILLER_30_864 VPWR VGND sg13cmos5l_decap_8
X_3552_ _3552_/Q clkload7/A _3552_/D _3552_/RESET_B VPWR VGND sg13cmos5l_dfrbpq_1
X_2503_ _2513_/B _2497_/Y _2499_/Y _2501_/Y VPWR VGND sg13cmos5l_a21o_1
X_3483_ _3483_/Q _3485_/CLK _3483_/D _3483_/RESET_B VPWR VGND sg13cmos5l_dfrbpq_1
X_2434_ _2434_/Y _2434_/A _2434_/B _2434_/C VPWR VGND sg13cmos5l_nand3_1
X_2365_ _2365_/X _2363_/A _2363_/B _2183_/Y VPWR VGND sg13cmos5l_a21o_1
XFILLER_37_0 VPWR VGND sg13cmos5l_decap_8
X_2296_ _2296_/Y _2296_/A _2296_/B VPWR VGND sg13cmos5l_nor2_1
XFILLER_49_290 VPWR VGND sg13cmos5l_decap_4
XFILLER_38_964 VPWR VGND sg13cmos5l_decap_8
XFILLER_25_636 VPWR VGND sg13cmos5l_decap_8
XFILLER_12_308 VPWR VGND sg13cmos5l_decap_8
XFILLER_36_1022 VPWR VGND sg13cmos5l_decap_8
XFILLER_12_319 VPWR VGND sg13cmos5l_fill_2
XFILLER_21_831 VPWR VGND sg13cmos5l_decap_8
XFILLER_21_864 VPWR VGND sg13cmos5l_decap_8
XFILLER_21_68 VPWR VGND sg13cmos5l_decap_8
XFILLER_0_735 VPWR VGND sg13cmos5l_decap_8
XFILLER_28_441 VPWR VGND sg13cmos5l_fill_2
XFILLER_46_76 VPWR VGND sg13cmos5l_decap_8
XFILLER_16_603 VPWR VGND sg13cmos5l_fill_2
XFILLER_29_986 VPWR VGND sg13cmos5l_decap_8
XFILLER_44_945 VPWR VGND sg13cmos5l_decap_8
XFILLER_43_444 VPWR VGND sg13cmos5l_decap_8
XFILLER_16_636 VPWR VGND sg13cmos5l_fill_2
XFILLER_43_455 VPWR VGND sg13cmos5l_fill_2
XFILLER_7_323 VPWR VGND sg13cmos5l_decap_4
X_3259__156 _3259_/RESET_B VPWR VGND sg13cmos5l_tiehi
XFILLER_7_367 VPWR VGND sg13cmos5l_decap_8
Xheichips26_dna_sequencer_75 uio_oe[1] VPWR VGND sg13cmos5l_tielo
XFILLER_3_573 VPWR VGND sg13cmos5l_decap_4
Xheichips26_dna_sequencer_86 uio_out[4] VPWR VGND sg13cmos5l_tielo
X_2150_ _2150_/Y _3344_/Q _3325_/Q VPWR VGND sg13cmos5l_xnor2_1
X_3266__149 _3266_/RESET_B VPWR VGND sg13cmos5l_tiehi
X_2081_ _3325_/D _2081_/A _2081_/B VPWR VGND sg13cmos5l_nor2_1
XFILLER_35_901 VPWR VGND sg13cmos5l_fill_2
XFILLER_35_923 VPWR VGND sg13cmos5l_decap_8
XFILLER_47_794 VPWR VGND sg13cmos5l_decap_8
XFILLER_15_680 VPWR VGND sg13cmos5l_decap_8
X_2983_ _2983_/Y _3495_/Q _3466_/Q VPWR VGND sg13cmos5l_xnor2_1
X_3320__357 _3320_/RESET_B VPWR VGND sg13cmos5l_tiehi
XFILLER_34_499 VPWR VGND sg13cmos5l_decap_8
X_1934_ _3284_/D input6/X hold498/X _1971_/A VPWR VGND sg13cmos5l_mux2_1
XFILLER_30_683 VPWR VGND sg13cmos5l_fill_1
X_1865_ _2283_/B _3377_/Q VPWR VGND sg13cmos5l_inv_1
X_1796_ _1796_/Y _1796_/A VPWR VGND sg13cmos5l_inv_1
X_3535_ _3535_/Q _3539_/CLK _3535_/D _3535_/RESET_B VPWR VGND sg13cmos5l_dfrbpq_1
X_3466_ _3466_/Q _3472_/CLK _3466_/D _3466_/RESET_B VPWR VGND sg13cmos5l_dfrbpq_1
X_2417_ _2417_/Y _2417_/A _2417_/B VPWR VGND sg13cmos5l_nand2_1
X_3397_ _3397_/Q _3472_/CLK _3397_/D _3397_/RESET_B VPWR VGND sg13cmos5l_dfrbpq_1
X_2348_ _3385_/D _2383_/A _2348_/B VPWR VGND sg13cmos5l_nor2_1
XFILLER_29_205 VPWR VGND sg13cmos5l_fill_1
XFILLER_29_238 VPWR VGND sg13cmos5l_decap_8
X_2279_ _2280_/C _2279_/A _2283_/C VPWR VGND sg13cmos5l_nor2_1
XFILLER_38_794 VPWR VGND sg13cmos5l_decap_8
XFILLER_41_926 VPWR VGND sg13cmos5l_decap_8
XFILLER_16_46 VPWR VGND sg13cmos5l_decap_8
XFILLER_25_466 VPWR VGND sg13cmos5l_decap_8
XFILLER_26_978 VPWR VGND sg13cmos5l_decap_8
XFILLER_40_403 VPWR VGND sg13cmos5l_decap_8
XFILLER_12_105 VPWR VGND sg13cmos5l_decap_8
XFILLER_13_628 VPWR VGND sg13cmos5l_decap_4
XFILLER_25_477 VPWR VGND sg13cmos5l_fill_1
XFILLER_21_683 VPWR VGND sg13cmos5l_decap_8
XFILLER_5_805 VPWR VGND sg13cmos5l_decap_8
XFILLER_21_694 VPWR VGND sg13cmos5l_fill_2
XFILLER_10_1003 VPWR VGND sg13cmos5l_decap_8
XFILLER_4_326 VPWR VGND sg13cmos5l_fill_2
XFILLER_4_359 VPWR VGND sg13cmos5l_fill_1
XFILLER_0_532 VPWR VGND sg13cmos5l_fill_1
XFILLER_0_565 VPWR VGND sg13cmos5l_decap_8
XFILLER_48_503 VPWR VGND sg13cmos5l_decap_8
XFILLER_44_742 VPWR VGND sg13cmos5l_decap_8
XFILLER_43_241 VPWR VGND sg13cmos5l_decap_8
XFILLER_17_967 VPWR VGND sg13cmos5l_decap_8
XFILLER_32_915 VPWR VGND sg13cmos5l_decap_8
XFILLER_31_458 VPWR VGND sg13cmos5l_decap_4
XFILLER_8_610 VPWR VGND sg13cmos5l_fill_2
XFILLER_8_665 VPWR VGND sg13cmos5l_decap_8
XFILLER_11_171 VPWR VGND sg13cmos5l_decap_8
X_3320_ _3320_/Q _3551_/CLK _3320_/D _3320_/RESET_B VPWR VGND sg13cmos5l_dfrbpq_1
XFILLER_4_882 VPWR VGND sg13cmos5l_decap_8
XFILLER_3_392 VPWR VGND sg13cmos5l_decap_8
X_3251_ _3251_/X _1876_/A _3250_/Y _3246_/Y VPWR VGND sg13cmos5l_a21o_1
X_2202_ _2202_/Y _2202_/A _2181_/Y VPWR VGND sg13cmos5l_nor2b_1
X_3182_ _3182_/Y _3187_/A _3187_/B _3181_/X _3062_/B VPWR VGND sg13cmos5l_a22oi_1
X_2133_ _2133_/Y _2237_/B _2129_/Y _2132_/Y VPWR VGND sg13cmos5l_a21oi_1
XFILLER_39_569 VPWR VGND sg13cmos5l_decap_8
XFILLER_26_208 VPWR VGND sg13cmos5l_decap_8
X_2064_ _2064_/Y _2043_/A _3281_/Q _2042_/Y VPWR VGND sg13cmos5l_a21oi_1
X_3463__194 _3463_/RESET_B VPWR VGND sg13cmos5l_tiehi
XFILLER_35_797 VPWR VGND sg13cmos5l_decap_4
X_2966_ _3499_/D _2966_/A _2966_/B VPWR VGND sg13cmos5l_and2_1
X_2897_ _2910_/B _3452_/Q _3451_/Q VPWR VGND sg13cmos5l_xor2_1
X_1917_ _3269_/D input8/X hold495/X _1923_/S VPWR VGND sg13cmos5l_mux2_1
X_1848_ _2134_/A _3341_/Q VPWR VGND sg13cmos5l_inv_1
XFILLER_8_80 VPWR VGND sg13cmos5l_decap_8
Xhold621 hold621/X _2449_/Y VPWR VGND sg13cmos5l_dlygate4sd3_1
Xhold610 _1867_/A _3311_/Q VPWR VGND sg13cmos5l_dlygate4sd3_1
Xhold632 _2032_/A _3319_/Q VPWR VGND sg13cmos5l_dlygate4sd3_1
Xhold654 hold654/X _3330_/Q VPWR VGND sg13cmos5l_dlygate4sd3_1
Xhold643 _2158_/A _3349_/Q VPWR VGND sg13cmos5l_dlygate4sd3_1
XFILLER_2_819 VPWR VGND sg13cmos5l_decap_8
X_3518_ _3518_/Q _3539_/CLK _3518_/D _3518_/RESET_B VPWR VGND sg13cmos5l_dfrbpq_1
Xhold676 hold676/X _3548_/Q VPWR VGND sg13cmos5l_dlygate4sd3_1
Xhold687 _1899_/B _1898_/Y VPWR VGND sg13cmos5l_dlygate4sd3_1
Xhold665 _2279_/A _3375_/Q VPWR VGND sg13cmos5l_dlygate4sd3_1
Xhold698 _2372_/A _3360_/Q VPWR VGND sg13cmos5l_dlygate4sd3_1
X_3449_ _3449_/Q _3485_/CLK _3449_/D _3449_/RESET_B VPWR VGND sg13cmos5l_dfrbpq_1
XFILLER_40_1007 VPWR VGND sg13cmos5l_decap_8
XFILLER_17_219 VPWR VGND sg13cmos5l_decap_8
XFILLER_38_591 VPWR VGND sg13cmos5l_decap_4
XFILLER_27_56 VPWR VGND sg13cmos5l_decap_4
XFILLER_26_775 VPWR VGND sg13cmos5l_decap_8
XFILLER_14_937 VPWR VGND sg13cmos5l_decap_8
XFILLER_25_274 VPWR VGND sg13cmos5l_fill_1
XFILLER_13_447 VPWR VGND sg13cmos5l_fill_1
XFILLER_43_66 VPWR VGND sg13cmos5l_decap_8
XFILLER_41_789 VPWR VGND sg13cmos5l_fill_1
XFILLER_22_981 VPWR VGND sg13cmos5l_decap_8
XFILLER_21_480 VPWR VGND sg13cmos5l_decap_4
XFILLER_5_646 VPWR VGND sg13cmos5l_fill_2
XFILLER_4_112 VPWR VGND sg13cmos5l_decap_8
XFILLER_1_830 VPWR VGND sg13cmos5l_decap_8
XFILLER_49_834 VPWR VGND sg13cmos5l_decap_8
XFILLER_0_384 VPWR VGND sg13cmos5l_decap_8
XFILLER_1_1012 VPWR VGND sg13cmos5l_decap_8
XFILLER_44_561 VPWR VGND sg13cmos5l_decap_8
XFILLER_16_252 VPWR VGND sg13cmos5l_fill_2
XFILLER_32_712 VPWR VGND sg13cmos5l_fill_2
XFILLER_17_1009 VPWR VGND sg13cmos5l_decap_8
X_3501__386 _3501_/RESET_B VPWR VGND sg13cmos5l_tiehi
XFILLER_31_211 VPWR VGND sg13cmos5l_decap_8
X_2820_ _2821_/B _2820_/A _2820_/B VPWR VGND sg13cmos5l_xnor2_1
XFILLER_31_255 VPWR VGND sg13cmos5l_fill_2
XFILLER_8_440 VPWR VGND sg13cmos5l_decap_8
XFILLER_9_963 VPWR VGND sg13cmos5l_decap_8
XFILLER_12_491 VPWR VGND sg13cmos5l_fill_2
X_2751_ _2751_/Y _3477_/Q _3473_/Q VPWR VGND sg13cmos5l_nor2b_1
X_2682_ _2682_/Y _3473_/Q _3446_/Q VPWR VGND sg13cmos5l_nand2_1
X_3303_ _3303_/Q _3539_/CLK _3303_/D _3303_/RESET_B VPWR VGND sg13cmos5l_dfrbpq_1
X_3234_ _3237_/B _1879_/B _3537_/Q _3545_/Q VPWR VGND sg13cmos5l_o21ai_1
X_3165_ _3165_/Y _3165_/A _3183_/B VPWR VGND sg13cmos5l_nor2_1
X_2116_ _2116_/Y _3319_/Q _3354_/Q VPWR VGND sg13cmos5l_nand2_1
X_3096_ _3096_/Y _3096_/A _3536_/Q VPWR VGND sg13cmos5l_nor2_1
X_2047_ _2047_/Y _2043_/Y _2044_/Y _2046_/Y VPWR VGND sg13cmos5l_a21oi_1
XFILLER_35_572 VPWR VGND sg13cmos5l_decap_8
Xfanout37 _2968_/B _2971_/B VPWR VGND sg13cmos5l_buf_1
Xfanout26 _3118_/A2 _3120_/A2 VPWR VGND sg13cmos5l_buf_1
Xfanout48 _2309_/A _2179_/Y VPWR VGND sg13cmos5l_buf_1
XFILLER_11_929 VPWR VGND sg13cmos5l_decap_8
Xfanout59 _3257_/A _3543_/D VPWR VGND sg13cmos5l_buf_1
XFILLER_10_439 VPWR VGND sg13cmos5l_decap_4
XFILLER_13_36 VPWR VGND sg13cmos5l_decap_8
X_2949_ _2950_/B _2944_/Y hold690/X _2970_/B VPWR VGND sg13cmos5l_o21ai_1
Xhold451 hold451/X _3307_/Q VPWR VGND sg13cmos5l_dlygate4sd3_1
Xhold440 _1798_/A _3521_/Q VPWR VGND sg13cmos5l_dlygate4sd3_1
Xhold462 _1879_/A _3539_/Q VPWR VGND sg13cmos5l_dlygate4sd3_1
XFILLER_1_126 VPWR VGND sg13cmos5l_fill_1
Xhold484 hold484/X _3462_/Q VPWR VGND sg13cmos5l_dlygate4sd3_1
Xhold473 _2419_/B _3368_/Q VPWR VGND sg13cmos5l_dlygate4sd3_1
Xhold495 hold495/X _3269_/Q VPWR VGND sg13cmos5l_dlygate4sd3_1
XFILLER_38_11 VPWR VGND sg13cmos5l_fill_2
XFILLER_18_539 VPWR VGND sg13cmos5l_decap_8
XFILLER_45_358 VPWR VGND sg13cmos5l_decap_8
XFILLER_45_347 VPWR VGND sg13cmos5l_fill_2
XFILLER_26_550 VPWR VGND sg13cmos5l_decap_4
XFILLER_13_211 VPWR VGND sg13cmos5l_decap_8
XFILLER_13_244 VPWR VGND sg13cmos5l_fill_2
XFILLER_14_778 VPWR VGND sg13cmos5l_decap_8
XFILLER_10_940 VPWR VGND sg13cmos5l_decap_8
Xclkload18 clkload18/X _3409_/CLK VPWR VGND sg13cmos5l_buf_8
XFILLER_6_944 VPWR VGND sg13cmos5l_decap_8
XFILLER_5_421 VPWR VGND sg13cmos5l_decap_8
XFILLER_23_1024 VPWR VGND sg13cmos5l_decap_4
XFILLER_24_509 VPWR VGND sg13cmos5l_decap_8
XFILLER_36_358 VPWR VGND sg13cmos5l_decap_8
XFILLER_20_704 VPWR VGND sg13cmos5l_decap_8
XFILLER_32_564 VPWR VGND sg13cmos5l_decap_8
X_2803_ _2813_/A _3472_/Q _2820_/B VPWR VGND sg13cmos5l_nor2_1
XFILLER_32_597 VPWR VGND sg13cmos5l_fill_1
XFILLER_9_760 VPWR VGND sg13cmos5l_decap_4
XFILLER_9_771 VPWR VGND sg13cmos5l_decap_8
X_2734_ _2734_/X _2512_/X _2728_/Y _2733_/Y VPWR VGND sg13cmos5l_a21o_1
X_2665_ _2667_/B _2672_/S _2647_/A VPWR VGND sg13cmos5l_nor2b_1
X_2596_ _2598_/A _2596_/A _2594_/S VPWR VGND sg13cmos5l_nor2b_1
X_3217_ _3531_/D _3217_/A _3216_/Y VPWR VGND sg13cmos5l_nor2b_1
XFILLER_28_815 VPWR VGND sg13cmos5l_fill_1
X_3148_ _3148_/Y _3149_/B VPWR VGND sg13cmos5l_inv_1
XFILLER_28_848 VPWR VGND sg13cmos5l_decap_8
XFILLER_43_807 VPWR VGND sg13cmos5l_decap_8
X_3079_ _3079_/Y _3492_/Q _3535_/Q VPWR VGND sg13cmos5l_nand2_1
XFILLER_42_339 VPWR VGND sg13cmos5l_decap_4
XFILLER_10_203 VPWR VGND sg13cmos5l_decap_8
XFILLER_10_225 VPWR VGND sg13cmos5l_decap_8
XFILLER_11_726 VPWR VGND sg13cmos5l_decap_8
XFILLER_6_229 VPWR VGND sg13cmos5l_decap_8
XFILLER_3_947 VPWR VGND sg13cmos5l_decap_8
XFILLER_2_413 VPWR VGND sg13cmos5l_decap_4
XFILLER_6_4 VPWR VGND sg13cmos5l_decap_8
XFILLER_49_54 VPWR VGND sg13cmos5l_decap_8
XFILLER_18_325 VPWR VGND sg13cmos5l_decap_4
XFILLER_45_133 VPWR VGND sg13cmos5l_decap_8
XFILLER_45_166 VPWR VGND sg13cmos5l_decap_4
XFILLER_18_369 VPWR VGND sg13cmos5l_fill_1
XFILLER_33_328 VPWR VGND sg13cmos5l_decap_8
XFILLER_14_520 VPWR VGND sg13cmos5l_fill_1
XFILLER_33_339 VPWR VGND sg13cmos5l_decap_8
XFILLER_6_763 VPWR VGND sg13cmos5l_decap_8
X_2450_ _2470_/A _2468_/B _2468_/C _2468_/A VPWR VGND sg13cmos5l_a21oi_1
XFILLER_39_4 VPWR VGND sg13cmos5l_fill_2
X_2381_ _3389_/D _2479_/A _2381_/B VPWR VGND sg13cmos5l_nor2_1
XFILLER_2_980 VPWR VGND sg13cmos5l_decap_8
XFILLER_37_634 VPWR VGND sg13cmos5l_decap_4
X_3002_ _3002_/Y _2998_/Y _2999_/X _3001_/Y _3003_/A _2980_/X VPWR VGND sg13cmos5l_a221oi_1
Xinput5 input5/X ui_in[3] VPWR VGND sg13cmos5l_buf_1
XFILLER_36_133 VPWR VGND sg13cmos5l_decap_4
XFILLER_24_317 VPWR VGND sg13cmos5l_decap_8
XFILLER_36_166 VPWR VGND sg13cmos5l_decap_8
XFILLER_36_177 VPWR VGND sg13cmos5l_fill_1
XFILLER_33_840 VPWR VGND sg13cmos5l_decap_8
XFILLER_20_512 VPWR VGND sg13cmos5l_fill_2
XFILLER_20_523 VPWR VGND sg13cmos5l_fill_1
XFILLER_20_578 VPWR VGND sg13cmos5l_fill_1
XFILLER_9_590 VPWR VGND sg13cmos5l_decap_8
X_2717_ _2737_/B _2717_/A _2717_/B VPWR VGND sg13cmos5l_and2_1
XFILLER_10_48 VPWR VGND sg13cmos5l_decap_8
X_2648_ _2649_/C _2648_/A _2648_/B _2648_/C VPWR VGND sg13cmos5l_and3_1
XFILLER_0_917 VPWR VGND sg13cmos5l_decap_8
X_2579_ _2596_/A _3397_/Q _2577_/Y _2578_/Y VPWR VGND sg13cmos5l_o21ai_1
XFILLER_28_645 VPWR VGND sg13cmos5l_fill_1
XFILLER_43_615 VPWR VGND sg13cmos5l_decap_8
XFILLER_42_103 VPWR VGND sg13cmos5l_decap_8
XFILLER_16_818 VPWR VGND sg13cmos5l_decap_8
XFILLER_15_328 VPWR VGND sg13cmos5l_decap_8
XFILLER_30_309 VPWR VGND sg13cmos5l_decap_8
XFILLER_11_534 VPWR VGND sg13cmos5l_decap_8
XFILLER_3_733 VPWR VGND sg13cmos5l_decap_8
XFILLER_2_298 VPWR VGND sg13cmos5l_decap_8
XFILLER_47_976 VPWR VGND sg13cmos5l_decap_8
XFILLER_46_431 VPWR VGND sg13cmos5l_decap_4
XFILLER_46_453 VPWR VGND sg13cmos5l_fill_2
XFILLER_18_144 VPWR VGND sg13cmos5l_fill_1
XFILLER_18_166 VPWR VGND sg13cmos5l_decap_8
XFILLER_15_873 VPWR VGND sg13cmos5l_fill_1
X_1950_ _3294_/D _1948_/X hold574/X _3239_/A VPWR VGND sg13cmos5l_a21oi_1
XFILLER_41_180 VPWR VGND sg13cmos5l_decap_8
X_1881_ _1883_/B _1988_/B _1893_/B VPWR VGND sg13cmos5l_nor2_1
X_3275__140 _3275_/RESET_B VPWR VGND sg13cmos5l_tiehi
X_3551_ _3551_/Q _3551_/CLK _3551_/D _3551_/RESET_B VPWR VGND sg13cmos5l_dfrbpq_1
X_2502_ _2506_/A _2497_/Y _2499_/Y _2501_/Y VPWR VGND sg13cmos5l_a21oi_1
X_3482_ _3482_/Q _3504_/CLK _3482_/D _3482_/RESET_B VPWR VGND sg13cmos5l_dfrbpq_1
X_2433_ _2434_/C _2433_/A _2433_/B _2433_/C _2433_/D VPWR VGND sg13cmos5l_nand4_1
X_2364_ _2364_/Y _2364_/A _2364_/B VPWR VGND sg13cmos5l_nor2_1
X_2295_ _2295_/Y _2294_/Y _2298_/A VPWR VGND sg13cmos5l_nand2b_1
XFILLER_38_943 VPWR VGND sg13cmos5l_decap_8
XFILLER_25_615 VPWR VGND sg13cmos5l_decap_8
XFILLER_36_1001 VPWR VGND sg13cmos5l_decap_8
XFILLER_40_629 VPWR VGND sg13cmos5l_decap_8
XFILLER_21_810 VPWR VGND sg13cmos5l_decap_8
XFILLER_33_681 VPWR VGND sg13cmos5l_fill_1
XFILLER_20_375 VPWR VGND sg13cmos5l_decap_4
XFILLER_21_25 VPWR VGND sg13cmos5l_decap_8
XFILLER_21_47 VPWR VGND sg13cmos5l_decap_8
XFILLER_0_714 VPWR VGND sg13cmos5l_decap_8
XFILLER_47_239 VPWR VGND sg13cmos5l_fill_2
XFILLER_29_965 VPWR VGND sg13cmos5l_decap_8
XFILLER_44_924 VPWR VGND sg13cmos5l_decap_8
XFILLER_16_615 VPWR VGND sg13cmos5l_decap_8
XFILLER_28_464 VPWR VGND sg13cmos5l_decap_4
XFILLER_43_412 VPWR VGND sg13cmos5l_decap_8
XFILLER_15_136 VPWR VGND sg13cmos5l_decap_8
XFILLER_15_158 VPWR VGND sg13cmos5l_fill_1
XFILLER_24_670 VPWR VGND sg13cmos5l_decap_4
XFILLER_12_865 VPWR VGND sg13cmos5l_decap_4
XFILLER_11_375 VPWR VGND sg13cmos5l_decap_4
XFILLER_12_887 VPWR VGND sg13cmos5l_decap_8
XFILLER_8_869 VPWR VGND sg13cmos5l_decap_8
XFILLER_7_49 VPWR VGND sg13cmos5l_fill_2
Xheichips26_dna_sequencer_87 uio_out[5] VPWR VGND sg13cmos5l_tielo
Xheichips26_dna_sequencer_76 uio_oe[2] VPWR VGND sg13cmos5l_tielo
XFILLER_3_596 VPWR VGND sg13cmos5l_decap_8
XFILLER_30_8 VPWR VGND sg13cmos5l_fill_1
XFILLER_39_707 VPWR VGND sg13cmos5l_decap_4
XFILLER_38_228 VPWR VGND sg13cmos5l_decap_8
XFILLER_38_239 VPWR VGND sg13cmos5l_decap_8
X_2080_ _3324_/D _2080_/A _2081_/B VPWR VGND sg13cmos5l_nor2_1
XFILLER_47_773 VPWR VGND sg13cmos5l_decap_8
XFILLER_34_412 VPWR VGND sg13cmos5l_decap_8
XFILLER_35_979 VPWR VGND sg13cmos5l_decap_8
X_2982_ _2982_/Y _3494_/Q _3465_/Q VPWR VGND sg13cmos5l_xnor2_1
XFILLER_22_629 VPWR VGND sg13cmos5l_decap_8
XFILLER_14_180 VPWR VGND sg13cmos5l_decap_8
X_1933_ _1941_/S _3302_/Q _3257_/A _1970_/B VPWR VGND sg13cmos5l_or3_1
XFILLER_30_640 VPWR VGND sg13cmos5l_decap_4
X_1864_ _2573_/B _1864_/A VPWR VGND sg13cmos5l_inv_1
X_1795_ _1795_/Y _1795_/A VPWR VGND sg13cmos5l_inv_1
X_3534_ _3534_/Q clkload5/A _3534_/D _3534_/RESET_B VPWR VGND sg13cmos5l_dfrbpq_1
X_3465_ _3465_/Q _3527_/CLK _3465_/D _3465_/RESET_B VPWR VGND sg13cmos5l_dfrbpq_1
X_2416_ _3395_/D _2432_/B _2416_/B VPWR VGND sg13cmos5l_nor2_1
X_3396_ _3396_/Q _3444_/CLK _3396_/D _3396_/RESET_B VPWR VGND sg13cmos5l_dfrbpq_1
X_2347_ _2347_/Y _2348_/B VPWR VGND sg13cmos5l_inv_1
XFILLER_29_217 VPWR VGND sg13cmos5l_decap_8
XFILLER_38_740 VPWR VGND sg13cmos5l_decap_8
X_2278_ _2287_/A _2282_/A _2277_/Y _2271_/Y VPWR VGND sg13cmos5l_o21ai_1
XFILLER_26_957 VPWR VGND sg13cmos5l_decap_8
XFILLER_41_905 VPWR VGND sg13cmos5l_decap_8
XFILLER_16_58 VPWR VGND sg13cmos5l_decap_4
XFILLER_25_445 VPWR VGND sg13cmos5l_decap_8
XFILLER_34_990 VPWR VGND sg13cmos5l_decap_8
XFILLER_20_172 VPWR VGND sg13cmos5l_decap_4
XFILLER_20_194 VPWR VGND sg13cmos5l_decap_4
XFILLER_0_511 VPWR VGND sg13cmos5l_decap_8
XFILLER_0_544 VPWR VGND sg13cmos5l_decap_8
XFILLER_48_537 VPWR VGND sg13cmos5l_decap_8
X_3265__150 _3265_/RESET_B VPWR VGND sg13cmos5l_tiehi
XFILLER_17_902 VPWR VGND sg13cmos5l_decap_8
XFILLER_29_773 VPWR VGND sg13cmos5l_decap_8
XFILLER_17_946 VPWR VGND sg13cmos5l_decap_8
XFILLER_43_220 VPWR VGND sg13cmos5l_decap_8
XFILLER_16_456 VPWR VGND sg13cmos5l_decap_8
XFILLER_44_798 VPWR VGND sg13cmos5l_decap_8
X_3337__118 _3337_/D VPWR VGND sg13cmos5l_tielo
XFILLER_8_600 VPWR VGND sg13cmos5l_decap_4
XFILLER_11_150 VPWR VGND sg13cmos5l_decap_8
XFILLER_12_662 VPWR VGND sg13cmos5l_decap_8
XFILLER_40_993 VPWR VGND sg13cmos5l_decap_8
XFILLER_12_684 VPWR VGND sg13cmos5l_decap_8
X_3272__143 _3272_/RESET_B VPWR VGND sg13cmos5l_tiehi
XFILLER_7_187 VPWR VGND sg13cmos5l_decap_8
XFILLER_4_861 VPWR VGND sg13cmos5l_decap_8
X_3250_ _3250_/Y _3250_/A _3250_/B VPWR VGND sg13cmos5l_xnor2_1
X_2201_ _3357_/D _2307_/A _2293_/A VPWR VGND sg13cmos5l_nor2_1
XFILLER_39_504 VPWR VGND sg13cmos5l_decap_8
X_3181_ _3181_/X _3121_/A _3177_/Y _3184_/S VPWR VGND sg13cmos5l_mux2_1
XFILLER_21_4 VPWR VGND sg13cmos5l_decap_8
X_2132_ _2132_/Y _2126_/B _2129_/Y _2147_/B VPWR VGND sg13cmos5l_o21ai_1
XFILLER_39_548 VPWR VGND sg13cmos5l_decap_8
X_2063_ _2063_/Y _2063_/A _3264_/Q VPWR VGND sg13cmos5l_nand2_1
XFILLER_19_272 VPWR VGND sg13cmos5l_decap_8
XFILLER_35_732 VPWR VGND sg13cmos5l_decap_8
XFILLER_22_404 VPWR VGND sg13cmos5l_decap_8
XFILLER_35_776 VPWR VGND sg13cmos5l_decap_8
XFILLER_22_448 VPWR VGND sg13cmos5l_decap_8
X_2965_ _3498_/D _2966_/A _2965_/B VPWR VGND sg13cmos5l_and2_1
XFILLER_33_1015 VPWR VGND sg13cmos5l_decap_8
X_1916_ _3268_/D input7/X hold529/X _1923_/S VPWR VGND sg13cmos5l_mux2_1
X_2896_ _2896_/X _3474_/Q _2896_/B VPWR VGND sg13cmos5l_or2_1
XFILLER_30_470 VPWR VGND sg13cmos5l_decap_8
XFILLER_30_481 VPWR VGND sg13cmos5l_decap_8
X_1847_ _3225_/A _3545_/Q VPWR VGND sg13cmos5l_inv_1
Xhold600 hold600/X _2417_/Y VPWR VGND sg13cmos5l_dlygate4sd3_1
Xhold611 _2615_/A _3413_/Q VPWR VGND sg13cmos5l_dlygate4sd3_1
Xhold633 hold633/X _2032_/Y VPWR VGND sg13cmos5l_dlygate4sd3_1
Xhold644 _2171_/A _2159_/Y VPWR VGND sg13cmos5l_dlygate4sd3_1
X_3517_ _3517_/Q _3539_/CLK _3517_/D _3517_/RESET_B VPWR VGND sg13cmos5l_dfrbpq_1
Xhold622 _2926_/A _3458_/Q VPWR VGND sg13cmos5l_dlygate4sd3_1
Xhold655 _2108_/B _2163_/A VPWR VGND sg13cmos5l_dlygate4sd3_1
Xhold666 _2305_/A _2299_/A VPWR VGND sg13cmos5l_dlygate4sd3_1
Xhold677 _2867_/A _3509_/Q VPWR VGND sg13cmos5l_dlygate4sd3_1
Xhold688 hold688/X _3549_/Q VPWR VGND sg13cmos5l_dlygate4sd3_1
Xhold699 hold699/X _2372_/Y VPWR VGND sg13cmos5l_dlygate4sd3_1
X_3448_ _3448_/Q _3485_/CLK _3448_/D _3448_/RESET_B VPWR VGND sg13cmos5l_dfrbpq_1
X_3366__303 _3366_/RESET_B VPWR VGND sg13cmos5l_tiehi
X_3379_ _3379_/Q _3408_/CLK _3379_/D _3379_/RESET_B VPWR VGND sg13cmos5l_dfrbpq_1
XFILLER_27_35 VPWR VGND sg13cmos5l_decap_8
XFILLER_38_570 VPWR VGND sg13cmos5l_decap_8
XFILLER_26_743 VPWR VGND sg13cmos5l_decap_8
XFILLER_27_79 VPWR VGND sg13cmos5l_decap_8
XFILLER_41_724 VPWR VGND sg13cmos5l_fill_2
XFILLER_41_713 VPWR VGND sg13cmos5l_fill_2
XFILLER_41_702 VPWR VGND sg13cmos5l_decap_8
XFILLER_13_426 VPWR VGND sg13cmos5l_decap_8
X_3518__306 _3518_/RESET_B VPWR VGND sg13cmos5l_tiehi
XFILLER_25_286 VPWR VGND sg13cmos5l_decap_8
XFILLER_25_297 VPWR VGND sg13cmos5l_fill_1
XFILLER_22_960 VPWR VGND sg13cmos5l_decap_8
XFILLER_5_603 VPWR VGND sg13cmos5l_decap_8
XFILLER_49_813 VPWR VGND sg13cmos5l_decap_8
XFILLER_0_363 VPWR VGND sg13cmos5l_decap_8
XFILLER_1_886 VPWR VGND sg13cmos5l_decap_8
XFILLER_48_389 VPWR VGND sg13cmos5l_fill_1
XFILLER_17_743 VPWR VGND sg13cmos5l_decap_8
XFILLER_17_754 VPWR VGND sg13cmos5l_fill_1
XFILLER_44_595 VPWR VGND sg13cmos5l_fill_1
XFILLER_32_779 VPWR VGND sg13cmos5l_decap_8
XFILLER_40_790 VPWR VGND sg13cmos5l_decap_8
XFILLER_9_942 VPWR VGND sg13cmos5l_decap_8
XFILLER_13_982 VPWR VGND sg13cmos5l_decap_8
X_2750_ _2754_/C _3477_/Q _2599_/A _2753_/B VPWR VGND sg13cmos5l_o21ai_1
X_2681_ _2681_/X _2692_/A _2692_/B _2705_/A VPWR VGND sg13cmos5l_a21o_1
XFILLER_4_680 VPWR VGND sg13cmos5l_fill_1
X_3302_ _3302_/Q clkload7/A _3302_/D _3302_/RESET_B VPWR VGND sg13cmos5l_dfrbpq_1
X_3233_ _3233_/X _3537_/Q _3225_/Y _3229_/A VPWR VGND sg13cmos5l_a21o_1
XFILLER_39_367 VPWR VGND sg13cmos5l_fill_2
XFILLER_39_356 VPWR VGND sg13cmos5l_decap_8
X_3164_ _3183_/B _3487_/Q _3177_/C VPWR VGND sg13cmos5l_nor2_1
X_2115_ _3334_/D _2115_/A _3349_/D VPWR VGND sg13cmos5l_nor2b_1
X_3095_ _3095_/Y _3095_/A _3095_/B VPWR VGND sg13cmos5l_nor2_1
X_2046_ _2046_/Y _1868_/Y _2045_/X _3312_/Q VPWR VGND sg13cmos5l_o21ai_1
XFILLER_23_702 VPWR VGND sg13cmos5l_decap_8
XFILLER_35_562 VPWR VGND sg13cmos5l_decap_4
Xfanout38 _2971_/B _2847_/Y VPWR VGND sg13cmos5l_buf_1
Xfanout27 _3120_/A2 _2039_/Y VPWR VGND sg13cmos5l_buf_1
Xfanout49 _2070_/A _2063_/A VPWR VGND sg13cmos5l_buf_1
XFILLER_11_908 VPWR VGND sg13cmos5l_decap_8
XFILLER_13_26 VPWR VGND sg13cmos5l_decap_4
X_2948_ _2948_/Y _3492_/Q _2948_/B VPWR VGND sg13cmos5l_nor2_1
XFILLER_22_278 VPWR VGND sg13cmos5l_decap_8
X_2879_ _2880_/B _2879_/A _2879_/B _2879_/C VPWR VGND sg13cmos5l_nand3_1
Xhold441 _3308_/D _1983_/Y VPWR VGND sg13cmos5l_dlygate4sd3_1
Xhold452 _1958_/B _1957_/Y VPWR VGND sg13cmos5l_dlygate4sd3_1
Xhold463 _3239_/B _3238_/Y VPWR VGND sg13cmos5l_dlygate4sd3_1
Xhold430 _2426_/B _3372_/Q VPWR VGND sg13cmos5l_dlygate4sd3_1
Xhold474 _3087_/C _3531_/Q VPWR VGND sg13cmos5l_dlygate4sd3_1
Xhold485 _1807_/A _3432_/Q VPWR VGND sg13cmos5l_dlygate4sd3_1
Xhold496 _1811_/A _3370_/Q VPWR VGND sg13cmos5l_dlygate4sd3_1
XFILLER_18_518 VPWR VGND sg13cmos5l_decap_8
X_3262__153 _3262_/RESET_B VPWR VGND sg13cmos5l_tiehi
XFILLER_14_724 VPWR VGND sg13cmos5l_decap_8
XFILLER_41_543 VPWR VGND sg13cmos5l_decap_4
XFILLER_14_757 VPWR VGND sg13cmos5l_decap_8
XFILLER_26_595 VPWR VGND sg13cmos5l_decap_4
XFILLER_13_256 VPWR VGND sg13cmos5l_decap_4
XFILLER_9_249 VPWR VGND sg13cmos5l_decap_8
XFILLER_6_923 VPWR VGND sg13cmos5l_decap_8
XFILLER_5_400 VPWR VGND sg13cmos5l_decap_8
XFILLER_10_996 VPWR VGND sg13cmos5l_decap_8
Xclkload19 clkload19/Y _3442_/CLK VPWR VGND sg13cmos5l_inv_4
XFILLER_23_1003 VPWR VGND sg13cmos5l_decap_8
XFILLER_49_665 VPWR VGND sg13cmos5l_fill_1
XFILLER_49_654 VPWR VGND sg13cmos5l_decap_8
X_3460__198 _3460_/RESET_B VPWR VGND sg13cmos5l_tiehi
XFILLER_45_893 VPWR VGND sg13cmos5l_decap_8
XFILLER_32_543 VPWR VGND sg13cmos5l_fill_1
X_2802_ _2829_/B _2800_/Y _2801_/Y _2799_/Y VPWR VGND sg13cmos5l_a21oi_1
X_2733_ _2733_/Y _2737_/A _2733_/B _2737_/C VPWR VGND sg13cmos5l_nor3_1
XFILLER_30_1018 VPWR VGND sg13cmos5l_decap_8
X_2664_ _2672_/S _2664_/A _2661_/Y VPWR VGND sg13cmos5l_nor2b_1
X_2595_ _3425_/D _2667_/A _2595_/B VPWR VGND sg13cmos5l_nor2_1
XFILLER_5_71 VPWR VGND sg13cmos5l_decap_8
X_3216_ _3216_/Y _3197_/X _3222_/S _3125_/B VPWR VGND sg13cmos5l_a21oi_1
X_3147_ _3149_/B _3147_/A _3147_/B VPWR VGND sg13cmos5l_xnor2_1
XFILLER_42_318 VPWR VGND sg13cmos5l_decap_8
XFILLER_39_1010 VPWR VGND sg13cmos5l_decap_8
XFILLER_36_882 VPWR VGND sg13cmos5l_decap_8
X_3078_ _3078_/Y _3490_/Q _3091_/A _3077_/Y VPWR VGND sg13cmos5l_o21ai_1
X_2029_ _2029_/Y _2024_/Y hold555/X _2087_/A VPWR VGND sg13cmos5l_a21oi_1
X_3492__96 _3492_/D VPWR VGND sg13cmos5l_tielo
XFILLER_23_521 VPWR VGND sg13cmos5l_fill_1
XFILLER_23_554 VPWR VGND sg13cmos5l_fill_2
XFILLER_24_25 VPWR VGND sg13cmos5l_decap_8
XFILLER_40_68 VPWR VGND sg13cmos5l_decap_8
X_3333__121 _3333_/D VPWR VGND sg13cmos5l_tielo
XFILLER_3_926 VPWR VGND sg13cmos5l_decap_8
XFILLER_49_11 VPWR VGND sg13cmos5l_fill_2
XFILLER_46_1025 VPWR VGND sg13cmos5l_decap_4
XFILLER_19_805 VPWR VGND sg13cmos5l_decap_4
XFILLER_46_635 VPWR VGND sg13cmos5l_decap_8
XFILLER_46_646 VPWR VGND sg13cmos5l_fill_2
XFILLER_45_112 VPWR VGND sg13cmos5l_decap_8
XFILLER_27_871 VPWR VGND sg13cmos5l_fill_1
XFILLER_42_896 VPWR VGND sg13cmos5l_decap_8
XFILLER_41_373 VPWR VGND sg13cmos5l_fill_1
XFILLER_10_793 VPWR VGND sg13cmos5l_decap_8
XFILLER_6_797 VPWR VGND sg13cmos5l_decap_8
X_2380_ _2380_/X _2433_/C _2433_/D VPWR VGND sg13cmos5l_and2_1
XFILLER_49_473 VPWR VGND sg13cmos5l_fill_1
XFILLER_37_613 VPWR VGND sg13cmos5l_decap_8
XFILLER_37_602 VPWR VGND sg13cmos5l_decap_8
Xinput6 input6/X uio_in[0] VPWR VGND sg13cmos5l_buf_1
X_3001_ _3001_/Y _3012_/A _3001_/B VPWR VGND sg13cmos5l_nor2_1
XFILLER_36_112 VPWR VGND sg13cmos5l_decap_8
XFILLER_36_156 VPWR VGND sg13cmos5l_fill_1
XFILLER_18_882 VPWR VGND sg13cmos5l_decap_8
XFILLER_33_863 VPWR VGND sg13cmos5l_fill_1
X_2716_ _2717_/B _3419_/Q _3420_/Q _3421_/Q VPWR VGND sg13cmos5l_o21ai_1
X_2647_ _2647_/Y _2647_/A _2647_/B _2647_/C VPWR VGND sg13cmos5l_nor3_1
X_2578_ _2578_/Y _2578_/A _2790_/A _2578_/C VPWR VGND sg13cmos5l_nand3_1
XFILLER_19_36 VPWR VGND sg13cmos5l_decap_4
X_3363__114 _3363_/D VPWR VGND sg13cmos5l_tielo
XFILLER_19_69 VPWR VGND sg13cmos5l_decap_8
XFILLER_28_657 VPWR VGND sg13cmos5l_fill_1
XFILLER_15_307 VPWR VGND sg13cmos5l_decap_8
XFILLER_24_874 VPWR VGND sg13cmos5l_decap_4
XFILLER_11_513 VPWR VGND sg13cmos5l_decap_8
XFILLER_23_384 VPWR VGND sg13cmos5l_fill_2
XFILLER_13_1024 VPWR VGND sg13cmos5l_decap_4
XFILLER_2_211 VPWR VGND sg13cmos5l_decap_8
XFILLER_2_255 VPWR VGND sg13cmos5l_decap_8
XFILLER_19_602 VPWR VGND sg13cmos5l_decap_4
XFILLER_47_955 VPWR VGND sg13cmos5l_decap_8
XFILLER_46_410 VPWR VGND sg13cmos5l_decap_8
XFILLER_19_635 VPWR VGND sg13cmos5l_decap_8
XFILLER_19_646 VPWR VGND sg13cmos5l_fill_1
XFILLER_34_616 VPWR VGND sg13cmos5l_decap_8
XFILLER_34_638 VPWR VGND sg13cmos5l_fill_2
XFILLER_33_159 VPWR VGND sg13cmos5l_fill_2
XFILLER_30_822 VPWR VGND sg13cmos5l_fill_1
X_1880_ _1893_/B _3292_/Q _3275_/Q _2063_/A VPWR VGND sg13cmos5l_mux2_1
XFILLER_30_844 VPWR VGND sg13cmos5l_fill_2
X_3550_ _3550_/Q clkload2/A _3550_/D _3550_/RESET_B VPWR VGND sg13cmos5l_dfrbpq_1
XFILLER_6_561 VPWR VGND sg13cmos5l_decap_8
X_2501_ _2501_/Y _2521_/A _2522_/A _2521_/B VPWR VGND sg13cmos5l_o21ai_1
X_3481_ _3481_/Q clkload4/A _3481_/D _3481_/RESET_B VPWR VGND sg13cmos5l_dfrbpq_1
X_2432_ _3408_/D _2432_/A _2432_/B VPWR VGND sg13cmos5l_nor2_1
X_2363_ _2363_/X _2363_/A _2363_/B VPWR VGND sg13cmos5l_and2_1
X_2294_ _2294_/Y _2224_/B _2296_/B _2293_/Y VPWR VGND sg13cmos5l_a21oi_1
XFILLER_38_922 VPWR VGND sg13cmos5l_decap_8
XFILLER_2_50 VPWR VGND sg13cmos5l_fill_1
XFILLER_38_999 VPWR VGND sg13cmos5l_decap_8
XFILLER_24_148 VPWR VGND sg13cmos5l_fill_2
XFILLER_20_332 VPWR VGND sg13cmos5l_decap_8
XFILLER_32_181 VPWR VGND sg13cmos5l_decap_8
XFILLER_21_888 VPWR VGND sg13cmos5l_decap_8
XFILLER_43_1028 VPWR VGND sg13cmos5l_fill_1
XFILLER_47_218 VPWR VGND sg13cmos5l_decap_8
XFILLER_28_421 VPWR VGND sg13cmos5l_decap_8
XFILLER_29_944 VPWR VGND sg13cmos5l_decap_8
XFILLER_46_56 VPWR VGND sg13cmos5l_fill_2
XFILLER_44_903 VPWR VGND sg13cmos5l_decap_8
XFILLER_16_649 VPWR VGND sg13cmos5l_decap_8
XFILLER_43_479 VPWR VGND sg13cmos5l_fill_2
XFILLER_30_107 VPWR VGND sg13cmos5l_fill_2
XFILLER_31_619 VPWR VGND sg13cmos5l_decap_8
XFILLER_11_310 VPWR VGND sg13cmos5l_decap_8
XFILLER_12_844 VPWR VGND sg13cmos5l_decap_8
XFILLER_30_129 VPWR VGND sg13cmos5l_decap_8
XFILLER_7_314 VPWR VGND sg13cmos5l_decap_4
XFILLER_11_343 VPWR VGND sg13cmos5l_fill_1
XFILLER_8_848 VPWR VGND sg13cmos5l_decap_8
XFILLER_3_553 VPWR VGND sg13cmos5l_decap_8
Xheichips26_dna_sequencer_88 uio_out[6] VPWR VGND sg13cmos5l_tielo
Xheichips26_dna_sequencer_77 uio_oe[3] VPWR VGND sg13cmos5l_tielo
XFILLER_38_207 VPWR VGND sg13cmos5l_decap_8
XFILLER_23_8 VPWR VGND sg13cmos5l_fill_2
XFILLER_4_1022 VPWR VGND sg13cmos5l_decap_8
XFILLER_47_752 VPWR VGND sg13cmos5l_decap_8
XFILLER_19_443 VPWR VGND sg13cmos5l_decap_8
XFILLER_35_903 VPWR VGND sg13cmos5l_fill_1
XFILLER_46_284 VPWR VGND sg13cmos5l_decap_8
XFILLER_19_487 VPWR VGND sg13cmos5l_decap_8
XFILLER_35_958 VPWR VGND sg13cmos5l_decap_8
XFILLER_22_608 VPWR VGND sg13cmos5l_decap_8
XFILLER_34_446 VPWR VGND sg13cmos5l_fill_2
X_2981_ _2981_/Y _3496_/Q _3467_/Q VPWR VGND sg13cmos5l_nand2_1
X_1932_ _3283_/D hold523/X input13/X _1932_/S VPWR VGND sg13cmos5l_mux2_1
XFILLER_30_630 VPWR VGND sg13cmos5l_decap_4
X_1863_ _2581_/B _3394_/Q VPWR VGND sg13cmos5l_inv_1
XFILLER_30_696 VPWR VGND sg13cmos5l_decap_8
XFILLER_7_892 VPWR VGND sg13cmos5l_decap_8
X_3533_ _3533_/Q clkload5/A _3533_/D _3533_/RESET_B VPWR VGND sg13cmos5l_dfrbpq_1
X_3464_ _3464_/Q _3472_/CLK _3464_/D _3464_/RESET_B VPWR VGND sg13cmos5l_dfrbpq_1
X_2415_ _2416_/B _2569_/B _2394_/Y _2415_/S VPWR VGND sg13cmos5l_mux2_1
X_3395_ _3395_/Q _3444_/CLK _3395_/D _3395_/RESET_B VPWR VGND sg13cmos5l_dfrbpq_1
X_2346_ _2348_/B _2345_/Y _2322_/X _2346_/S VPWR VGND sg13cmos5l_mux2_1
X_2277_ _2277_/Y _3378_/Q _2283_/C _2274_/Y VPWR VGND sg13cmos5l_o21ai_1
XFILLER_16_26 VPWR VGND sg13cmos5l_fill_1
XFILLER_26_936 VPWR VGND sg13cmos5l_decap_8
XFILLER_40_449 VPWR VGND sg13cmos5l_fill_2
XFILLER_12_129 VPWR VGND sg13cmos5l_decap_8
XFILLER_21_652 VPWR VGND sg13cmos5l_decap_8
XFILLER_32_47 VPWR VGND sg13cmos5l_fill_1
XFILLER_20_151 VPWR VGND sg13cmos5l_decap_8
XFILLER_4_328 VPWR VGND sg13cmos5l_fill_1
XFILLER_29_752 VPWR VGND sg13cmos5l_decap_4
XFILLER_44_733 VPWR VGND sg13cmos5l_decap_4
XFILLER_17_925 VPWR VGND sg13cmos5l_decap_8
XFILLER_16_435 VPWR VGND sg13cmos5l_fill_2
XFILLER_44_777 VPWR VGND sg13cmos5l_decap_8
XFILLER_43_287 VPWR VGND sg13cmos5l_decap_8
XFILLER_12_630 VPWR VGND sg13cmos5l_fill_2
XFILLER_40_972 VPWR VGND sg13cmos5l_decap_8
XFILLER_12_641 VPWR VGND sg13cmos5l_decap_8
XFILLER_7_166 VPWR VGND sg13cmos5l_fill_2
XFILLER_4_840 VPWR VGND sg13cmos5l_decap_8
XFILLER_3_361 VPWR VGND sg13cmos5l_decap_8
X_2200_ _2293_/A _2187_/X _2199_/Y _2200_/S VPWR VGND sg13cmos5l_mux2_1
X_3180_ _3180_/Y _3180_/A _3180_/B VPWR VGND sg13cmos5l_nand2_1
X_2131_ _2131_/Y _2235_/B _2129_/Y _2130_/Y VPWR VGND sg13cmos5l_a21oi_1
XFILLER_39_527 VPWR VGND sg13cmos5l_decap_8
XFILLER_14_4 VPWR VGND sg13cmos5l_decap_4
X_2062_ _2062_/Y _2043_/A _3283_/Q _1868_/Y VPWR VGND sg13cmos5l_a21oi_1
XFILLER_47_582 VPWR VGND sg13cmos5l_decap_8
XFILLER_19_251 VPWR VGND sg13cmos5l_decap_8
XFILLER_35_711 VPWR VGND sg13cmos5l_decap_8
XFILLER_19_295 VPWR VGND sg13cmos5l_decap_4
XFILLER_34_243 VPWR VGND sg13cmos5l_fill_2
X_2964_ _3497_/D _2966_/A _2964_/B VPWR VGND sg13cmos5l_and2_1
XFILLER_22_427 VPWR VGND sg13cmos5l_decap_8
Xclkbuf_leaf_14_clk _3472_/CLK clkbuf_2_2__f_clk/X VPWR VGND sg13cmos5l_buf_8
X_1915_ _3267_/D input6/X hold528/X _1923_/S VPWR VGND sg13cmos5l_mux2_1
X_2895_ _2896_/B _3473_/Q _3452_/Q _3451_/Q VPWR VGND sg13cmos5l_nor3_1
XFILLER_31_994 VPWR VGND sg13cmos5l_decap_8
X_1846_ _2043_/A _2070_/A VPWR VGND sg13cmos5l_inv_1
Xhold612 _2196_/A _3379_/Q VPWR VGND sg13cmos5l_dlygate4sd3_1
Xhold601 _3396_/D _2418_/Y VPWR VGND sg13cmos5l_dlygate4sd3_1
X_3516_ _3516_/Q _3539_/CLK _3516_/D _3516_/RESET_B VPWR VGND sg13cmos5l_dfrbpq_1
Xhold645 _2930_/B _3457_/Q VPWR VGND sg13cmos5l_dlygate4sd3_1
Xhold623 _3458_/D _2773_/Y VPWR VGND sg13cmos5l_dlygate4sd3_1
Xhold634 _2611_/A _3409_/Q VPWR VGND sg13cmos5l_dlygate4sd3_1
Xhold667 hold667/X _3356_/Q VPWR VGND sg13cmos5l_dlygate4sd3_1
Xhold656 _2217_/A _3334_/Q VPWR VGND sg13cmos5l_dlygate4sd3_1
Xhold678 _1835_/A _3410_/Q VPWR VGND sg13cmos5l_dlygate4sd3_1
X_3447_ _3447_/Q _3485_/CLK _3447_/D _3447_/RESET_B VPWR VGND sg13cmos5l_dfrbpq_1
Xhold689 _1805_/A _3489_/Q VPWR VGND sg13cmos5l_dlygate4sd3_1
X_3378_ _3378_/Q _3378_/CLK _3378_/D _3378_/RESET_B VPWR VGND sg13cmos5l_dfrbpq_1
X_2329_ _2333_/A _2349_/A _2350_/B _2323_/X _2328_/Y _2324_/X VPWR VGND sg13cmos5l_a221oi_1
XFILLER_45_508 VPWR VGND sg13cmos5l_decap_8
XFILLER_27_14 VPWR VGND sg13cmos5l_decap_8
XFILLER_25_210 VPWR VGND sg13cmos5l_decap_8
XFILLER_41_758 VPWR VGND sg13cmos5l_fill_2
XFILLER_40_213 VPWR VGND sg13cmos5l_decap_8
XFILLER_40_257 VPWR VGND sg13cmos5l_fill_2
X_3303__387 _3303_/RESET_B VPWR VGND sg13cmos5l_tiehi
XFILLER_21_493 VPWR VGND sg13cmos5l_decap_4
XFILLER_49_1023 VPWR VGND sg13cmos5l_decap_4
XFILLER_1_865 VPWR VGND sg13cmos5l_decap_8
XFILLER_49_869 VPWR VGND sg13cmos5l_decap_8
XFILLER_48_357 VPWR VGND sg13cmos5l_fill_2
XFILLER_17_722 VPWR VGND sg13cmos5l_decap_8
XFILLER_44_541 VPWR VGND sg13cmos5l_fill_2
XFILLER_44_530 VPWR VGND sg13cmos5l_decap_8
XFILLER_44_574 VPWR VGND sg13cmos5l_decap_8
XFILLER_9_921 VPWR VGND sg13cmos5l_decap_8
XFILLER_13_961 VPWR VGND sg13cmos5l_decap_8
XFILLER_12_460 VPWR VGND sg13cmos5l_decap_4
X_2680_ _2705_/A _3475_/Q _3474_/Q VPWR VGND sg13cmos5l_xnor2_1
XFILLER_12_493 VPWR VGND sg13cmos5l_fill_1
XFILLER_8_497 VPWR VGND sg13cmos5l_decap_8
XFILLER_8_475 VPWR VGND sg13cmos5l_decap_8
XFILLER_9_998 VPWR VGND sg13cmos5l_decap_8
X_3301_ _3301_/Q clkload7/A _3301_/D _3301_/RESET_B VPWR VGND sg13cmos5l_dfrbpq_1
XFILLER_3_180 VPWR VGND sg13cmos5l_fill_1
X_3232_ _3537_/D _3239_/A _3232_/B VPWR VGND sg13cmos5l_nor2_1
Xclkbuf_leaf_3_clk _3551_/CLK clkload0/A VPWR VGND sg13cmos5l_buf_8
XFILLER_39_335 VPWR VGND sg13cmos5l_decap_8
X_3163_ _3165_/A _3487_/Q _3177_/C VPWR VGND sg13cmos5l_and2_1
X_2114_ _2114_/X _2114_/A _2147_/B VPWR VGND sg13cmos5l_and2_1
XFILLER_48_880 VPWR VGND sg13cmos5l_decap_8
X_3094_ _3094_/Y _3517_/Q _3085_/Y _3093_/Y _3518_/Q VPWR VGND sg13cmos5l_a22oi_1
X_2045_ _2045_/X _3290_/Q _3273_/Q _2070_/A VPWR VGND sg13cmos5l_mux2_1
XFILLER_35_541 VPWR VGND sg13cmos5l_decap_8
XFILLER_23_725 VPWR VGND sg13cmos5l_decap_8
Xfanout28 _1971_/A _1941_/S VPWR VGND sg13cmos5l_buf_1
Xfanout39 _2970_/B _2846_/Y VPWR VGND sg13cmos5l_buf_1
X_2947_ _2950_/A _2947_/A _2944_/Y VPWR VGND sg13cmos5l_nor2b_1
XFILLER_31_791 VPWR VGND sg13cmos5l_fill_1
X_2878_ _2878_/Y _2863_/B _2858_/C _2879_/C VPWR VGND sg13cmos5l_a21oi_1
X_1829_ _3123_/A _2928_/A VPWR VGND sg13cmos5l_inv_1
Xhold420 _2609_/B _3403_/Q VPWR VGND sg13cmos5l_dlygate4sd3_1
Xhold442 _2147_/A _3329_/Q VPWR VGND sg13cmos5l_dlygate4sd3_1
XFILLER_2_618 VPWR VGND sg13cmos5l_fill_1
XFILLER_2_607 VPWR VGND sg13cmos5l_decap_8
Xhold453 _2136_/B _3320_/Q VPWR VGND sg13cmos5l_dlygate4sd3_1
Xhold431 _2259_/B _3346_/Q VPWR VGND sg13cmos5l_dlygate4sd3_1
Xhold475 _3516_/D _3105_/Y VPWR VGND sg13cmos5l_dlygate4sd3_1
Xhold464 _1803_/A _3516_/Q VPWR VGND sg13cmos5l_dlygate4sd3_1
Xhold486 _3464_/D _2782_/Y VPWR VGND sg13cmos5l_dlygate4sd3_1
Xhold497 _3370_/D _2256_/Y VPWR VGND sg13cmos5l_dlygate4sd3_1
XFILLER_38_35 VPWR VGND sg13cmos5l_fill_1
XFILLER_38_24 VPWR VGND sg13cmos5l_decap_8
XFILLER_38_46 VPWR VGND sg13cmos5l_decap_8
XFILLER_39_891 VPWR VGND sg13cmos5l_fill_1
XFILLER_14_703 VPWR VGND sg13cmos5l_decap_8
XFILLER_41_522 VPWR VGND sg13cmos5l_fill_2
XFILLER_13_246 VPWR VGND sg13cmos5l_fill_1
XFILLER_22_780 VPWR VGND sg13cmos5l_fill_2
XFILLER_6_902 VPWR VGND sg13cmos5l_decap_8
XFILLER_5_412 VPWR VGND sg13cmos5l_fill_2
XFILLER_10_975 VPWR VGND sg13cmos5l_decap_8
XFILLER_6_979 VPWR VGND sg13cmos5l_decap_8
XFILLER_5_467 VPWR VGND sg13cmos5l_decap_4
X_3449__209 _3449_/RESET_B VPWR VGND sg13cmos5l_tiehi
XFILLER_1_640 VPWR VGND sg13cmos5l_decap_8
XFILLER_49_633 VPWR VGND sg13cmos5l_decap_8
XFILLER_0_150 VPWR VGND sg13cmos5l_decap_4
XFILLER_0_183 VPWR VGND sg13cmos5l_decap_8
XFILLER_49_699 VPWR VGND sg13cmos5l_fill_1
XFILLER_49_688 VPWR VGND sg13cmos5l_decap_8
XFILLER_37_839 VPWR VGND sg13cmos5l_decap_8
X_3460__100 _3460_/D VPWR VGND sg13cmos5l_tielo
XFILLER_45_872 VPWR VGND sg13cmos5l_decap_8
XFILLER_20_728 VPWR VGND sg13cmos5l_decap_8
X_2801_ _2801_/Y _3463_/Q _3434_/Q VPWR VGND sg13cmos5l_xnor2_1
X_2732_ _3451_/D _2839_/A _2732_/B VPWR VGND sg13cmos5l_nor2_1
XFILLER_8_272 VPWR VGND sg13cmos5l_decap_8
XFILLER_8_294 VPWR VGND sg13cmos5l_decap_8
X_2663_ _2664_/A _2655_/Y _2659_/A _2662_/X VPWR VGND sg13cmos5l_o21ai_1
X_2594_ _2595_/B _2758_/B _2583_/Y _2594_/S VPWR VGND sg13cmos5l_mux2_1
XFILLER_8_1009 VPWR VGND sg13cmos5l_decap_8
X_3215_ _3217_/A _3209_/A _3143_/X _3222_/S VPWR VGND sg13cmos5l_a21oi_1
XFILLER_39_132 VPWR VGND sg13cmos5l_decap_4
XFILLER_28_806 VPWR VGND sg13cmos5l_decap_8
X_3146_ _3147_/B _3526_/Q _3129_/Y _3126_/Y VPWR VGND sg13cmos5l_a21oi_1
X_3077_ _3077_/Y _3491_/Q _3534_/Q VPWR VGND sg13cmos5l_nand2b_1
X_2028_ _2162_/B _2147_/A _2114_/A VPWR VGND sg13cmos5l_nor2b_1
XFILLER_36_850 VPWR VGND sg13cmos5l_decap_8
XFILLER_11_706 VPWR VGND sg13cmos5l_fill_2
XFILLER_23_599 VPWR VGND sg13cmos5l_decap_4
XFILLER_40_47 VPWR VGND sg13cmos5l_decap_8
XFILLER_3_905 VPWR VGND sg13cmos5l_decap_8
XFILLER_46_1004 VPWR VGND sg13cmos5l_decap_8
XFILLER_46_614 VPWR VGND sg13cmos5l_decap_8
XFILLER_18_349 VPWR VGND sg13cmos5l_decap_8
XFILLER_42_875 VPWR VGND sg13cmos5l_decap_8
XFILLER_41_330 VPWR VGND sg13cmos5l_decap_8
XFILLER_14_533 VPWR VGND sg13cmos5l_decap_8
XFILLER_14_566 VPWR VGND sg13cmos5l_decap_8
XFILLER_10_772 VPWR VGND sg13cmos5l_fill_2
X_3316__364 _3316_/RESET_B VPWR VGND sg13cmos5l_tiehi
XFILLER_39_6 VPWR VGND sg13cmos5l_fill_1
XFILLER_49_485 VPWR VGND sg13cmos5l_decap_8
XFILLER_49_452 VPWR VGND sg13cmos5l_decap_8
Xinput7 input7/X uio_in[1] VPWR VGND sg13cmos5l_buf_1
X_3000_ _3001_/B _3000_/A _3000_/B VPWR VGND sg13cmos5l_nor2_1
XFILLER_36_102 VPWR VGND sg13cmos5l_decap_4
XFILLER_25_809 VPWR VGND sg13cmos5l_decap_8
X_2715_ _2715_/X _3422_/Q _2717_/A VPWR VGND sg13cmos5l_xor2_1
X_2646_ _2647_/C _2646_/A _2658_/A _2646_/C VPWR VGND sg13cmos5l_nor3_1
X_2577_ _2577_/Y _3395_/Q _2577_/B VPWR VGND sg13cmos5l_nand2_1
XFILLER_28_636 VPWR VGND sg13cmos5l_decap_8
X_3129_ _3129_/Y _3127_/Y _3128_/Y _3126_/Y VPWR VGND sg13cmos5l_a21oi_1
XFILLER_28_669 VPWR VGND sg13cmos5l_decap_8
XFILLER_27_179 VPWR VGND sg13cmos5l_decap_8
X_3439__219 _3439_/RESET_B VPWR VGND sg13cmos5l_tiehi
XFILLER_13_1003 VPWR VGND sg13cmos5l_decap_8
XFILLER_3_779 VPWR VGND sg13cmos5l_decap_8
XFILLER_47_934 VPWR VGND sg13cmos5l_decap_8
XFILLER_18_102 VPWR VGND sg13cmos5l_decap_8
XFILLER_46_466 VPWR VGND sg13cmos5l_decap_8
XFILLER_33_105 VPWR VGND sg13cmos5l_decap_8
XFILLER_15_864 VPWR VGND sg13cmos5l_decap_8
XFILLER_42_683 VPWR VGND sg13cmos5l_fill_2
XFILLER_14_352 VPWR VGND sg13cmos5l_fill_1
XFILLER_30_834 VPWR VGND sg13cmos5l_fill_1
XFILLER_30_878 VPWR VGND sg13cmos5l_decap_8
XFILLER_30_889 VPWR VGND sg13cmos5l_fill_1
X_3480_ _3480_/Q clkload4/A _3480_/D _3480_/RESET_B VPWR VGND sg13cmos5l_dfrbpq_1
X_2500_ _2521_/B _3445_/Q _2500_/B VPWR VGND sg13cmos5l_xnor2_1
X_2431_ _3407_/D _2431_/A _2432_/B VPWR VGND sg13cmos5l_nor2_1
XFILLER_6_584 VPWR VGND sg13cmos5l_decap_8
XFILLER_44_4 VPWR VGND sg13cmos5l_decap_8
XFILLER_29_1021 VPWR VGND sg13cmos5l_decap_8
X_2362_ _2363_/B _3360_/Q _3361_/Q _3362_/Q VPWR VGND sg13cmos5l_o21ai_1
X_2293_ _2293_/Y _2293_/A _2296_/B VPWR VGND sg13cmos5l_nor2_1
XFILLER_38_901 VPWR VGND sg13cmos5l_decap_8
XFILLER_2_73 VPWR VGND sg13cmos5l_decap_8
XFILLER_38_978 VPWR VGND sg13cmos5l_decap_8
XFILLER_37_477 VPWR VGND sg13cmos5l_decap_4
XFILLER_40_609 VPWR VGND sg13cmos5l_fill_1
XFILLER_33_672 VPWR VGND sg13cmos5l_decap_8
XFILLER_20_311 VPWR VGND sg13cmos5l_decap_8
X_2629_ _2639_/A _3440_/Q _2645_/B VPWR VGND sg13cmos5l_nor2_1
XFILLER_43_1007 VPWR VGND sg13cmos5l_decap_8
XFILLER_0_749 VPWR VGND sg13cmos5l_decap_8
XFILLER_29_923 VPWR VGND sg13cmos5l_decap_8
XFILLER_46_35 VPWR VGND sg13cmos5l_decap_8
XFILLER_44_959 VPWR VGND sg13cmos5l_decap_8
XFILLER_12_812 VPWR VGND sg13cmos5l_decap_8
XFILLER_11_300 VPWR VGND sg13cmos5l_decap_4
XFILLER_8_827 VPWR VGND sg13cmos5l_decap_8
XFILLER_3_532 VPWR VGND sg13cmos5l_decap_8
Xheichips26_dna_sequencer_89 uio_out[7] VPWR VGND sg13cmos5l_tielo
Xheichips26_dna_sequencer_78 uio_oe[4] VPWR VGND sg13cmos5l_tielo
X_3313__367 _3313_/RESET_B VPWR VGND sg13cmos5l_tiehi
XFILLER_4_1001 VPWR VGND sg13cmos5l_decap_8
XFILLER_47_731 VPWR VGND sg13cmos5l_decap_8
XFILLER_47_720 VPWR VGND sg13cmos5l_fill_2
XFILLER_19_411 VPWR VGND sg13cmos5l_decap_8
XFILLER_46_263 VPWR VGND sg13cmos5l_decap_8
XFILLER_35_937 VPWR VGND sg13cmos5l_decap_8
X_2980_ _2980_/X _2908_/B _2874_/B _3005_/B VPWR VGND sg13cmos5l_mux2_1
XFILLER_21_108 VPWR VGND sg13cmos5l_fill_1
X_1931_ _3282_/D hold541/X input12/X _1932_/S VPWR VGND sg13cmos5l_mux2_1
X_1862_ _2569_/B _1862_/A VPWR VGND sg13cmos5l_inv_1
Xinput10 input10/X uio_in[4] VPWR VGND sg13cmos5l_buf_1
XFILLER_7_871 VPWR VGND sg13cmos5l_decap_8
X_3532_ _3532_/Q clkload5/A _3532_/D _3532_/RESET_B VPWR VGND sg13cmos5l_dfrbpq_1
X_3463_ _3463_/Q _3463_/CLK _3463_/D _3463_/RESET_B VPWR VGND sg13cmos5l_dfrbpq_1
X_2414_ _3394_/D _2432_/B _2414_/B VPWR VGND sg13cmos5l_nor2_1
X_3394_ _3394_/Q _3444_/CLK _3394_/D _3394_/RESET_B VPWR VGND sg13cmos5l_dfrbpq_1
XFILLER_35_0 VPWR VGND sg13cmos5l_decap_4
X_2345_ _2345_/Y _2529_/A _2349_/B VPWR VGND sg13cmos5l_nand2_1
X_2276_ _2282_/A _2283_/D _2281_/B VPWR VGND sg13cmos5l_nor2_1
XFILLER_38_764 VPWR VGND sg13cmos5l_decap_8
XFILLER_26_915 VPWR VGND sg13cmos5l_decap_8
XFILLER_25_436 VPWR VGND sg13cmos5l_decap_4
XFILLER_21_631 VPWR VGND sg13cmos5l_decap_8
XFILLER_5_819 VPWR VGND sg13cmos5l_decap_8
XFILLER_10_1017 VPWR VGND sg13cmos5l_decap_8
XFILLER_10_1028 VPWR VGND sg13cmos5l_fill_1
XFILLER_0_579 VPWR VGND sg13cmos5l_decap_8
XFILLER_29_731 VPWR VGND sg13cmos5l_decap_8
XFILLER_44_712 VPWR VGND sg13cmos5l_decap_8
XFILLER_16_414 VPWR VGND sg13cmos5l_decap_8
XFILLER_28_263 VPWR VGND sg13cmos5l_fill_2
XFILLER_44_756 VPWR VGND sg13cmos5l_decap_8
XFILLER_43_277 VPWR VGND sg13cmos5l_fill_1
XFILLER_43_266 VPWR VGND sg13cmos5l_fill_2
XFILLER_43_255 VPWR VGND sg13cmos5l_decap_8
XFILLER_31_406 VPWR VGND sg13cmos5l_decap_8
XFILLER_32_929 VPWR VGND sg13cmos5l_decap_8
XFILLER_40_951 VPWR VGND sg13cmos5l_decap_8
XFILLER_8_624 VPWR VGND sg13cmos5l_decap_8
XFILLER_8_679 VPWR VGND sg13cmos5l_decap_4
XFILLER_11_185 VPWR VGND sg13cmos5l_decap_8
XFILLER_4_896 VPWR VGND sg13cmos5l_decap_8
XFILLER_26_1013 VPWR VGND sg13cmos5l_decap_8
X_2130_ _2130_/Y _2122_/X _2129_/Y _2147_/B VPWR VGND sg13cmos5l_o21ai_1
X_2061_ _2061_/Y _2070_/A _3266_/Q VPWR VGND sg13cmos5l_nand2_1
XFILLER_19_230 VPWR VGND sg13cmos5l_decap_8
XFILLER_34_211 VPWR VGND sg13cmos5l_decap_8
X_3359__312 _3359_/RESET_B VPWR VGND sg13cmos5l_tiehi
XFILLER_16_981 VPWR VGND sg13cmos5l_decap_8
X_2963_ _3496_/D _1795_/Y _2963_/A2 _2962_/Y VPWR VGND sg13cmos5l_a21oi_1
XFILLER_15_491 VPWR VGND sg13cmos5l_decap_8
X_1914_ _1922_/S _1914_/A _1970_/B VPWR VGND sg13cmos5l_or2_1
XFILLER_31_973 VPWR VGND sg13cmos5l_decap_8
XFILLER_8_50 VPWR VGND sg13cmos5l_fill_2
X_2894_ _2894_/Y _2893_/A _2893_/B _2705_/A VPWR VGND sg13cmos5l_a21oi_1
X_1845_ _2431_/A _1845_/A VPWR VGND sg13cmos5l_inv_1
XFILLER_8_94 VPWR VGND sg13cmos5l_fill_2
Xhold602 _1834_/A _3411_/Q VPWR VGND sg13cmos5l_dlygate4sd3_1
Xhold624 _2134_/B _3340_/Q VPWR VGND sg13cmos5l_dlygate4sd3_1
X_3515_ _3515_/Q clkload5/A _3515_/D _3515_/RESET_B VPWR VGND sg13cmos5l_dfrbpq_1
Xhold613 _2928_/A _3507_/Q VPWR VGND sg13cmos5l_dlygate4sd3_1
Xhold635 _1841_/A _3445_/Q VPWR VGND sg13cmos5l_dlygate4sd3_1
Xhold668 _2104_/A _3333_/Q VPWR VGND sg13cmos5l_dlygate4sd3_1
Xhold657 _3130_/A _3530_/Q VPWR VGND sg13cmos5l_dlygate4sd3_1
Xhold646 _3457_/D _2771_/Y VPWR VGND sg13cmos5l_dlygate4sd3_1
Xhold679 hold679/X _3460_/Q VPWR VGND sg13cmos5l_dlygate4sd3_1
X_3446_ _3446_/Q _3485_/CLK _3446_/D _3446_/RESET_B VPWR VGND sg13cmos5l_dfrbpq_1
X_3377_ _3377_/Q _3378_/CLK _3377_/D _3377_/RESET_B VPWR VGND sg13cmos5l_dfrbpq_1
X_2328_ _2328_/Y _2325_/Y _2326_/Y _2327_/Y _3410_/Q VPWR VGND sg13cmos5l_a22oi_1
XFILLER_38_550 VPWR VGND sg13cmos5l_decap_8
X_2259_ _3372_/D _2610_/A _2259_/B VPWR VGND sg13cmos5l_and2_1
XFILLER_13_406 VPWR VGND sg13cmos5l_decap_4
XFILLER_26_789 VPWR VGND sg13cmos5l_decap_8
XFILLER_43_36 VPWR VGND sg13cmos5l_decap_8
XFILLER_41_737 VPWR VGND sg13cmos5l_decap_8
XFILLER_40_236 VPWR VGND sg13cmos5l_decap_8
XFILLER_22_995 VPWR VGND sg13cmos5l_decap_8
XFILLER_49_1002 VPWR VGND sg13cmos5l_decap_8
XFILLER_0_321 VPWR VGND sg13cmos5l_fill_2
XFILLER_1_844 VPWR VGND sg13cmos5l_decap_8
XFILLER_49_848 VPWR VGND sg13cmos5l_decap_8
XFILLER_0_398 VPWR VGND sg13cmos5l_fill_2
XFILLER_29_561 VPWR VGND sg13cmos5l_decap_8
XFILLER_1_1026 VPWR VGND sg13cmos5l_fill_2
XFILLER_29_583 VPWR VGND sg13cmos5l_decap_8
XFILLER_29_594 VPWR VGND sg13cmos5l_fill_1
XFILLER_17_767 VPWR VGND sg13cmos5l_decap_8
X_3458__200 _3458_/RESET_B VPWR VGND sg13cmos5l_tiehi
XFILLER_31_225 VPWR VGND sg13cmos5l_fill_2
XFILLER_32_748 VPWR VGND sg13cmos5l_decap_8
XFILLER_9_900 VPWR VGND sg13cmos5l_decap_8
XFILLER_13_940 VPWR VGND sg13cmos5l_decap_8
XFILLER_31_236 VPWR VGND sg13cmos5l_fill_1
X_3493__157 _3493_/RESET_B VPWR VGND sg13cmos5l_tiehi
XFILLER_8_454 VPWR VGND sg13cmos5l_decap_8
XFILLER_9_977 VPWR VGND sg13cmos5l_decap_8
XFILLER_33_91 VPWR VGND sg13cmos5l_decap_8
X_3300_ _3300_/Q clkload7/A _3300_/D _3300_/RESET_B VPWR VGND sg13cmos5l_dfrbpq_1
X_3231_ _3231_/Y _3230_/A _3229_/A _3229_/Y _3230_/Y VPWR VGND sg13cmos5l_a22oi_1
X_3162_ _3162_/Y _2879_/A _3156_/Y _3166_/B _3166_/A VPWR VGND sg13cmos5l_a22oi_1
X_2113_ _3332_/D _2176_/A _2162_/D VPWR VGND sg13cmos5l_nor2_1
XFILLER_27_509 VPWR VGND sg13cmos5l_decap_8
X_3093_ _3093_/Y _3093_/A VPWR VGND sg13cmos5l_inv_1
X_2044_ _2044_/Y _2070_/A _3271_/Q _2042_/Y VPWR VGND sg13cmos5l_a21oi_1
XFILLER_35_520 VPWR VGND sg13cmos5l_decap_8
XFILLER_22_203 VPWR VGND sg13cmos5l_decap_4
XFILLER_22_214 VPWR VGND sg13cmos5l_decap_4
Xfanout29 _1923_/S _1922_/S VPWR VGND sg13cmos5l_buf_1
XFILLER_35_586 VPWR VGND sg13cmos5l_fill_2
XFILLER_22_247 VPWR VGND sg13cmos5l_fill_2
X_2946_ _2946_/Y _2936_/Y _2944_/Y _2945_/Y VPWR VGND sg13cmos5l_a21oi_1
X_2877_ _3479_/D _2968_/B _2974_/A VPWR VGND sg13cmos5l_nor2_1
X_1828_ _3122_/A _1828_/A VPWR VGND sg13cmos5l_inv_1
Xhold443 _3351_/D _2147_/X VPWR VGND sg13cmos5l_dlygate4sd3_1
XFILLER_1_107 VPWR VGND sg13cmos5l_fill_1
Xhold454 _1874_/A _3542_/Q VPWR VGND sg13cmos5l_dlygate4sd3_1
Xhold421 _2608_/B _3402_/Q VPWR VGND sg13cmos5l_dlygate4sd3_1
Xhold432 _2260_/B _3347_/Q VPWR VGND sg13cmos5l_dlygate4sd3_1
Xhold476 hold476/X _3306_/Q VPWR VGND sg13cmos5l_dlygate4sd3_1
Xhold465 _3303_/D _1973_/Y VPWR VGND sg13cmos5l_dlygate4sd3_1
Xhold487 hold487/X _3343_/Q VPWR VGND sg13cmos5l_dlygate4sd3_1
X_3429_ _3429_/Q _3551_/CLK _3429_/D _3429_/RESET_B VPWR VGND sg13cmos5l_dfrbpq_1
Xhold498 hold498/X _3284_/Q VPWR VGND sg13cmos5l_dlygate4sd3_1
XFILLER_46_807 VPWR VGND sg13cmos5l_decap_8
XFILLER_45_306 VPWR VGND sg13cmos5l_decap_8
XFILLER_38_391 VPWR VGND sg13cmos5l_fill_2
XFILLER_41_501 VPWR VGND sg13cmos5l_decap_8
XFILLER_13_225 VPWR VGND sg13cmos5l_decap_8
XFILLER_41_578 VPWR VGND sg13cmos5l_fill_2
XFILLER_9_218 VPWR VGND sg13cmos5l_decap_4
XFILLER_16_1023 VPWR VGND sg13cmos5l_decap_4
XFILLER_10_954 VPWR VGND sg13cmos5l_decap_8
XFILLER_6_958 VPWR VGND sg13cmos5l_decap_8
XFILLER_5_435 VPWR VGND sg13cmos5l_decap_4
XFILLER_49_623 VPWR VGND sg13cmos5l_fill_2
XFILLER_49_612 VPWR VGND sg13cmos5l_decap_8
X_3349__322 _3349_/RESET_B VPWR VGND sg13cmos5l_tiehi
XFILLER_0_162 VPWR VGND sg13cmos5l_decap_8
XFILLER_36_317 VPWR VGND sg13cmos5l_decap_8
XFILLER_48_199 VPWR VGND sg13cmos5l_decap_4
XFILLER_44_372 VPWR VGND sg13cmos5l_fill_2
X_3356__315 _3356_/RESET_B VPWR VGND sg13cmos5l_tiehi
XFILLER_20_718 VPWR VGND sg13cmos5l_decap_4
X_2800_ _2800_/Y _3462_/Q _3433_/Q VPWR VGND sg13cmos5l_xnor2_1
XFILLER_32_578 VPWR VGND sg13cmos5l_fill_1
X_2731_ _2731_/Y _2731_/A _2731_/B VPWR VGND sg13cmos5l_nor2_1
XFILLER_12_280 VPWR VGND sg13cmos5l_decap_8
XFILLER_9_785 VPWR VGND sg13cmos5l_fill_1
X_2662_ _2662_/X _3440_/Q _2662_/B _2662_/C VPWR VGND sg13cmos5l_or3_1
X_2593_ _2593_/Y _2576_/Y _2594_/S _2592_/Y VPWR VGND sg13cmos5l_a21oi_1
XFILLER_5_980 VPWR VGND sg13cmos5l_decap_8
X_3214_ _3222_/S _3211_/Y _3213_/Y _3145_/Y VPWR VGND sg13cmos5l_o21ai_1
X_3363__308 _3363_/RESET_B VPWR VGND sg13cmos5l_tiehi
XFILLER_39_111 VPWR VGND sg13cmos5l_decap_8
XFILLER_39_177 VPWR VGND sg13cmos5l_decap_4
X_3145_ _3145_/Y _3212_/A _3145_/B VPWR VGND sg13cmos5l_nand2b_1
XFILLER_27_317 VPWR VGND sg13cmos5l_decap_8
X_3076_ _3076_/Y _3490_/Q _3091_/A _3063_/A _3489_/Q _3075_/Y VPWR VGND sg13cmos5l_a221oi_1
XFILLER_27_328 VPWR VGND sg13cmos5l_fill_2
X_2027_ _2027_/Y _2021_/Y _2026_/Y _2030_/A VPWR VGND sg13cmos5l_a21oi_1
XFILLER_35_383 VPWR VGND sg13cmos5l_decap_8
XFILLER_23_556 VPWR VGND sg13cmos5l_fill_1
XFILLER_24_49 VPWR VGND sg13cmos5l_decap_8
XFILLER_35_394 VPWR VGND sg13cmos5l_decap_8
XFILLER_10_239 VPWR VGND sg13cmos5l_decap_8
X_2929_ _2952_/A hold679/X _2926_/Y _2928_/Y VPWR VGND sg13cmos5l_o21ai_1
XFILLER_2_438 VPWR VGND sg13cmos5l_decap_8
XFILLER_49_24 VPWR VGND sg13cmos5l_decap_8
X_3448__210 _3448_/RESET_B VPWR VGND sg13cmos5l_tiehi
XFILLER_49_68 VPWR VGND sg13cmos5l_fill_2
XFILLER_46_659 VPWR VGND sg13cmos5l_fill_2
XFILLER_45_147 VPWR VGND sg13cmos5l_fill_2
XFILLER_14_501 VPWR VGND sg13cmos5l_decap_4
XFILLER_27_884 VPWR VGND sg13cmos5l_fill_2
X_3455__203 _3455_/RESET_B VPWR VGND sg13cmos5l_tiehi
XFILLER_14_82 VPWR VGND sg13cmos5l_decap_4
XFILLER_6_777 VPWR VGND sg13cmos5l_fill_2
XFILLER_5_298 VPWR VGND sg13cmos5l_decap_4
XFILLER_2_994 VPWR VGND sg13cmos5l_decap_8
XFILLER_49_431 VPWR VGND sg13cmos5l_decap_8
Xinput8 input8/X uio_in[2] VPWR VGND sg13cmos5l_buf_1
XFILLER_37_648 VPWR VGND sg13cmos5l_decap_8
XFILLER_33_810 VPWR VGND sg13cmos5l_decap_8
XFILLER_33_854 VPWR VGND sg13cmos5l_decap_8
XFILLER_9_560 VPWR VGND sg13cmos5l_decap_8
XFILLER_9_571 VPWR VGND sg13cmos5l_fill_1
X_2714_ _2737_/A _3423_/Q _2714_/B VPWR VGND sg13cmos5l_xor2_1
X_3514__355 _3514_/RESET_B VPWR VGND sg13cmos5l_tiehi
X_2645_ _2646_/C _2645_/A _2645_/B VPWR VGND sg13cmos5l_nor2_1
X_2576_ _2576_/Y _2577_/B _2573_/Y _2578_/C _2575_/Y VPWR VGND sg13cmos5l_a22oi_1
X_3547__131 _3547_/RESET_B VPWR VGND sg13cmos5l_tiehi
XFILLER_28_615 VPWR VGND sg13cmos5l_decap_8
X_3128_ _3128_/Y _3523_/Q _3497_/Q VPWR VGND sg13cmos5l_xnor2_1
XFILLER_43_629 VPWR VGND sg13cmos5l_decap_8
X_3059_ _3070_/A _3053_/Y _3057_/Y _3058_/Y VPWR VGND sg13cmos5l_o21ai_1
XFILLER_24_898 VPWR VGND sg13cmos5l_fill_1
XFILLER_11_548 VPWR VGND sg13cmos5l_decap_8
XFILLER_23_386 VPWR VGND sg13cmos5l_fill_1
XFILLER_4_4 VPWR VGND sg13cmos5l_fill_2
XFILLER_3_758 VPWR VGND sg13cmos5l_decap_8
XFILLER_47_913 VPWR VGND sg13cmos5l_decap_8
XFILLER_19_615 VPWR VGND sg13cmos5l_decap_8
X_3346__325 _3346_/RESET_B VPWR VGND sg13cmos5l_tiehi
XFILLER_20_1008 VPWR VGND sg13cmos5l_decap_8
XFILLER_27_681 VPWR VGND sg13cmos5l_decap_4
XFILLER_41_150 VPWR VGND sg13cmos5l_decap_8
XFILLER_30_802 VPWR VGND sg13cmos5l_fill_2
XFILLER_14_375 VPWR VGND sg13cmos5l_decap_4
XFILLER_30_857 VPWR VGND sg13cmos5l_decap_8
XFILLER_41_194 VPWR VGND sg13cmos5l_fill_2
X_3353__318 _3353_/RESET_B VPWR VGND sg13cmos5l_tiehi
XFILLER_10_581 VPWR VGND sg13cmos5l_fill_1
XFILLER_41_91 VPWR VGND sg13cmos5l_decap_8
X_2430_ _3406_/D _2430_/A _2432_/B VPWR VGND sg13cmos5l_nor2_1
XFILLER_29_1000 VPWR VGND sg13cmos5l_decap_8
X_2361_ _2361_/Y _2429_/A _1836_/Y _2377_/C _2359_/A VPWR VGND sg13cmos5l_a22oi_1
X_2292_ _2296_/B _2290_/Y _2291_/Y _2289_/Y VPWR VGND sg13cmos5l_o21ai_1
XFILLER_2_791 VPWR VGND sg13cmos5l_decap_8
XFILLER_49_283 VPWR VGND sg13cmos5l_decap_8
XFILLER_38_957 VPWR VGND sg13cmos5l_decap_8
XFILLER_37_401 VPWR VGND sg13cmos5l_fill_1
XFILLER_49_294 VPWR VGND sg13cmos5l_fill_1
XFILLER_46_990 VPWR VGND sg13cmos5l_decap_8
XFILLER_25_629 VPWR VGND sg13cmos5l_decap_8
XFILLER_17_191 VPWR VGND sg13cmos5l_decap_8
XFILLER_24_128 VPWR VGND sg13cmos5l_fill_2
XFILLER_36_1015 VPWR VGND sg13cmos5l_decap_8
XFILLER_21_824 VPWR VGND sg13cmos5l_decap_8
X_3397__267 _3397_/RESET_B VPWR VGND sg13cmos5l_tiehi
X_3438__220 _3438_/RESET_B VPWR VGND sg13cmos5l_tiehi
XFILLER_21_857 VPWR VGND sg13cmos5l_decap_8
XFILLER_9_390 VPWR VGND sg13cmos5l_decap_8
X_2628_ _2662_/B _2626_/Y _2627_/Y _2640_/A VPWR VGND sg13cmos5l_a21oi_1
XFILLER_0_728 VPWR VGND sg13cmos5l_decap_8
X_2559_ _2561_/B _2617_/C _2617_/D VPWR VGND sg13cmos5l_nand2_1
X_3445__213 _3445_/RESET_B VPWR VGND sg13cmos5l_tiehi
XFILLER_29_902 VPWR VGND sg13cmos5l_decap_8
XFILLER_29_979 VPWR VGND sg13cmos5l_decap_8
XFILLER_46_69 VPWR VGND sg13cmos5l_decap_8
XFILLER_44_938 VPWR VGND sg13cmos5l_decap_8
XFILLER_43_426 VPWR VGND sg13cmos5l_decap_8
XFILLER_16_629 VPWR VGND sg13cmos5l_decap_8
XFILLER_30_109 VPWR VGND sg13cmos5l_fill_1
XFILLER_23_172 VPWR VGND sg13cmos5l_decap_8
XFILLER_24_695 VPWR VGND sg13cmos5l_decap_8
XFILLER_7_327 VPWR VGND sg13cmos5l_fill_2
X_3452__206 _3452_/RESET_B VPWR VGND sg13cmos5l_tiehi
XFILLER_3_500 VPWR VGND sg13cmos5l_decap_8
Xheichips26_dna_sequencer_79 uio_oe[5] VPWR VGND sg13cmos5l_tielo
XFILLER_3_577 VPWR VGND sg13cmos5l_fill_1
XFILLER_47_787 VPWR VGND sg13cmos5l_decap_8
XFILLER_35_916 VPWR VGND sg13cmos5l_decap_8
XFILLER_28_990 VPWR VGND sg13cmos5l_decap_8
XFILLER_34_426 VPWR VGND sg13cmos5l_decap_8
XFILLER_15_673 VPWR VGND sg13cmos5l_decap_8
XFILLER_43_993 VPWR VGND sg13cmos5l_decap_8
X_1930_ _3281_/D hold521/X input11/X _1932_/S VPWR VGND sg13cmos5l_mux2_1
X_1861_ _2417_/A _3397_/Q VPWR VGND sg13cmos5l_inv_1
XFILLER_30_654 VPWR VGND sg13cmos5l_decap_4
Xinput11 input11/X uio_in[5] VPWR VGND sg13cmos5l_buf_1
XFILLER_30_676 VPWR VGND sg13cmos5l_decap_8
XFILLER_7_850 VPWR VGND sg13cmos5l_decap_8
X_3531_ _3531_/Q clkload5/A _3531_/D _3531_/RESET_B VPWR VGND sg13cmos5l_dfrbpq_1
XFILLER_6_382 VPWR VGND sg13cmos5l_fill_1
X_3462_ _3462_/Q clkload3/A _3462_/D _3462_/RESET_B VPWR VGND sg13cmos5l_dfrbpq_1
X_3393_ _3393_/Q _3444_/CLK _3393_/D _3393_/RESET_B VPWR VGND sg13cmos5l_dfrbpq_1
X_2413_ _2413_/Y hold640/X _2415_/S _2412_/Y VPWR VGND sg13cmos5l_o21ai_1
X_2344_ _3384_/D _2383_/A _2344_/B VPWR VGND sg13cmos5l_nor2_1
X_2275_ _2281_/B _3377_/Q _2283_/C VPWR VGND sg13cmos5l_xnor2_1
XFILLER_25_415 VPWR VGND sg13cmos5l_fill_2
XFILLER_16_39 VPWR VGND sg13cmos5l_decap_8
XFILLER_19_990 VPWR VGND sg13cmos5l_decap_8
XFILLER_41_919 VPWR VGND sg13cmos5l_decap_8
XFILLER_40_418 VPWR VGND sg13cmos5l_decap_4
XFILLER_21_676 VPWR VGND sg13cmos5l_decap_8
XFILLER_4_319 VPWR VGND sg13cmos5l_decap_8
XFILLER_4_308 VPWR VGND sg13cmos5l_fill_2
XFILLER_0_525 VPWR VGND sg13cmos5l_decap_8
XFILLER_0_558 VPWR VGND sg13cmos5l_fill_2
XFILLER_29_787 VPWR VGND sg13cmos5l_decap_4
XFILLER_43_234 VPWR VGND sg13cmos5l_decap_8
XFILLER_16_437 VPWR VGND sg13cmos5l_fill_1
XFILLER_32_908 VPWR VGND sg13cmos5l_decap_8
XFILLER_40_930 VPWR VGND sg13cmos5l_decap_8
XFILLER_25_993 VPWR VGND sg13cmos5l_decap_8
XFILLER_7_113 VPWR VGND sg13cmos5l_decap_4
XFILLER_11_164 VPWR VGND sg13cmos5l_decap_8
XFILLER_12_676 VPWR VGND sg13cmos5l_decap_4
XFILLER_12_698 VPWR VGND sg13cmos5l_decap_4
XFILLER_8_658 VPWR VGND sg13cmos5l_decap_8
XFILLER_22_60 VPWR VGND sg13cmos5l_fill_2
XFILLER_7_168 VPWR VGND sg13cmos5l_fill_1
XFILLER_4_875 VPWR VGND sg13cmos5l_decap_8
XFILLER_3_385 VPWR VGND sg13cmos5l_decap_8
X_3387__277 _3387_/RESET_B VPWR VGND sg13cmos5l_tiehi
XFILLER_39_518 VPWR VGND sg13cmos5l_decap_4
XFILLER_47_540 VPWR VGND sg13cmos5l_fill_2
X_2060_ _2060_/X _3311_/Q _2060_/B VPWR VGND sg13cmos5l_or2_1
XFILLER_19_220 VPWR VGND sg13cmos5l_decap_4
XFILLER_19_286 VPWR VGND sg13cmos5l_decap_4
XFILLER_35_746 VPWR VGND sg13cmos5l_decap_8
XFILLER_16_960 VPWR VGND sg13cmos5l_decap_8
XFILLER_34_245 VPWR VGND sg13cmos5l_fill_1
X_2962_ _2962_/Y hold577/X _2962_/A2 _2966_/A VPWR VGND sg13cmos5l_o21ai_1
X_1913_ _1970_/B input3/X input2/X _1948_/A VPWR VGND sg13cmos5l_nand3_1
XFILLER_31_952 VPWR VGND sg13cmos5l_decap_8
X_2893_ _2913_/B _2893_/A _2893_/B VPWR VGND sg13cmos5l_and2_1
XFILLER_8_62 VPWR VGND sg13cmos5l_decap_8
X_1844_ _2971_/A _2759_/B VPWR VGND sg13cmos5l_inv_1
X_3435__223 _3435_/RESET_B VPWR VGND sg13cmos5l_tiehi
XFILLER_30_495 VPWR VGND sg13cmos5l_fill_2
Xhold603 _3438_/D _2613_/Y VPWR VGND sg13cmos5l_dlygate4sd3_1
Xhold614 _2034_/B _3318_/Q VPWR VGND sg13cmos5l_dlygate4sd3_1
Xhold636 _1845_/A _3381_/Q VPWR VGND sg13cmos5l_dlygate4sd3_1
Xhold625 hold625/X _2134_/Y VPWR VGND sg13cmos5l_dlygate4sd3_1
X_3514_ _3514_/Q clkload5/A _3514_/D _3514_/RESET_B VPWR VGND sg13cmos5l_dfrbpq_1
Xhold669 _2820_/A _3468_/Q VPWR VGND sg13cmos5l_dlygate4sd3_1
Xhold658 _1859_/A _3425_/Q VPWR VGND sg13cmos5l_dlygate4sd3_1
Xhold647 hold647/X _3550_/Q VPWR VGND sg13cmos5l_dlygate4sd3_1
X_3445_ _3445_/Q _3472_/CLK _3445_/D _3445_/RESET_B VPWR VGND sg13cmos5l_dfrbpq_1
X_3376_ _3376_/Q _3378_/CLK _3376_/D _3376_/RESET_B VPWR VGND sg13cmos5l_dfrbpq_1
X_2327_ _2327_/Y _3384_/Q _3383_/Q _3409_/Q VPWR VGND sg13cmos5l_nand3b_1
X_3442__216 _3442_/RESET_B VPWR VGND sg13cmos5l_tiehi
X_2258_ _3371_/D _1810_/Y _2963_/A2 _2257_/Y VPWR VGND sg13cmos5l_a21oi_1
XFILLER_27_49 VPWR VGND sg13cmos5l_decap_8
X_2189_ _2189_/Y _2183_/Y _2202_/A _2187_/X _2430_/A _2188_/Y VPWR VGND sg13cmos5l_a221oi_1
XFILLER_38_595 VPWR VGND sg13cmos5l_fill_2
XFILLER_38_584 VPWR VGND sg13cmos5l_decap_8
X_3522__262 _3522_/RESET_B VPWR VGND sg13cmos5l_tiehi
XFILLER_14_908 VPWR VGND sg13cmos5l_fill_1
XFILLER_25_267 VPWR VGND sg13cmos5l_decap_8
XFILLER_26_768 VPWR VGND sg13cmos5l_decap_8
XFILLER_43_59 VPWR VGND sg13cmos5l_decap_8
XFILLER_40_259 VPWR VGND sg13cmos5l_fill_1
XFILLER_21_473 VPWR VGND sg13cmos5l_decap_8
XFILLER_22_974 VPWR VGND sg13cmos5l_decap_8
XFILLER_5_639 VPWR VGND sg13cmos5l_decap_8
XFILLER_0_300 VPWR VGND sg13cmos5l_decap_8
XFILLER_1_823 VPWR VGND sg13cmos5l_decap_8
XFILLER_49_827 VPWR VGND sg13cmos5l_decap_8
XFILLER_0_377 VPWR VGND sg13cmos5l_decap_8
XFILLER_48_359 VPWR VGND sg13cmos5l_fill_1
XFILLER_1_1005 VPWR VGND sg13cmos5l_decap_8
XFILLER_17_702 VPWR VGND sg13cmos5l_decap_4
XFILLER_29_551 VPWR VGND sg13cmos5l_decap_4
XFILLER_44_510 VPWR VGND sg13cmos5l_fill_2
XFILLER_44_554 VPWR VGND sg13cmos5l_decap_8
XFILLER_16_245 VPWR VGND sg13cmos5l_decap_8
XFILLER_32_705 VPWR VGND sg13cmos5l_decap_8
XFILLER_31_248 VPWR VGND sg13cmos5l_decap_8
XFILLER_13_996 VPWR VGND sg13cmos5l_decap_8
XFILLER_8_433 VPWR VGND sg13cmos5l_decap_8
XFILLER_9_956 VPWR VGND sg13cmos5l_decap_8
XFILLER_3_193 VPWR VGND sg13cmos5l_fill_2
X_3230_ _3230_/Y _3230_/A _3545_/Q VPWR VGND sg13cmos5l_nand2_1
XFILLER_39_315 VPWR VGND sg13cmos5l_decap_4
X_3161_ _3166_/B _3486_/Q _3161_/B VPWR VGND sg13cmos5l_xnor2_1
X_2112_ _2162_/D _2095_/Y _2104_/Y _2226_/A VPWR VGND sg13cmos5l_a21oi_1
X_3092_ _3093_/A _2951_/Y _3091_/Y _3095_/B VPWR VGND sg13cmos5l_mux2_1
X_2043_ _2043_/Y _2043_/A _2043_/B VPWR VGND sg13cmos5l_nand2_1
X_2945_ _2945_/Y hold575/X _2944_/Y _2970_/B VPWR VGND sg13cmos5l_o21ai_1
XFILLER_31_760 VPWR VGND sg13cmos5l_fill_2
X_2876_ _2974_/A _2854_/X _2875_/Y _2879_/C VPWR VGND sg13cmos5l_mux2_1
X_1827_ _3063_/A _3532_/Q VPWR VGND sg13cmos5l_inv_1
Xhold433 _2964_/B _3465_/Q VPWR VGND sg13cmos5l_dlygate4sd3_1
Xhold444 _2965_/B _3466_/Q VPWR VGND sg13cmos5l_dlygate4sd3_1
Xhold422 _2610_/B _3404_/Q VPWR VGND sg13cmos5l_dlygate4sd3_1
Xhold477 _1956_/B _1955_/Y VPWR VGND sg13cmos5l_dlygate4sd3_1
Xhold455 _3257_/B _3256_/Y VPWR VGND sg13cmos5l_dlygate4sd3_1
Xhold466 _2083_/A _3321_/Q VPWR VGND sg13cmos5l_dlygate4sd3_1
Xhold499 hold499/X _3290_/Q VPWR VGND sg13cmos5l_dlygate4sd3_1
X_3428_ _3428_/Q _3527_/CLK _3428_/D _3428_/RESET_B VPWR VGND sg13cmos5l_dfrbpq_1
Xhold488 _2785_/B _3435_/Q VPWR VGND sg13cmos5l_dlygate4sd3_1
X_3359_ _3359_/Q _3409_/CLK _3359_/D _3359_/RESET_B VPWR VGND sg13cmos5l_dfrbpq_1
XFILLER_26_543 VPWR VGND sg13cmos5l_decap_8
XFILLER_13_204 VPWR VGND sg13cmos5l_decap_8
XFILLER_14_738 VPWR VGND sg13cmos5l_decap_4
XFILLER_16_1002 VPWR VGND sg13cmos5l_decap_8
XFILLER_10_933 VPWR VGND sg13cmos5l_decap_8
XFILLER_22_782 VPWR VGND sg13cmos5l_fill_1
X_3377__287 _3377_/RESET_B VPWR VGND sg13cmos5l_tiehi
XFILLER_6_937 VPWR VGND sg13cmos5l_decap_8
XFILLER_1_697 VPWR VGND sg13cmos5l_decap_8
XFILLER_23_1017 VPWR VGND sg13cmos5l_decap_8
XFILLER_23_1028 VPWR VGND sg13cmos5l_fill_1
XFILLER_28_92 VPWR VGND sg13cmos5l_decap_8
XFILLER_32_557 VPWR VGND sg13cmos5l_decap_8
XFILLER_9_753 VPWR VGND sg13cmos5l_decap_8
X_2730_ _2731_/B _2728_/A _2728_/B _2507_/Y VPWR VGND sg13cmos5l_a21oi_1
XFILLER_8_252 VPWR VGND sg13cmos5l_fill_2
XFILLER_9_764 VPWR VGND sg13cmos5l_fill_1
X_2661_ _2661_/Y _2647_/Y _2654_/Y _2660_/Y VPWR VGND sg13cmos5l_o21ai_1
XFILLER_9_797 VPWR VGND sg13cmos5l_fill_1
X_2592_ _2592_/Y _1860_/A _2594_/S _2615_/B VPWR VGND sg13cmos5l_o21ai_1
XFILLER_5_85 VPWR VGND sg13cmos5l_fill_1
X_3213_ _3213_/Y _3206_/A _3209_/Y _3212_/Y VPWR VGND sg13cmos5l_o21ai_1
X_3144_ _3145_/B _3212_/B _3212_/C VPWR VGND sg13cmos5l_nand2_1
X_3075_ _3075_/Y _3086_/B _3531_/Q _3532_/Q _2948_/B VPWR VGND sg13cmos5l_a22oi_1
X_2026_ _2026_/Y hold583/X _2021_/Y _2020_/Y VPWR VGND sg13cmos5l_a21oi_1
XFILLER_35_340 VPWR VGND sg13cmos5l_fill_1
XFILLER_39_1024 VPWR VGND sg13cmos5l_decap_4
XFILLER_36_896 VPWR VGND sg13cmos5l_decap_8
XFILLER_11_719 VPWR VGND sg13cmos5l_decap_8
XFILLER_10_218 VPWR VGND sg13cmos5l_decap_8
X_2928_ _2928_/Y _2928_/A _3125_/A _2931_/C VPWR VGND sg13cmos5l_nand3_1
X_2859_ _2868_/B _3506_/Q _3507_/Q _3508_/Q VPWR VGND sg13cmos5l_nor3_1
XFILLER_2_406 VPWR VGND sg13cmos5l_decap_8
XFILLER_2_417 VPWR VGND sg13cmos5l_fill_1
XFILLER_49_47 VPWR VGND sg13cmos5l_decap_8
XFILLER_18_307 VPWR VGND sg13cmos5l_decap_8
XFILLER_45_126 VPWR VGND sg13cmos5l_decap_8
XFILLER_39_690 VPWR VGND sg13cmos5l_fill_2
XFILLER_18_318 VPWR VGND sg13cmos5l_decap_8
XFILLER_45_159 VPWR VGND sg13cmos5l_decap_8
XFILLER_27_863 VPWR VGND sg13cmos5l_fill_2
XFILLER_14_513 VPWR VGND sg13cmos5l_decap_8
XFILLER_5_222 VPWR VGND sg13cmos5l_decap_8
XFILLER_6_756 VPWR VGND sg13cmos5l_decap_8
X_3531__158 _3531_/RESET_B VPWR VGND sg13cmos5l_tiehi
XFILLER_5_277 VPWR VGND sg13cmos5l_decap_8
XFILLER_30_60 VPWR VGND sg13cmos5l_decap_8
XFILLER_2_973 VPWR VGND sg13cmos5l_decap_8
XFILLER_49_410 VPWR VGND sg13cmos5l_decap_8
XFILLER_7_1011 VPWR VGND sg13cmos5l_decap_8
Xinput9 input9/X uio_in[3] VPWR VGND sg13cmos5l_buf_1
XFILLER_37_638 VPWR VGND sg13cmos5l_fill_1
XFILLER_37_627 VPWR VGND sg13cmos5l_decap_8
X_3507__374 _3507_/RESET_B VPWR VGND sg13cmos5l_tiehi
XFILLER_36_126 VPWR VGND sg13cmos5l_decap_8
XFILLER_18_863 VPWR VGND sg13cmos5l_fill_1
XFILLER_36_137 VPWR VGND sg13cmos5l_fill_1
XFILLER_45_671 VPWR VGND sg13cmos5l_fill_2
XFILLER_9_583 VPWR VGND sg13cmos5l_decap_8
X_2713_ _2728_/A _3423_/Q _2714_/B VPWR VGND sg13cmos5l_xnor2_1
X_2644_ _2647_/B _2653_/A _2653_/B VPWR VGND sg13cmos5l_nor2_1
X_2575_ _2575_/Y _3445_/Q _3441_/Q VPWR VGND sg13cmos5l_nor2b_1
X_3127_ _3127_/Y _3524_/Q _3498_/Q VPWR VGND sg13cmos5l_xnor2_1
XFILLER_43_608 VPWR VGND sg13cmos5l_decap_8
XFILLER_36_671 VPWR VGND sg13cmos5l_decap_8
X_3058_ _3058_/Y _3515_/Q _3058_/B VPWR VGND sg13cmos5l_xnor2_1
XFILLER_24_822 VPWR VGND sg13cmos5l_decap_8
X_2009_ _2009_/Y _1868_/B _2018_/C _2009_/B1 VPWR VGND sg13cmos5l_o21ai_1
XFILLER_24_888 VPWR VGND sg13cmos5l_fill_1
XFILLER_11_527 VPWR VGND sg13cmos5l_decap_8
XFILLER_3_726 VPWR VGND sg13cmos5l_decap_8
XFILLER_3_715 VPWR VGND sg13cmos5l_decap_8
XFILLER_2_269 VPWR VGND sg13cmos5l_fill_2
XFILLER_46_424 VPWR VGND sg13cmos5l_decap_8
XFILLER_47_969 VPWR VGND sg13cmos5l_decap_8
XFILLER_46_446 VPWR VGND sg13cmos5l_decap_8
XFILLER_46_435 VPWR VGND sg13cmos5l_fill_1
XFILLER_15_833 VPWR VGND sg13cmos5l_decap_4
XFILLER_26_170 VPWR VGND sg13cmos5l_fill_2
XFILLER_42_685 VPWR VGND sg13cmos5l_fill_1
XFILLER_41_173 VPWR VGND sg13cmos5l_decap_8
XFILLER_25_93 VPWR VGND sg13cmos5l_fill_1
XFILLER_10_593 VPWR VGND sg13cmos5l_decap_8
X_2360_ _2377_/C _3360_/Q _3361_/Q VPWR VGND sg13cmos5l_xnor2_1
X_2291_ _2291_/Y _2293_/A _2224_/B _2288_/Y VPWR VGND sg13cmos5l_o21ai_1
XFILLER_2_770 VPWR VGND sg13cmos5l_decap_8
XFILLER_38_936 VPWR VGND sg13cmos5l_decap_8
XFILLER_37_424 VPWR VGND sg13cmos5l_decap_4
XFILLER_25_608 VPWR VGND sg13cmos5l_decap_8
XFILLER_17_181 VPWR VGND sg13cmos5l_decap_4
XFILLER_18_693 VPWR VGND sg13cmos5l_decap_8
XFILLER_21_803 VPWR VGND sg13cmos5l_decap_8
XFILLER_32_151 VPWR VGND sg13cmos5l_decap_8
XFILLER_32_195 VPWR VGND sg13cmos5l_fill_2
XFILLER_21_18 VPWR VGND sg13cmos5l_decap_8
X_2627_ _2627_/Y _3431_/Q _3403_/Q VPWR VGND sg13cmos5l_xnor2_1
XFILLER_0_707 VPWR VGND sg13cmos5l_decap_8
X_2558_ _2617_/D _2550_/A _2550_/B _2556_/Y VPWR VGND sg13cmos5l_o21ai_1
X_2489_ _2489_/Y _3441_/Q _3414_/Q VPWR VGND sg13cmos5l_nand2_1
XFILLER_28_402 VPWR VGND sg13cmos5l_decap_8
XFILLER_28_457 VPWR VGND sg13cmos5l_decap_8
XFILLER_29_958 VPWR VGND sg13cmos5l_decap_8
XFILLER_44_917 VPWR VGND sg13cmos5l_decap_8
XFILLER_43_405 VPWR VGND sg13cmos5l_decap_8
XFILLER_16_608 VPWR VGND sg13cmos5l_decap_8
XFILLER_43_438 VPWR VGND sg13cmos5l_fill_2
XFILLER_15_129 VPWR VGND sg13cmos5l_decap_4
XFILLER_24_663 VPWR VGND sg13cmos5l_decap_8
XFILLER_24_674 VPWR VGND sg13cmos5l_fill_2
XFILLER_24_685 VPWR VGND sg13cmos5l_decap_8
XFILLER_11_324 VPWR VGND sg13cmos5l_fill_2
XFILLER_12_858 VPWR VGND sg13cmos5l_decap_8
XFILLER_23_195 VPWR VGND sg13cmos5l_decap_8
XFILLER_11_379 VPWR VGND sg13cmos5l_fill_1
XFILLER_3_567 VPWR VGND sg13cmos5l_fill_2
XFILLER_3_589 VPWR VGND sg13cmos5l_decap_8
XFILLER_47_700 VPWR VGND sg13cmos5l_decap_8
XFILLER_47_766 VPWR VGND sg13cmos5l_decap_8
XFILLER_46_232 VPWR VGND sg13cmos5l_decap_8
XFILLER_27_490 VPWR VGND sg13cmos5l_fill_2
XFILLER_36_81 VPWR VGND sg13cmos5l_decap_8
XFILLER_43_972 VPWR VGND sg13cmos5l_decap_8
XFILLER_15_652 VPWR VGND sg13cmos5l_decap_8
XFILLER_42_482 VPWR VGND sg13cmos5l_decap_8
XFILLER_14_151 VPWR VGND sg13cmos5l_fill_2
X_1860_ _2749_/B _1860_/A VPWR VGND sg13cmos5l_inv_1
XFILLER_30_644 VPWR VGND sg13cmos5l_fill_1
Xinput12 input12/X uio_in[6] VPWR VGND sg13cmos5l_buf_1
X_3530_ _3530_/Q clkload4/A _3530_/D _3530_/RESET_B VPWR VGND sg13cmos5l_dfrbpq_1
XFILLER_11_880 VPWR VGND sg13cmos5l_decap_8
X_3461_ _3461_/Q clkload3/A _3461_/D _3461_/RESET_B VPWR VGND sg13cmos5l_dfrbpq_1
X_2412_ _2412_/Y _2412_/A _2415_/S VPWR VGND sg13cmos5l_nand2_1
X_3392_ _3392_/Q _3442_/CLK _3392_/D _3392_/RESET_B VPWR VGND sg13cmos5l_dfrbpq_1
X_2343_ _2344_/B _2433_/A _2433_/B VPWR VGND sg13cmos5l_nand2_1
X_2274_ _2274_/Y _3377_/Q _2283_/C VPWR VGND sg13cmos5l_nand2_1
XFILLER_38_733 VPWR VGND sg13cmos5l_decap_8
XFILLER_25_427 VPWR VGND sg13cmos5l_decap_4
Xclkbuf_leaf_17_clk _3504_/CLK clkbuf_2_2__f_clk/X VPWR VGND sg13cmos5l_buf_8
XFILLER_33_471 VPWR VGND sg13cmos5l_fill_2
XFILLER_34_983 VPWR VGND sg13cmos5l_decap_8
XFILLER_20_165 VPWR VGND sg13cmos5l_decap_8
XFILLER_20_187 VPWR VGND sg13cmos5l_decap_8
XFILLER_20_198 VPWR VGND sg13cmos5l_fill_2
XFILLER_21_699 VPWR VGND sg13cmos5l_decap_8
X_1989_ _1991_/C hold688/X _1988_/Y _1986_/X VPWR VGND sg13cmos5l_o21ai_1
XFILLER_0_537 VPWR VGND sg13cmos5l_decap_8
XFILLER_17_939 VPWR VGND sg13cmos5l_decap_8
XFILLER_29_766 VPWR VGND sg13cmos5l_decap_8
XFILLER_43_213 VPWR VGND sg13cmos5l_decap_8
XFILLER_16_449 VPWR VGND sg13cmos5l_decap_8
XFILLER_19_1011 VPWR VGND sg13cmos5l_decap_8
XFILLER_24_460 VPWR VGND sg13cmos5l_decap_8
XFILLER_25_972 VPWR VGND sg13cmos5l_decap_8
XFILLER_8_604 VPWR VGND sg13cmos5l_fill_2
XFILLER_12_655 VPWR VGND sg13cmos5l_fill_2
XFILLER_40_986 VPWR VGND sg13cmos5l_decap_8
XFILLER_11_143 VPWR VGND sg13cmos5l_decap_8
XFILLER_22_83 VPWR VGND sg13cmos5l_decap_4
XFILLER_4_854 VPWR VGND sg13cmos5l_decap_8
XFILLER_47_563 VPWR VGND sg13cmos5l_decap_4
XFILLER_19_265 VPWR VGND sg13cmos5l_decap_8
XFILLER_47_596 VPWR VGND sg13cmos5l_decap_8
XFILLER_35_725 VPWR VGND sg13cmos5l_fill_2
XFILLER_35_769 VPWR VGND sg13cmos5l_decap_8
X_2961_ _2961_/Y _1796_/Y _2963_/A2 _2960_/Y VPWR VGND sg13cmos5l_a21oi_1
XFILLER_31_920 VPWR VGND sg13cmos5l_fill_1
X_1912_ _3266_/D hold513/X input13/X _1912_/S VPWR VGND sg13cmos5l_mux2_1
XFILLER_43_791 VPWR VGND sg13cmos5l_decap_8
XFILLER_30_430 VPWR VGND sg13cmos5l_decap_8
XFILLER_33_1008 VPWR VGND sg13cmos5l_decap_8
X_2892_ _2893_/B _3452_/Q _3451_/Q _3453_/Q VPWR VGND sg13cmos5l_o21ai_1
XFILLER_30_463 VPWR VGND sg13cmos5l_decap_8
X_1843_ _2968_/A _1843_/A VPWR VGND sg13cmos5l_inv_1
Xhold615 hold615/X _2034_/Y VPWR VGND sg13cmos5l_dlygate4sd3_1
X_3513_ _3513_/Q clkload5/A _3513_/D _3513_/RESET_B VPWR VGND sg13cmos5l_dfrbpq_1
Xhold626 _2955_/B _3491_/Q VPWR VGND sg13cmos5l_dlygate4sd3_1
Xhold604 hold604/X _3456_/Q VPWR VGND sg13cmos5l_dlygate4sd3_1
Xclkbuf_leaf_6_clk clkload9/A clkload0/A VPWR VGND sg13cmos5l_buf_8
Xhold659 _2097_/B _3331_/Q VPWR VGND sg13cmos5l_dlygate4sd3_1
Xhold648 _2786_/A _3441_/Q VPWR VGND sg13cmos5l_dlygate4sd3_1
X_3444_ _3444_/Q _3444_/CLK _3444_/D _3444_/RESET_B VPWR VGND sg13cmos5l_dfrbpq_1
Xhold637 _2250_/B _3366_/Q VPWR VGND sg13cmos5l_dlygate4sd3_1
X_3375_ _3375_/Q _3378_/CLK _3375_/D _3375_/RESET_B VPWR VGND sg13cmos5l_dfrbpq_1
X_2326_ _2326_/Y _3383_/Q _3384_/Q VPWR VGND sg13cmos5l_xnor2_1
X_2257_ _2257_/Y _2155_/A _2958_/A2 _2179_/B VPWR VGND sg13cmos5l_o21ai_1
XFILLER_27_28 VPWR VGND sg13cmos5l_decap_8
X_2188_ _2188_/Y _3357_/Q _2359_/A _2186_/Y VPWR VGND sg13cmos5l_a21oi_1
XFILLER_25_224 VPWR VGND sg13cmos5l_fill_2
XFILLER_13_419 VPWR VGND sg13cmos5l_decap_8
XFILLER_25_279 VPWR VGND sg13cmos5l_decap_8
XFILLER_40_227 VPWR VGND sg13cmos5l_decap_4
XFILLER_22_953 VPWR VGND sg13cmos5l_decap_8
XFILLER_1_802 VPWR VGND sg13cmos5l_decap_8
XFILLER_49_806 VPWR VGND sg13cmos5l_decap_8
XFILLER_0_334 VPWR VGND sg13cmos5l_decap_4
XFILLER_1_879 VPWR VGND sg13cmos5l_decap_8
XFILLER_0_356 VPWR VGND sg13cmos5l_decap_8
XFILLER_1_1028 VPWR VGND sg13cmos5l_fill_1
XFILLER_17_736 VPWR VGND sg13cmos5l_decap_8
XFILLER_44_599 VPWR VGND sg13cmos5l_decap_8
XFILLER_44_588 VPWR VGND sg13cmos5l_decap_8
XFILLER_31_227 VPWR VGND sg13cmos5l_fill_1
XFILLER_9_935 VPWR VGND sg13cmos5l_decap_8
XFILLER_13_975 VPWR VGND sg13cmos5l_decap_8
X_3393__271 _3393_/RESET_B VPWR VGND sg13cmos5l_tiehi
XFILLER_4_673 VPWR VGND sg13cmos5l_decap_8
XFILLER_3_161 VPWR VGND sg13cmos5l_decap_8
X_3160_ _3160_/Y _3161_/B _3486_/Q VPWR VGND sg13cmos5l_nand2b_1
XFILLER_39_349 VPWR VGND sg13cmos5l_decap_8
X_2111_ _3331_/D _2176_/A _2162_/C VPWR VGND sg13cmos5l_nor2_1
XFILLER_12_4 VPWR VGND sg13cmos5l_decap_8
X_3091_ _3091_/Y _3091_/A _3536_/Q VPWR VGND sg13cmos5l_nor2_1
X_2042_ _2042_/Y _3310_/Q _3311_/Q VPWR VGND sg13cmos5l_nand2b_1
XFILLER_48_894 VPWR VGND sg13cmos5l_decap_8
XFILLER_35_555 VPWR VGND sg13cmos5l_decap_8
XFILLER_35_566 VPWR VGND sg13cmos5l_fill_2
XFILLER_23_739 VPWR VGND sg13cmos5l_fill_2
XFILLER_35_588 VPWR VGND sg13cmos5l_fill_1
X_3296__401 _3296_/RESET_B VPWR VGND sg13cmos5l_tiehi
XFILLER_22_249 VPWR VGND sg13cmos5l_fill_1
XFILLER_13_19 VPWR VGND sg13cmos5l_decap_8
X_2944_ _2944_/Y _2938_/Y _2941_/Y _2943_/Y VPWR VGND sg13cmos5l_o21ai_1
X_2875_ _2875_/Y _3122_/A _2879_/B VPWR VGND sg13cmos5l_nand2_1
X_1826_ _3091_/A _3533_/Q VPWR VGND sg13cmos5l_inv_1
Xhold423 hold423/X _3301_/Q VPWR VGND sg13cmos5l_dlygate4sd3_1
Xhold434 _2144_/B _3325_/Q VPWR VGND sg13cmos5l_dlygate4sd3_1
Xhold445 _1815_/A _3323_/Q VPWR VGND sg13cmos5l_dlygate4sd3_1
Xhold456 hold456/X _3308_/Q VPWR VGND sg13cmos5l_dlygate4sd3_1
Xhold478 _1796_/A _3495_/Q VPWR VGND sg13cmos5l_dlygate4sd3_1
Xhold467 _3343_/D _2138_/Y VPWR VGND sg13cmos5l_dlygate4sd3_1
X_3427_ _3427_/Q _3472_/CLK _3427_/D _3427_/RESET_B VPWR VGND sg13cmos5l_dfrbpq_1
Xhold489 _1810_/A _3371_/Q VPWR VGND sg13cmos5l_dlygate4sd3_1
X_3358_ _3358_/Q _3409_/CLK _3358_/D _3358_/RESET_B VPWR VGND sg13cmos5l_dfrbpq_1
X_2309_ _3380_/D _2309_/A _2309_/B VPWR VGND sg13cmos5l_nor2_1
X_3289_ _3289_/Q clkload9/A _3289_/D _3289_/RESET_B VPWR VGND sg13cmos5l_dfrbpq_1
XFILLER_39_861 VPWR VGND sg13cmos5l_decap_8
XFILLER_38_393 VPWR VGND sg13cmos5l_fill_1
XFILLER_14_717 VPWR VGND sg13cmos5l_decap_8
XFILLER_26_588 VPWR VGND sg13cmos5l_decap_8
XFILLER_41_536 VPWR VGND sg13cmos5l_decap_8
XFILLER_10_912 VPWR VGND sg13cmos5l_decap_8
XFILLER_21_260 VPWR VGND sg13cmos5l_decap_8
XFILLER_22_794 VPWR VGND sg13cmos5l_fill_2
XFILLER_6_916 VPWR VGND sg13cmos5l_decap_8
XFILLER_21_293 VPWR VGND sg13cmos5l_decap_8
XFILLER_10_989 VPWR VGND sg13cmos5l_decap_8
XFILLER_1_654 VPWR VGND sg13cmos5l_decap_4
XFILLER_49_647 VPWR VGND sg13cmos5l_decap_8
XFILLER_0_197 VPWR VGND sg13cmos5l_decap_8
XFILLER_28_71 VPWR VGND sg13cmos5l_fill_1
XFILLER_45_853 VPWR VGND sg13cmos5l_fill_1
XFILLER_45_886 VPWR VGND sg13cmos5l_decap_8
XFILLER_17_577 VPWR VGND sg13cmos5l_decap_4
X_3540__193 _3540_/RESET_B VPWR VGND sg13cmos5l_tiehi
XFILLER_13_750 VPWR VGND sg13cmos5l_decap_8
XFILLER_13_761 VPWR VGND sg13cmos5l_fill_1
XFILLER_8_220 VPWR VGND sg13cmos5l_decap_8
XFILLER_13_794 VPWR VGND sg13cmos5l_fill_2
XFILLER_8_231 VPWR VGND sg13cmos5l_decap_8
X_2660_ _2660_/Y _2650_/A _2652_/Y _2655_/Y _2659_/A VPWR VGND sg13cmos5l_a22oi_1
X_3432__227 _3432_/RESET_B VPWR VGND sg13cmos5l_tiehi
X_2591_ _2594_/S _2590_/Y _2591_/B VPWR VGND sg13cmos5l_nand2b_1
XFILLER_5_64 VPWR VGND sg13cmos5l_decap_8
X_3212_ _3212_/Y _3212_/A _3212_/B _3212_/C VPWR VGND sg13cmos5l_nand3_1
X_3143_ _3143_/X _3143_/A _3143_/B VPWR VGND sg13cmos5l_xor2_1
X_3074_ _3514_/D _3223_/A _3212_/A VPWR VGND sg13cmos5l_nor2_1
X_2025_ _2025_/Y _3314_/Q _2025_/B _2025_/C VPWR VGND sg13cmos5l_nor3_1
XFILLER_39_1003 VPWR VGND sg13cmos5l_decap_8
XFILLER_36_875 VPWR VGND sg13cmos5l_decap_8
XFILLER_24_18 VPWR VGND sg13cmos5l_decap_8
X_2927_ _2931_/C _3509_/Q _2930_/A _2934_/B VPWR VGND sg13cmos5l_o21ai_1
XFILLER_31_591 VPWR VGND sg13cmos5l_decap_8
X_2858_ _2858_/X _2879_/A _2863_/B _2858_/C VPWR VGND sg13cmos5l_and3_1
XFILLER_3_919 VPWR VGND sg13cmos5l_decap_8
X_2789_ _3471_/D _2789_/A _2845_/A VPWR VGND sg13cmos5l_nor2_1
X_1809_ _1809_/Y _1809_/A VPWR VGND sg13cmos5l_inv_1
XFILLER_46_1018 VPWR VGND sg13cmos5l_decap_8
XFILLER_46_628 VPWR VGND sg13cmos5l_decap_8
X_3383__281 _3383_/RESET_B VPWR VGND sg13cmos5l_tiehi
XFILLER_45_149 VPWR VGND sg13cmos5l_fill_1
XFILLER_26_341 VPWR VGND sg13cmos5l_fill_2
XFILLER_27_886 VPWR VGND sg13cmos5l_fill_1
XFILLER_42_889 VPWR VGND sg13cmos5l_decap_8
XFILLER_22_580 VPWR VGND sg13cmos5l_decap_4
XFILLER_6_713 VPWR VGND sg13cmos5l_decap_4
XFILLER_10_786 VPWR VGND sg13cmos5l_decap_8
X_3390__274 _3390_/RESET_B VPWR VGND sg13cmos5l_tiehi
XFILLER_2_952 VPWR VGND sg13cmos5l_decap_8
XFILLER_49_466 VPWR VGND sg13cmos5l_fill_2
XFILLER_49_499 VPWR VGND sg13cmos5l_decap_8
XFILLER_36_149 VPWR VGND sg13cmos5l_decap_8
XFILLER_18_875 VPWR VGND sg13cmos5l_decap_8
XFILLER_18_897 VPWR VGND sg13cmos5l_decap_8
XFILLER_33_801 VPWR VGND sg13cmos5l_fill_1
XFILLER_44_160 VPWR VGND sg13cmos5l_decap_8
X_2712_ _2714_/B _3422_/Q _2717_/A VPWR VGND sg13cmos5l_nor2_1
X_2643_ _2653_/B _2560_/Y _2516_/Y _2651_/B VPWR VGND sg13cmos5l_mux2_1
X_2574_ _2578_/C _3445_/Q _2417_/A _2577_/B VPWR VGND sg13cmos5l_o21ai_1
XFILLER_19_18 VPWR VGND sg13cmos5l_decap_4
XFILLER_19_29 VPWR VGND sg13cmos5l_decap_8
X_3126_ _3126_/Y _3525_/Q _3499_/Q VPWR VGND sg13cmos5l_nand2_1
XFILLER_27_127 VPWR VGND sg13cmos5l_fill_2
XFILLER_36_650 VPWR VGND sg13cmos5l_decap_8
X_3057_ _3057_/Y _3069_/B _3057_/B VPWR VGND sg13cmos5l_nand2_1
XFILLER_24_801 VPWR VGND sg13cmos5l_decap_8
XFILLER_23_322 VPWR VGND sg13cmos5l_fill_2
X_2008_ _2018_/C _2008_/A VPWR VGND sg13cmos5l_inv_1
XFILLER_35_182 VPWR VGND sg13cmos5l_decap_8
XFILLER_11_506 VPWR VGND sg13cmos5l_decap_8
XFILLER_24_867 VPWR VGND sg13cmos5l_decap_8
XFILLER_23_399 VPWR VGND sg13cmos5l_decap_8
XFILLER_13_1017 VPWR VGND sg13cmos5l_decap_8
XFILLER_13_1028 VPWR VGND sg13cmos5l_fill_1
X_3450__102 _3450_/D VPWR VGND sg13cmos5l_tielo
XFILLER_2_204 VPWR VGND sg13cmos5l_decap_8
XFILLER_47_948 VPWR VGND sg13cmos5l_decap_8
XFILLER_46_403 VPWR VGND sg13cmos5l_decap_8
XFILLER_19_628 VPWR VGND sg13cmos5l_decap_8
XFILLER_34_609 VPWR VGND sg13cmos5l_decap_8
XFILLER_33_119 VPWR VGND sg13cmos5l_decap_4
XFILLER_42_653 VPWR VGND sg13cmos5l_fill_1
XFILLER_42_642 VPWR VGND sg13cmos5l_decap_8
XFILLER_25_50 VPWR VGND sg13cmos5l_decap_8
XFILLER_42_675 VPWR VGND sg13cmos5l_decap_4
XFILLER_14_399 VPWR VGND sg13cmos5l_decap_8
XFILLER_30_815 VPWR VGND sg13cmos5l_decap_8
XFILLER_41_196 VPWR VGND sg13cmos5l_fill_1
XFILLER_10_572 VPWR VGND sg13cmos5l_fill_2
XFILLER_6_554 VPWR VGND sg13cmos5l_decap_8
XFILLER_6_532 VPWR VGND sg13cmos5l_decap_8
X_2290_ _2290_/Y _2296_/A _2220_/B _2224_/B _2293_/A VPWR VGND sg13cmos5l_a22oi_1
XFILLER_38_915 VPWR VGND sg13cmos5l_decap_8
XFILLER_2_43 VPWR VGND sg13cmos5l_decap_8
XFILLER_49_252 VPWR VGND sg13cmos5l_decap_4
XFILLER_32_141 VPWR VGND sg13cmos5l_decap_4
XFILLER_32_174 VPWR VGND sg13cmos5l_decap_8
XFILLER_20_325 VPWR VGND sg13cmos5l_decap_8
X_2626_ _2626_/Y _3430_/Q _3402_/Q VPWR VGND sg13cmos5l_xnor2_1
X_3373__291 _3373_/RESET_B VPWR VGND sg13cmos5l_tiehi
X_2557_ _2617_/C _2557_/A _2557_/B _2557_/C VPWR VGND sg13cmos5l_nand3_1
X_2488_ _2488_/Y _3414_/Q _2488_/B VPWR VGND sg13cmos5l_xnor2_1
XFILLER_28_414 VPWR VGND sg13cmos5l_decap_8
XFILLER_29_937 VPWR VGND sg13cmos5l_decap_8
XFILLER_46_49 VPWR VGND sg13cmos5l_decap_8
X_3109_ _3109_/Y _1801_/Y _3110_/S _3108_/Y VPWR VGND sg13cmos5l_a21oi_1
X_3380__284 _3380_/RESET_B VPWR VGND sg13cmos5l_tiehi
XFILLER_23_130 VPWR VGND sg13cmos5l_fill_2
XFILLER_11_336 VPWR VGND sg13cmos5l_decap_8
XFILLER_7_318 VPWR VGND sg13cmos5l_fill_2
XFILLER_7_307 VPWR VGND sg13cmos5l_decap_8
XFILLER_3_546 VPWR VGND sg13cmos5l_decap_8
XFILLER_11_85 VPWR VGND sg13cmos5l_decap_4
XFILLER_4_1015 VPWR VGND sg13cmos5l_decap_8
XFILLER_47_745 VPWR VGND sg13cmos5l_decap_8
XFILLER_46_222 VPWR VGND sg13cmos5l_decap_4
XFILLER_19_436 VPWR VGND sg13cmos5l_decap_8
XFILLER_46_277 VPWR VGND sg13cmos5l_decap_8
XFILLER_43_951 VPWR VGND sg13cmos5l_decap_8
XFILLER_14_130 VPWR VGND sg13cmos5l_fill_1
XFILLER_30_601 VPWR VGND sg13cmos5l_fill_2
XFILLER_30_634 VPWR VGND sg13cmos5l_fill_2
Xinput13 input13/X uio_in[7] VPWR VGND sg13cmos5l_buf_1
XFILLER_30_689 VPWR VGND sg13cmos5l_fill_2
XFILLER_10_380 VPWR VGND sg13cmos5l_fill_1
XFILLER_7_885 VPWR VGND sg13cmos5l_decap_8
XFILLER_10_391 VPWR VGND sg13cmos5l_fill_2
X_3460_ _3460_/Q _3527_/CLK _3460_/D _3460_/RESET_B VPWR VGND sg13cmos5l_dfrbpq_1
XFILLER_42_4 VPWR VGND sg13cmos5l_fill_2
X_2411_ _3393_/D _2432_/B _2411_/B VPWR VGND sg13cmos5l_nor2_1
X_3391_ _3391_/Q _3442_/CLK _3391_/D _3391_/RESET_B VPWR VGND sg13cmos5l_dfrbpq_1
X_2342_ _2433_/B _2341_/A _2341_/B _2557_/A VPWR VGND sg13cmos5l_o21ai_1
XFILLER_38_712 VPWR VGND sg13cmos5l_decap_8
X_2273_ _2283_/D _3376_/Q _2266_/X _2285_/B VPWR VGND sg13cmos5l_a21oi_1
XFILLER_38_778 VPWR VGND sg13cmos5l_decap_8
XFILLER_26_929 VPWR VGND sg13cmos5l_decap_8
XFILLER_16_19 VPWR VGND sg13cmos5l_decap_8
XFILLER_34_962 VPWR VGND sg13cmos5l_decap_8
XFILLER_20_111 VPWR VGND sg13cmos5l_fill_2
XFILLER_21_645 VPWR VGND sg13cmos5l_decap_8
XFILLER_33_494 VPWR VGND sg13cmos5l_decap_8
X_1988_ _1988_/Y _3547_/Q _1988_/B VPWR VGND sg13cmos5l_nand2b_1
X_2609_ _3434_/D _2784_/A _2609_/B VPWR VGND sg13cmos5l_and2_1
XFILLER_29_745 VPWR VGND sg13cmos5l_decap_8
XFILLER_29_756 VPWR VGND sg13cmos5l_fill_1
Xclkbuf_2_2__f_clk clkbuf_2_2__f_clk/X clkbuf_0_clk/X VPWR VGND sg13cmos5l_buf_8
XFILLER_44_726 VPWR VGND sg13cmos5l_decap_8
XFILLER_16_428 VPWR VGND sg13cmos5l_fill_1
XFILLER_25_951 VPWR VGND sg13cmos5l_decap_8
XFILLER_40_965 VPWR VGND sg13cmos5l_decap_8
XFILLER_8_638 VPWR VGND sg13cmos5l_fill_2
XFILLER_11_199 VPWR VGND sg13cmos5l_decap_4
XFILLER_22_62 VPWR VGND sg13cmos5l_fill_1
XFILLER_4_833 VPWR VGND sg13cmos5l_decap_8
XFILLER_3_310 VPWR VGND sg13cmos5l_fill_1
XFILLER_3_354 VPWR VGND sg13cmos5l_decap_8
XFILLER_0_0 VPWR VGND sg13cmos5l_decap_8
XFILLER_26_1027 VPWR VGND sg13cmos5l_fill_2
XFILLER_14_8 VPWR VGND sg13cmos5l_fill_2
XFILLER_47_542 VPWR VGND sg13cmos5l_fill_1
XFILLER_19_244 VPWR VGND sg13cmos5l_decap_8
XFILLER_35_704 VPWR VGND sg13cmos5l_decap_8
XFILLER_19_299 VPWR VGND sg13cmos5l_fill_1
XFILLER_34_225 VPWR VGND sg13cmos5l_decap_4
XFILLER_34_236 VPWR VGND sg13cmos5l_decap_8
XFILLER_15_450 VPWR VGND sg13cmos5l_decap_4
XFILLER_16_995 VPWR VGND sg13cmos5l_decap_8
X_2960_ _2960_/Y _3463_/Q _2963_/A2 _2427_/A VPWR VGND sg13cmos5l_o21ai_1
X_1911_ _3265_/D hold551/X input12/X _1912_/S VPWR VGND sg13cmos5l_mux2_1
X_2891_ _2916_/B _3454_/Q _2893_/A VPWR VGND sg13cmos5l_xor2_1
X_1842_ _2969_/A _2754_/A VPWR VGND sg13cmos5l_inv_1
XFILLER_31_987 VPWR VGND sg13cmos5l_decap_8
X_3512_ _3512_/Q clkload5/A _3512_/D _3512_/RESET_B VPWR VGND sg13cmos5l_dfrbpq_1
Xhold627 hold627/X _3095_/A VPWR VGND sg13cmos5l_dlygate4sd3_1
Xhold605 _3456_/D _2769_/Y VPWR VGND sg13cmos5l_dlygate4sd3_1
Xhold616 _2753_/A _3426_/Q VPWR VGND sg13cmos5l_dlygate4sd3_1
Xhold649 _2240_/A _3364_/Q VPWR VGND sg13cmos5l_dlygate4sd3_1
XFILLER_6_192 VPWR VGND sg13cmos5l_decap_8
X_3443_ _3443_/Q _3453_/CLK _3443_/D _3443_/RESET_B VPWR VGND sg13cmos5l_dfrbpq_1
Xhold638 hold638/X _2250_/Y VPWR VGND sg13cmos5l_dlygate4sd3_1
XFILLER_33_0 VPWR VGND sg13cmos5l_decap_8
X_3374_ _3374_/Q _3463_/CLK _3374_/D _3374_/RESET_B VPWR VGND sg13cmos5l_dfrbpq_1
X_2325_ _2325_/Y _3409_/Q _3383_/Q VPWR VGND sg13cmos5l_nand2_1
X_2256_ _2256_/Y _1811_/Y _2958_/A2 _2255_/Y VPWR VGND sg13cmos5l_a21oi_1
XFILLER_38_564 VPWR VGND sg13cmos5l_fill_2
X_2187_ _2187_/X _3356_/Q _2187_/B VPWR VGND sg13cmos5l_xor2_1
XFILLER_21_497 VPWR VGND sg13cmos5l_fill_1
XFILLER_49_1016 VPWR VGND sg13cmos5l_decap_8
XFILLER_49_1027 VPWR VGND sg13cmos5l_fill_2
XFILLER_1_858 VPWR VGND sg13cmos5l_decap_8
XFILLER_48_317 VPWR VGND sg13cmos5l_decap_4
XFILLER_29_575 VPWR VGND sg13cmos5l_decap_4
XFILLER_32_718 VPWR VGND sg13cmos5l_decap_4
XFILLER_13_954 VPWR VGND sg13cmos5l_decap_8
XFILLER_40_762 VPWR VGND sg13cmos5l_fill_2
XFILLER_9_914 VPWR VGND sg13cmos5l_decap_8
XFILLER_24_291 VPWR VGND sg13cmos5l_decap_8
XFILLER_33_50 VPWR VGND sg13cmos5l_fill_1
XFILLER_33_61 VPWR VGND sg13cmos5l_fill_2
XFILLER_32_1020 VPWR VGND sg13cmos5l_decap_8
XFILLER_8_468 VPWR VGND sg13cmos5l_decap_8
XFILLER_4_630 VPWR VGND sg13cmos5l_fill_1
XFILLER_3_195 VPWR VGND sg13cmos5l_fill_1
X_2110_ _2162_/C _2097_/X _2109_/Y _2110_/S VPWR VGND sg13cmos5l_mux2_1
X_3090_ _3090_/Y _3517_/Q _3085_/Y _3089_/Y VPWR VGND sg13cmos5l_o21ai_1
XFILLER_48_873 VPWR VGND sg13cmos5l_decap_8
X_2041_ _2041_/X _3284_/Q _3267_/Q _3286_/Q _3269_/Q _2063_/A _1868_/B VPWR VGND sg13cmos5l_mux4_1
XFILLER_35_501 VPWR VGND sg13cmos5l_decap_4
XFILLER_35_534 VPWR VGND sg13cmos5l_decap_8
X_2943_ _2943_/Y _3492_/Q _2943_/B VPWR VGND sg13cmos5l_nor2_1
XFILLER_16_792 VPWR VGND sg13cmos5l_decap_8
X_2874_ _3478_/D _2968_/B _2874_/B VPWR VGND sg13cmos5l_nor2_1
X_1825_ _3096_/A _3534_/Q VPWR VGND sg13cmos5l_inv_1
Xhold424 _3301_/D _3258_/Y VPWR VGND sg13cmos5l_dlygate4sd3_1
Xhold435 _2155_/B _3326_/Q VPWR VGND sg13cmos5l_dlygate4sd3_1
Xhold457 _1960_/B _1959_/Y VPWR VGND sg13cmos5l_dlygate4sd3_1
Xhold468 hold468/X _3303_/Q VPWR VGND sg13cmos5l_dlygate4sd3_1
Xhold446 _3345_/D _2142_/Y VPWR VGND sg13cmos5l_dlygate4sd3_1
X_3426_ _3426_/Q _3472_/CLK _3426_/D _3426_/RESET_B VPWR VGND sg13cmos5l_dfrbpq_1
Xhold479 _3495_/D _2961_/Y VPWR VGND sg13cmos5l_dlygate4sd3_1
X_3357_ _3357_/Q _3409_/CLK _3357_/D _3357_/RESET_B VPWR VGND sg13cmos5l_dfrbpq_1
XFILLER_38_17 VPWR VGND sg13cmos5l_decap_8
X_2308_ _2309_/B _2294_/Y _2298_/A _2308_/S VPWR VGND sg13cmos5l_mux2_1
XFILLER_39_840 VPWR VGND sg13cmos5l_decap_8
X_3288_ _3288_/Q clkload8/A _3288_/D _3288_/RESET_B VPWR VGND sg13cmos5l_dfrbpq_1
XFILLER_39_884 VPWR VGND sg13cmos5l_decap_8
X_2239_ _2239_/Y _3365_/Q _2239_/B VPWR VGND sg13cmos5l_nor2_1
XFILLER_41_515 VPWR VGND sg13cmos5l_decap_8
XFILLER_26_567 VPWR VGND sg13cmos5l_decap_4
XFILLER_13_239 VPWR VGND sg13cmos5l_fill_1
XFILLER_22_773 VPWR VGND sg13cmos5l_decap_8
XFILLER_10_968 VPWR VGND sg13cmos5l_decap_8
XFILLER_5_449 VPWR VGND sg13cmos5l_decap_4
XFILLER_0_110 VPWR VGND sg13cmos5l_fill_2
XFILLER_1_633 VPWR VGND sg13cmos5l_decap_8
XFILLER_0_143 VPWR VGND sg13cmos5l_decap_8
XFILLER_48_125 VPWR VGND sg13cmos5l_decap_4
XFILLER_0_176 VPWR VGND sg13cmos5l_decap_8
XFILLER_48_158 VPWR VGND sg13cmos5l_decap_4
XFILLER_28_50 VPWR VGND sg13cmos5l_decap_8
XFILLER_45_865 VPWR VGND sg13cmos5l_decap_8
XFILLER_44_71 VPWR VGND sg13cmos5l_decap_4
XFILLER_8_254 VPWR VGND sg13cmos5l_fill_1
XFILLER_12_294 VPWR VGND sg13cmos5l_decap_8
XFILLER_8_287 VPWR VGND sg13cmos5l_decap_8
XFILLER_8_265 VPWR VGND sg13cmos5l_decap_8
X_2590_ _2590_/Y _2599_/B _2587_/Y _2599_/A VPWR VGND sg13cmos5l_o21ai_1
XFILLER_5_994 VPWR VGND sg13cmos5l_decap_8
XFILLER_4_482 VPWR VGND sg13cmos5l_decap_4
X_3211_ _3211_/Y _3199_/X _3203_/Y _3206_/A _3209_/Y _3210_/Y VPWR VGND sg13cmos5l_a221oi_1
XFILLER_39_125 VPWR VGND sg13cmos5l_decap_8
X_3142_ _3209_/A _3201_/B VPWR VGND sg13cmos5l_inv_1
XFILLER_39_158 VPWR VGND sg13cmos5l_decap_4
XFILLER_39_136 VPWR VGND sg13cmos5l_fill_1
X_3073_ _3212_/A _3056_/B _3058_/Y _3055_/Y VPWR VGND sg13cmos5l_a21oi_1
XFILLER_48_692 VPWR VGND sg13cmos5l_decap_8
XFILLER_47_191 VPWR VGND sg13cmos5l_fill_2
X_2024_ _2024_/Y _2020_/Y _2023_/Y _2114_/A VPWR VGND sg13cmos5l_o21ai_1
XFILLER_36_843 VPWR VGND sg13cmos5l_decap_8
XFILLER_35_320 VPWR VGND sg13cmos5l_decap_8
X_2926_ _2926_/Y _2926_/A _2934_/B VPWR VGND sg13cmos5l_nand2_1
X_2857_ _2857_/Y _2853_/Y _2855_/Y _2856_/Y _3506_/Q VPWR VGND sg13cmos5l_a22oi_1
X_1808_ _1808_/Y _1808_/A VPWR VGND sg13cmos5l_inv_1
X_2788_ _3470_/D _2788_/A _2845_/A VPWR VGND sg13cmos5l_nor2_1
XFILLER_49_38 VPWR VGND sg13cmos5l_decap_4
X_3409_ _3409_/Q _3409_/CLK _3409_/D _3409_/RESET_B VPWR VGND sg13cmos5l_dfrbpq_1
XFILLER_46_607 VPWR VGND sg13cmos5l_decap_8
X_3309__375 _3309_/RESET_B VPWR VGND sg13cmos5l_tiehi
XFILLER_27_832 VPWR VGND sg13cmos5l_decap_8
XFILLER_27_865 VPWR VGND sg13cmos5l_fill_1
XFILLER_42_857 VPWR VGND sg13cmos5l_decap_4
XFILLER_14_526 VPWR VGND sg13cmos5l_decap_8
XFILLER_27_898 VPWR VGND sg13cmos5l_decap_4
XFILLER_41_367 VPWR VGND sg13cmos5l_fill_2
XFILLER_14_559 VPWR VGND sg13cmos5l_decap_8
XFILLER_10_754 VPWR VGND sg13cmos5l_fill_2
XFILLER_30_73 VPWR VGND sg13cmos5l_fill_1
XFILLER_2_931 VPWR VGND sg13cmos5l_decap_8
XFILLER_49_445 VPWR VGND sg13cmos5l_decap_8
XFILLER_49_478 VPWR VGND sg13cmos5l_decap_8
XFILLER_36_106 VPWR VGND sg13cmos5l_fill_2
XFILLER_18_832 VPWR VGND sg13cmos5l_decap_8
XFILLER_18_843 VPWR VGND sg13cmos5l_fill_2
XFILLER_32_323 VPWR VGND sg13cmos5l_decap_8
X_2711_ _2717_/A _3421_/Q _3419_/Q _3420_/Q VPWR VGND sg13cmos5l_or3_1
X_2642_ _2653_/A _2639_/A _2639_/B hold683/X VPWR VGND sg13cmos5l_o21ai_1
X_2573_ _2573_/Y _3397_/Q _2573_/B VPWR VGND sg13cmos5l_nor2_1
XFILLER_5_791 VPWR VGND sg13cmos5l_decap_8
X_3125_ _3530_/D _3125_/A _3125_/B VPWR VGND sg13cmos5l_nor2_1
XFILLER_28_629 VPWR VGND sg13cmos5l_decap_8
X_3056_ _3057_/B _3056_/A _3056_/B VPWR VGND sg13cmos5l_nand2_1
X_2007_ _2008_/A _2084_/B _2005_/Y _3240_/A _1883_/B _2014_/B VPWR VGND sg13cmos5l_a221oi_1
XFILLER_23_345 VPWR VGND sg13cmos5l_decap_4
XFILLER_23_378 VPWR VGND sg13cmos5l_fill_1
X_3339__335 _3339_/RESET_B VPWR VGND sg13cmos5l_tiehi
X_2909_ _2974_/B _2904_/A _2904_/B _2700_/Y VPWR VGND sg13cmos5l_a21oi_1
X_3530__160 _3530_/RESET_B VPWR VGND sg13cmos5l_tiehi
XFILLER_47_927 VPWR VGND sg13cmos5l_decap_8
XFILLER_46_459 VPWR VGND sg13cmos5l_decap_8
XFILLER_15_802 VPWR VGND sg13cmos5l_decap_8
XFILLER_27_651 VPWR VGND sg13cmos5l_decap_8
XFILLER_14_345 VPWR VGND sg13cmos5l_decap_8
XFILLER_15_857 VPWR VGND sg13cmos5l_decap_8
XFILLER_26_194 VPWR VGND sg13cmos5l_decap_8
XFILLER_42_698 VPWR VGND sg13cmos5l_decap_8
XFILLER_41_164 VPWR VGND sg13cmos5l_decap_4
XFILLER_25_73 VPWR VGND sg13cmos5l_decap_4
XFILLER_30_827 VPWR VGND sg13cmos5l_decap_8
XFILLER_41_50 VPWR VGND sg13cmos5l_decap_8
XFILLER_6_500 VPWR VGND sg13cmos5l_fill_1
XFILLER_6_577 VPWR VGND sg13cmos5l_decap_8
XFILLER_29_1014 VPWR VGND sg13cmos5l_decap_8
XFILLER_37_7 VPWR VGND sg13cmos5l_fill_1
XFILLER_49_231 VPWR VGND sg13cmos5l_decap_8
XFILLER_2_55 VPWR VGND sg13cmos5l_fill_2
XFILLER_2_66 VPWR VGND sg13cmos5l_decap_8
XFILLER_33_665 VPWR VGND sg13cmos5l_decap_8
XFILLER_21_838 VPWR VGND sg13cmos5l_fill_2
X_2625_ _2640_/A _3432_/Q _3404_/Q VPWR VGND sg13cmos5l_nand2_1
X_2556_ _2556_/Y _2530_/X _2556_/B VPWR VGND sg13cmos5l_nand2b_1
X_2487_ _2487_/X _2498_/A _2498_/B _2518_/A VPWR VGND sg13cmos5l_a21o_1
XFILLER_29_916 VPWR VGND sg13cmos5l_decap_8
X_3108_ _3108_/Y _3093_/A _3110_/S _3121_/B VPWR VGND sg13cmos5l_o21ai_1
XFILLER_28_448 VPWR VGND sg13cmos5l_decap_4
XFILLER_37_993 VPWR VGND sg13cmos5l_decap_8
X_3039_ _3049_/B _3534_/Q _3533_/Q _3532_/Q VPWR VGND sg13cmos5l_nor3_1
XFILLER_11_304 VPWR VGND sg13cmos5l_fill_1
XFILLER_12_805 VPWR VGND sg13cmos5l_decap_8
XFILLER_11_326 VPWR VGND sg13cmos5l_fill_1
XFILLER_23_186 VPWR VGND sg13cmos5l_decap_4
XFILLER_20_871 VPWR VGND sg13cmos5l_decap_8
XFILLER_3_525 VPWR VGND sg13cmos5l_decap_8
XFILLER_2_4 VPWR VGND sg13cmos5l_decap_4
X_3489__165 _3489_/RESET_B VPWR VGND sg13cmos5l_tiehi
XFILLER_19_404 VPWR VGND sg13cmos5l_decap_8
XFILLER_43_930 VPWR VGND sg13cmos5l_decap_8
XFILLER_14_120 VPWR VGND sg13cmos5l_fill_1
XFILLER_15_687 VPWR VGND sg13cmos5l_fill_1
XFILLER_7_864 VPWR VGND sg13cmos5l_decap_8
XFILLER_6_363 VPWR VGND sg13cmos5l_fill_1
X_2410_ _2410_/Y _1864_/A _2415_/S _2409_/Y VPWR VGND sg13cmos5l_o21ai_1
X_3390_ _3390_/Q _3442_/CLK _3390_/D _3390_/RESET_B VPWR VGND sg13cmos5l_dfrbpq_1
X_2341_ _2433_/A _2341_/A _2341_/B _2341_/C VPWR VGND sg13cmos5l_or3_1
XFILLER_35_4 VPWR VGND sg13cmos5l_fill_2
X_2272_ _2285_/B _2279_/A _2283_/C VPWR VGND sg13cmos5l_and2_1
X_3329__345 _3329_/RESET_B VPWR VGND sg13cmos5l_tiehi
XFILLER_42_1022 VPWR VGND sg13cmos5l_decap_8
XFILLER_38_757 VPWR VGND sg13cmos5l_decap_8
XFILLER_37_212 VPWR VGND sg13cmos5l_fill_2
XFILLER_26_908 VPWR VGND sg13cmos5l_decap_8
XFILLER_18_492 VPWR VGND sg13cmos5l_decap_8
XFILLER_34_941 VPWR VGND sg13cmos5l_decap_8
XFILLER_33_473 VPWR VGND sg13cmos5l_fill_1
X_1987_ _1991_/B _1987_/A _1987_/B VPWR VGND sg13cmos5l_nor2_1
X_3336__338 _3336_/RESET_B VPWR VGND sg13cmos5l_tiehi
X_2608_ _3433_/D _2608_/A _2608_/B VPWR VGND sg13cmos5l_and2_1
XFILLER_0_506 VPWR VGND sg13cmos5l_fill_1
X_2539_ _2539_/Y _2538_/B _2529_/C _2529_/A VPWR VGND sg13cmos5l_a21oi_1
XFILLER_29_724 VPWR VGND sg13cmos5l_decap_8
XFILLER_28_256 VPWR VGND sg13cmos5l_decap_8
XFILLER_44_749 VPWR VGND sg13cmos5l_decap_8
XFILLER_43_248 VPWR VGND sg13cmos5l_decap_8
XFILLER_12_602 VPWR VGND sg13cmos5l_fill_1
XFILLER_40_944 VPWR VGND sg13cmos5l_decap_8
XFILLER_11_123 VPWR VGND sg13cmos5l_fill_1
XFILLER_24_495 VPWR VGND sg13cmos5l_decap_8
XFILLER_8_617 VPWR VGND sg13cmos5l_decap_8
XFILLER_11_178 VPWR VGND sg13cmos5l_decap_8
XFILLER_22_74 VPWR VGND sg13cmos5l_decap_4
XFILLER_4_812 VPWR VGND sg13cmos5l_decap_8
XFILLER_3_333 VPWR VGND sg13cmos5l_decap_4
XFILLER_4_889 VPWR VGND sg13cmos5l_decap_8
XFILLER_26_1006 VPWR VGND sg13cmos5l_decap_8
X_3428__233 _3428_/RESET_B VPWR VGND sg13cmos5l_tiehi
XFILLER_47_82 VPWR VGND sg13cmos5l_fill_2
XFILLER_34_204 VPWR VGND sg13cmos5l_decap_8
XFILLER_16_974 VPWR VGND sg13cmos5l_decap_8
XFILLER_31_911 VPWR VGND sg13cmos5l_fill_1
X_1910_ _3264_/D hold526/X input11/X _1912_/S VPWR VGND sg13cmos5l_mux2_1
XFILLER_42_270 VPWR VGND sg13cmos5l_fill_2
X_2890_ _2916_/A _3455_/Q _2890_/B VPWR VGND sg13cmos5l_xor2_1
X_1841_ _2790_/A _1841_/A VPWR VGND sg13cmos5l_inv_1
XFILLER_31_966 VPWR VGND sg13cmos5l_decap_8
XFILLER_8_43 VPWR VGND sg13cmos5l_decap_8
XFILLER_8_87 VPWR VGND sg13cmos5l_decap_8
XFILLER_7_650 VPWR VGND sg13cmos5l_decap_8
XFILLER_6_171 VPWR VGND sg13cmos5l_decap_8
X_3511_ _3511_/Q clkload5/A _3511_/D _3511_/RESET_B VPWR VGND sg13cmos5l_dfrbpq_1
Xhold606 _2754_/A _3475_/Q VPWR VGND sg13cmos5l_dlygate4sd3_1
Xhold617 _3426_/D _2598_/Y VPWR VGND sg13cmos5l_dlygate4sd3_1
Xhold628 _3491_/D _2956_/Y VPWR VGND sg13cmos5l_dlygate4sd3_1
X_3442_ _3442_/Q _3442_/CLK _3442_/D _3442_/RESET_B VPWR VGND sg13cmos5l_dfrbpq_1
Xhold639 _3366_/D _2251_/Y VPWR VGND sg13cmos5l_dlygate4sd3_1
X_3373_ _3373_/Q _3463_/CLK _3373_/D _3373_/RESET_B VPWR VGND sg13cmos5l_dfrbpq_1
X_2324_ _2324_/X _2324_/A _2529_/A _2324_/C VPWR VGND sg13cmos5l_and3_1
X_2255_ _2255_/Y _3344_/Q _2958_/A2 _2776_/A VPWR VGND sg13cmos5l_o21ai_1
X_2186_ _2186_/Y _3356_/Q _3379_/Q VPWR VGND sg13cmos5l_nand2_1
XFILLER_38_543 VPWR VGND sg13cmos5l_fill_2
XFILLER_22_911 VPWR VGND sg13cmos5l_fill_1
XFILLER_21_410 VPWR VGND sg13cmos5l_fill_2
XFILLER_34_793 VPWR VGND sg13cmos5l_decap_4
XFILLER_22_988 VPWR VGND sg13cmos5l_decap_8
XFILLER_4_119 VPWR VGND sg13cmos5l_fill_1
XFILLER_0_314 VPWR VGND sg13cmos5l_decap_8
XFILLER_1_837 VPWR VGND sg13cmos5l_decap_8
XFILLER_1_1019 VPWR VGND sg13cmos5l_decap_8
XFILLER_44_568 VPWR VGND sg13cmos5l_fill_2
XFILLER_17_85 VPWR VGND sg13cmos5l_fill_1
XFILLER_12_421 VPWR VGND sg13cmos5l_decap_8
XFILLER_13_933 VPWR VGND sg13cmos5l_decap_8
XFILLER_24_270 VPWR VGND sg13cmos5l_decap_8
XFILLER_31_218 VPWR VGND sg13cmos5l_decap_8
XFILLER_40_752 VPWR VGND sg13cmos5l_fill_2
XFILLER_12_432 VPWR VGND sg13cmos5l_fill_1
XFILLER_40_774 VPWR VGND sg13cmos5l_fill_2
XFILLER_8_447 VPWR VGND sg13cmos5l_decap_8
XFILLER_39_329 VPWR VGND sg13cmos5l_fill_1
XFILLER_48_852 VPWR VGND sg13cmos5l_decap_8
XFILLER_47_340 VPWR VGND sg13cmos5l_decap_8
X_2040_ _2040_/X _2040_/A _2040_/B VPWR VGND sg13cmos5l_or2_1
X_3326__348 _3326_/RESET_B VPWR VGND sg13cmos5l_tiehi
XFILLER_47_384 VPWR VGND sg13cmos5l_decap_4
XFILLER_35_579 VPWR VGND sg13cmos5l_decap_8
X_2942_ _2943_/B _3491_/Q _2942_/B VPWR VGND sg13cmos5l_nor2_1
XFILLER_22_218 VPWR VGND sg13cmos5l_fill_2
X_2873_ _2874_/B _2854_/B _2872_/Y _2879_/C VPWR VGND sg13cmos5l_mux2_1
X_1824_ _2263_/A _2123_/B VPWR VGND sg13cmos5l_inv_1
XFILLER_8_981 VPWR VGND sg13cmos5l_decap_8
Xhold425 _2783_/B _3433_/Q VPWR VGND sg13cmos5l_dlygate4sd3_1
Xhold436 _2784_/B _3434_/Q VPWR VGND sg13cmos5l_dlygate4sd3_1
Xhold469 hold469/X _1946_/Y VPWR VGND sg13cmos5l_dlygate4sd3_1
Xhold447 _1797_/A _3494_/Q VPWR VGND sg13cmos5l_dlygate4sd3_1
Xhold458 _2261_/B _3348_/Q VPWR VGND sg13cmos5l_dlygate4sd3_1
X_3425_ _3425_/Q _3472_/CLK _3425_/D _3425_/RESET_B VPWR VGND sg13cmos5l_dfrbpq_1
X_3356_ _3356_/Q _3409_/CLK _3356_/D _3356_/RESET_B VPWR VGND sg13cmos5l_dfrbpq_1
X_3287_ _3287_/Q clkload9/A _3287_/D _3287_/RESET_B VPWR VGND sg13cmos5l_dfrbpq_1
X_2307_ _3379_/D _2307_/A _2307_/B _2307_/C VPWR VGND sg13cmos5l_nor3_1
X_2238_ _2239_/B _2203_/B _2232_/Y _2234_/Y _2237_/Y VPWR VGND sg13cmos5l_a22oi_1
XFILLER_38_362 VPWR VGND sg13cmos5l_fill_2
X_2169_ _2169_/Y _2163_/Y _2167_/Y _2168_/Y VPWR VGND sg13cmos5l_a21oi_1
XFILLER_13_218 VPWR VGND sg13cmos5l_decap_8
XFILLER_16_1016 VPWR VGND sg13cmos5l_decap_8
XFILLER_22_763 VPWR VGND sg13cmos5l_decap_8
XFILLER_16_1027 VPWR VGND sg13cmos5l_fill_2
XFILLER_21_240 VPWR VGND sg13cmos5l_decap_8
XFILLER_10_947 VPWR VGND sg13cmos5l_decap_8
X_3418__243 _3418_/RESET_B VPWR VGND sg13cmos5l_tiehi
XFILLER_5_428 VPWR VGND sg13cmos5l_decap_8
XFILLER_49_605 VPWR VGND sg13cmos5l_decap_8
XFILLER_45_800 VPWR VGND sg13cmos5l_fill_2
X_3425__236 _3425_/RESET_B VPWR VGND sg13cmos5l_tiehi
XFILLER_45_833 VPWR VGND sg13cmos5l_fill_2
XFILLER_44_354 VPWR VGND sg13cmos5l_fill_1
XFILLER_44_343 VPWR VGND sg13cmos5l_fill_1
XFILLER_44_398 VPWR VGND sg13cmos5l_decap_8
XFILLER_44_61 VPWR VGND sg13cmos5l_fill_1
XFILLER_44_50 VPWR VGND sg13cmos5l_decap_8
XFILLER_25_590 VPWR VGND sg13cmos5l_decap_8
XFILLER_40_560 VPWR VGND sg13cmos5l_decap_8
XFILLER_9_712 VPWR VGND sg13cmos5l_fill_2
XFILLER_9_778 VPWR VGND sg13cmos5l_decap_8
XFILLER_12_273 VPWR VGND sg13cmos5l_decap_8
XFILLER_5_973 VPWR VGND sg13cmos5l_decap_8
XFILLER_4_494 VPWR VGND sg13cmos5l_decap_4
X_3210_ _3210_/Y _3210_/A _3210_/B VPWR VGND sg13cmos5l_nor2_1
XFILLER_39_104 VPWR VGND sg13cmos5l_fill_2
X_3141_ _3201_/B _3212_/B _3141_/B VPWR VGND sg13cmos5l_nor2_1
X_3072_ _3513_/D _3223_/A _3205_/A VPWR VGND sg13cmos5l_nor2_1
XFILLER_47_181 VPWR VGND sg13cmos5l_fill_1
X_2023_ _2023_/Y hold583/X _2021_/Y _2115_/A VPWR VGND sg13cmos5l_a21oi_1
X_3477__99 _3477_/D VPWR VGND sg13cmos5l_tielo
XFILLER_35_376 VPWR VGND sg13cmos5l_decap_8
X_2925_ _2934_/B _2921_/Y _2923_/Y _2924_/Y VPWR VGND sg13cmos5l_o21ai_1
X_2856_ _2856_/Y _3479_/Q _3478_/Q _3121_/A VPWR VGND sg13cmos5l_nand3b_1
X_1807_ _1807_/Y _1807_/A VPWR VGND sg13cmos5l_inv_1
X_2787_ _3469_/D _2787_/A _2845_/A VPWR VGND sg13cmos5l_nor2_1
XFILLER_49_17 VPWR VGND sg13cmos5l_decap_8
X_3408_ _3408_/Q _3408_/CLK _3408_/D _3408_/RESET_B VPWR VGND sg13cmos5l_dfrbpq_1
X_3339_ _3339_/Q _3408_/CLK _3339_/D _3339_/RESET_B VPWR VGND sg13cmos5l_dfrbpq_1
XFILLER_39_660 VPWR VGND sg13cmos5l_decap_8
XFILLER_26_310 VPWR VGND sg13cmos5l_decap_8
XFILLER_26_343 VPWR VGND sg13cmos5l_fill_1
XFILLER_27_877 VPWR VGND sg13cmos5l_decap_8
XFILLER_42_825 VPWR VGND sg13cmos5l_fill_1
XFILLER_41_324 VPWR VGND sg13cmos5l_fill_2
XFILLER_41_302 VPWR VGND sg13cmos5l_fill_2
X_3498__392 _3498_/RESET_B VPWR VGND sg13cmos5l_tiehi
XFILLER_10_711 VPWR VGND sg13cmos5l_decap_8
XFILLER_10_722 VPWR VGND sg13cmos5l_fill_2
XFILLER_14_86 VPWR VGND sg13cmos5l_fill_1
XFILLER_2_910 VPWR VGND sg13cmos5l_decap_8
XFILLER_30_85 VPWR VGND sg13cmos5l_decap_4
XFILLER_49_424 VPWR VGND sg13cmos5l_decap_8
XFILLER_7_1025 VPWR VGND sg13cmos5l_decap_4
XFILLER_2_987 VPWR VGND sg13cmos5l_decap_8
XFILLER_39_83 VPWR VGND sg13cmos5l_decap_8
XFILLER_39_72 VPWR VGND sg13cmos5l_fill_1
XFILLER_49_468 VPWR VGND sg13cmos5l_fill_1
XFILLER_18_811 VPWR VGND sg13cmos5l_decap_4
XFILLER_45_696 VPWR VGND sg13cmos5l_decap_4
XFILLER_33_847 VPWR VGND sg13cmos5l_decap_8
XFILLER_32_357 VPWR VGND sg13cmos5l_fill_2
XFILLER_41_891 VPWR VGND sg13cmos5l_decap_8
X_2710_ _3449_/D _2839_/A _2828_/A VPWR VGND sg13cmos5l_nor2_1
XFILLER_9_553 VPWR VGND sg13cmos5l_decap_8
XFILLER_13_582 VPWR VGND sg13cmos5l_fill_1
XFILLER_9_597 VPWR VGND sg13cmos5l_fill_2
X_2641_ _2641_/X _2641_/A _2641_/B VPWR VGND sg13cmos5l_xor2_1
X_2572_ _2577_/B _2568_/Y _2570_/Y _2571_/Y VPWR VGND sg13cmos5l_o21ai_1
XFILLER_4_280 VPWR VGND sg13cmos5l_decap_8
X_3124_ _3529_/D _3124_/A _3125_/B VPWR VGND sg13cmos5l_nor2_1
XFILLER_28_608 VPWR VGND sg13cmos5l_fill_2
X_3408__253 _3408_/RESET_B VPWR VGND sg13cmos5l_tiehi
X_3055_ _3055_/Y _3056_/A _3069_/B VPWR VGND sg13cmos5l_nor2b_1
X_2006_ _3240_/A _1876_/A _2006_/B VPWR VGND sg13cmos5l_nand2b_1
XFILLER_24_836 VPWR VGND sg13cmos5l_fill_2
XFILLER_23_324 VPWR VGND sg13cmos5l_fill_1
X_2908_ _3483_/D _2968_/B _2908_/B VPWR VGND sg13cmos5l_nor2_1
X_3532__404 _3532_/RESET_B VPWR VGND sg13cmos5l_tiehi
X_2839_ _3473_/D _2839_/A _2839_/B _2839_/C VPWR VGND sg13cmos5l_nor3_1
X_3415__246 _3415_/RESET_B VPWR VGND sg13cmos5l_tiehi
XFILLER_47_906 VPWR VGND sg13cmos5l_decap_8
X_3422__239 _3422_/RESET_B VPWR VGND sg13cmos5l_tiehi
XFILLER_27_674 VPWR VGND sg13cmos5l_decap_8
XFILLER_27_685 VPWR VGND sg13cmos5l_fill_2
XFILLER_14_335 VPWR VGND sg13cmos5l_decap_4
X_3537__304 _3537_/RESET_B VPWR VGND sg13cmos5l_tiehi
XFILLER_26_184 VPWR VGND sg13cmos5l_decap_4
XFILLER_41_143 VPWR VGND sg13cmos5l_decap_8
XFILLER_14_368 VPWR VGND sg13cmos5l_decap_8
XFILLER_14_379 VPWR VGND sg13cmos5l_fill_1
XFILLER_41_187 VPWR VGND sg13cmos5l_decap_8
XFILLER_22_390 VPWR VGND sg13cmos5l_decap_8
XFILLER_41_84 VPWR VGND sg13cmos5l_decap_8
XFILLER_2_784 VPWR VGND sg13cmos5l_decap_8
XFILLER_1_283 VPWR VGND sg13cmos5l_fill_1
XFILLER_49_265 VPWR VGND sg13cmos5l_fill_2
XFILLER_49_276 VPWR VGND sg13cmos5l_decap_8
XFILLER_46_983 VPWR VGND sg13cmos5l_decap_8
XFILLER_45_493 VPWR VGND sg13cmos5l_decap_4
XFILLER_36_1008 VPWR VGND sg13cmos5l_decap_8
XFILLER_21_817 VPWR VGND sg13cmos5l_decap_8
XFILLER_32_165 VPWR VGND sg13cmos5l_decap_4
XFILLER_33_688 VPWR VGND sg13cmos5l_fill_2
XFILLER_14_880 VPWR VGND sg13cmos5l_decap_8
XFILLER_33_699 VPWR VGND sg13cmos5l_fill_2
X_2624_ _2647_/A _2555_/B _2511_/B _2651_/B VPWR VGND sg13cmos5l_mux2_1
X_2555_ _3419_/D _2673_/A _2555_/B VPWR VGND sg13cmos5l_nor2_1
X_2486_ _2518_/A _3442_/Q _3443_/Q VPWR VGND sg13cmos5l_xnor2_1
X_3107_ _3517_/D _3223_/A _3107_/B VPWR VGND sg13cmos5l_nor2_1
XFILLER_43_419 VPWR VGND sg13cmos5l_decap_8
XFILLER_37_972 VPWR VGND sg13cmos5l_decap_8
X_3038_ _3038_/Y _3038_/A _3038_/B _3038_/C VPWR VGND sg13cmos5l_nand3_1
XFILLER_23_132 VPWR VGND sg13cmos5l_fill_1
XFILLER_23_165 VPWR VGND sg13cmos5l_decap_8
XFILLER_20_850 VPWR VGND sg13cmos5l_decap_8
XFILLER_47_714 VPWR VGND sg13cmos5l_fill_2
XFILLER_46_246 VPWR VGND sg13cmos5l_fill_2
XFILLER_28_983 VPWR VGND sg13cmos5l_decap_8
XFILLER_34_419 VPWR VGND sg13cmos5l_decap_8
XFILLER_36_95 VPWR VGND sg13cmos5l_decap_8
XFILLER_43_986 VPWR VGND sg13cmos5l_decap_8
XFILLER_42_463 VPWR VGND sg13cmos5l_fill_2
XFILLER_42_452 VPWR VGND sg13cmos5l_decap_8
XFILLER_15_666 VPWR VGND sg13cmos5l_decap_8
XFILLER_42_496 VPWR VGND sg13cmos5l_decap_8
XFILLER_14_187 VPWR VGND sg13cmos5l_fill_1
XFILLER_14_198 VPWR VGND sg13cmos5l_decap_8
XFILLER_30_658 VPWR VGND sg13cmos5l_fill_2
XFILLER_30_669 VPWR VGND sg13cmos5l_decap_8
XFILLER_7_843 VPWR VGND sg13cmos5l_decap_8
XFILLER_10_371 VPWR VGND sg13cmos5l_decap_8
XFILLER_11_894 VPWR VGND sg13cmos5l_decap_8
XFILLER_6_342 VPWR VGND sg13cmos5l_decap_8
XFILLER_10_393 VPWR VGND sg13cmos5l_fill_1
XFILLER_6_375 VPWR VGND sg13cmos5l_decap_8
XFILLER_42_6 VPWR VGND sg13cmos5l_fill_1
X_2340_ _2341_/C _2350_/A _2326_/Y VPWR VGND sg13cmos5l_nor2b_1
XFILLER_42_1001 VPWR VGND sg13cmos5l_decap_8
X_2271_ _2271_/Y _2283_/A _2283_/C VPWR VGND sg13cmos5l_nand2_1
XFILLER_28_4 VPWR VGND sg13cmos5l_decap_4
XFILLER_37_257 VPWR VGND sg13cmos5l_fill_1
X_3405__256 _3405_/RESET_B VPWR VGND sg13cmos5l_tiehi
XFILLER_19_983 VPWR VGND sg13cmos5l_decap_8
XFILLER_25_408 VPWR VGND sg13cmos5l_decap_8
XFILLER_45_290 VPWR VGND sg13cmos5l_decap_4
XFILLER_33_452 VPWR VGND sg13cmos5l_fill_1
XFILLER_34_997 VPWR VGND sg13cmos5l_decap_8
XFILLER_20_113 VPWR VGND sg13cmos5l_fill_1
XFILLER_20_135 VPWR VGND sg13cmos5l_decap_8
XFILLER_21_669 VPWR VGND sg13cmos5l_decap_8
X_1986_ _1986_/X _1986_/A _2005_/A VPWR VGND sg13cmos5l_and2_1
Xclkbuf_leaf_9_clk _3463_/CLK clkload1/A VPWR VGND sg13cmos5l_buf_8
X_2607_ _3432_/D _1807_/Y _2963_/A2 _2606_/Y VPWR VGND sg13cmos5l_a21oi_1
X_3412__249 _3412_/RESET_B VPWR VGND sg13cmos5l_tiehi
XFILLER_0_518 VPWR VGND sg13cmos5l_decap_8
X_2538_ _2542_/B _3391_/Q _2538_/B VPWR VGND sg13cmos5l_xnor2_1
X_2469_ _2470_/B _2463_/A _2466_/Y _2467_/Y _2461_/Y _2468_/X VPWR VGND sg13cmos5l_a221oi_1
XFILLER_29_714 VPWR VGND sg13cmos5l_decap_4
XFILLER_17_909 VPWR VGND sg13cmos5l_decap_8
XFILLER_43_227 VPWR VGND sg13cmos5l_decap_8
XFILLER_19_1025 VPWR VGND sg13cmos5l_decap_4
XFILLER_25_986 VPWR VGND sg13cmos5l_decap_8
XFILLER_40_923 VPWR VGND sg13cmos5l_decap_8
XFILLER_24_474 VPWR VGND sg13cmos5l_fill_2
XFILLER_12_669 VPWR VGND sg13cmos5l_decap_8
XFILLER_7_117 VPWR VGND sg13cmos5l_fill_2
XFILLER_7_106 VPWR VGND sg13cmos5l_decap_8
XFILLER_11_157 VPWR VGND sg13cmos5l_decap_8
XFILLER_22_53 VPWR VGND sg13cmos5l_decap_8
XFILLER_4_868 VPWR VGND sg13cmos5l_decap_8
XFILLER_3_378 VPWR VGND sg13cmos5l_decap_8
XFILLER_19_213 VPWR VGND sg13cmos5l_decap_8
XFILLER_47_533 VPWR VGND sg13cmos5l_decap_8
XFILLER_19_224 VPWR VGND sg13cmos5l_fill_2
XFILLER_19_279 VPWR VGND sg13cmos5l_decap_8
XFILLER_35_739 VPWR VGND sg13cmos5l_decap_8
XFILLER_16_920 VPWR VGND sg13cmos5l_fill_1
XFILLER_16_953 VPWR VGND sg13cmos5l_decap_8
X_1840_ _2789_/A _1840_/A VPWR VGND sg13cmos5l_inv_1
XFILLER_30_444 VPWR VGND sg13cmos5l_fill_1
XFILLER_30_488 VPWR VGND sg13cmos5l_decap_8
X_3510_ _3510_/Q clkload5/A _3510_/D _3510_/RESET_B VPWR VGND sg13cmos5l_dfrbpq_1
XFILLER_7_684 VPWR VGND sg13cmos5l_fill_2
Xhold618 _2759_/B _3477_/Q VPWR VGND sg13cmos5l_dlygate4sd3_1
Xhold607 _3502_/D _2969_/Y VPWR VGND sg13cmos5l_dlygate4sd3_1
Xhold629 _2967_/A _3473_/Q VPWR VGND sg13cmos5l_dlygate4sd3_1
X_3441_ _3441_/Q _3442_/CLK _3441_/D _3441_/RESET_B VPWR VGND sg13cmos5l_dfrbpq_1
X_3372_ _3372_/Q _3378_/CLK _3372_/D _3372_/RESET_B VPWR VGND sg13cmos5l_dfrbpq_1
X_3370__296 _3370_/RESET_B VPWR VGND sg13cmos5l_tiehi
X_2323_ _2323_/X _2324_/A _2324_/C _2529_/A VPWR VGND sg13cmos5l_a21o_1
XFILLER_38_500 VPWR VGND sg13cmos5l_decap_8
X_2254_ _3369_/D _1812_/Y _2958_/A2 _2253_/Y VPWR VGND sg13cmos5l_a21oi_1
X_2185_ _2202_/A _2185_/A _2184_/Y VPWR VGND sg13cmos5l_nor2b_1
XFILLER_38_577 VPWR VGND sg13cmos5l_decap_8
XFILLER_25_249 VPWR VGND sg13cmos5l_fill_2
X_3342__332 _3342_/RESET_B VPWR VGND sg13cmos5l_tiehi
XFILLER_41_709 VPWR VGND sg13cmos5l_decap_4
XFILLER_34_761 VPWR VGND sg13cmos5l_fill_1
X_3479__176 _3479_/RESET_B VPWR VGND sg13cmos5l_tiehi
XFILLER_22_967 VPWR VGND sg13cmos5l_decap_8
XFILLER_33_293 VPWR VGND sg13cmos5l_decap_8
XFILLER_21_466 VPWR VGND sg13cmos5l_decap_8
X_1969_ _1969_/Y _1965_/Y _1968_/Y _3257_/A VPWR VGND sg13cmos5l_a21oi_1
XFILLER_1_816 VPWR VGND sg13cmos5l_decap_8
X_3486__169 _3486_/RESET_B VPWR VGND sg13cmos5l_tiehi
X_3382__112 _3382_/D VPWR VGND sg13cmos5l_tielo
X_3527__166 _3527_/RESET_B VPWR VGND sg13cmos5l_tiehi
XFILLER_29_544 VPWR VGND sg13cmos5l_decap_8
XFILLER_29_555 VPWR VGND sg13cmos5l_fill_2
XFILLER_17_706 VPWR VGND sg13cmos5l_fill_1
XFILLER_44_547 VPWR VGND sg13cmos5l_decap_8
XFILLER_12_400 VPWR VGND sg13cmos5l_decap_8
XFILLER_13_912 VPWR VGND sg13cmos5l_decap_8
XFILLER_40_797 VPWR VGND sg13cmos5l_decap_8
XFILLER_9_949 VPWR VGND sg13cmos5l_decap_8
XFILLER_13_989 VPWR VGND sg13cmos5l_decap_8
X_3538__295 _3538_/RESET_B VPWR VGND sg13cmos5l_tiehi
XFILLER_33_63 VPWR VGND sg13cmos5l_fill_1
XFILLER_12_499 VPWR VGND sg13cmos5l_decap_8
XFILLER_4_610 VPWR VGND sg13cmos5l_decap_8
XFILLER_3_153 VPWR VGND sg13cmos5l_fill_2
X_3289__411 _3289_/RESET_B VPWR VGND sg13cmos5l_tiehi
XFILLER_4_698 VPWR VGND sg13cmos5l_decap_8
XFILLER_3_186 VPWR VGND sg13cmos5l_decap_8
XFILLER_39_308 VPWR VGND sg13cmos5l_decap_8
XFILLER_39_319 VPWR VGND sg13cmos5l_fill_1
XFILLER_0_882 VPWR VGND sg13cmos5l_decap_8
XFILLER_48_831 VPWR VGND sg13cmos5l_decap_8
XFILLER_23_709 VPWR VGND sg13cmos5l_fill_2
X_2941_ _2941_/Y _2951_/B _2952_/A _2940_/Y VPWR VGND sg13cmos5l_o21ai_1
XFILLER_16_772 VPWR VGND sg13cmos5l_decap_8
X_3402__259 _3402_/RESET_B VPWR VGND sg13cmos5l_tiehi
XFILLER_15_293 VPWR VGND sg13cmos5l_fill_2
X_2872_ _2872_/Y _3121_/A _2879_/B VPWR VGND sg13cmos5l_nand2_1
XFILLER_31_797 VPWR VGND sg13cmos5l_fill_2
X_1823_ _2265_/A _1823_/A VPWR VGND sg13cmos5l_inv_1
XFILLER_30_274 VPWR VGND sg13cmos5l_fill_1
XFILLER_8_960 VPWR VGND sg13cmos5l_decap_8
Xhold426 _2427_/B _3373_/Q VPWR VGND sg13cmos5l_dlygate4sd3_1
Xhold448 _3523_/D _3116_/Y VPWR VGND sg13cmos5l_dlygate4sd3_1
X_3424_ _3424_/Q _3472_/CLK _3424_/D _3424_/RESET_B VPWR VGND sg13cmos5l_dfrbpq_1
Xhold459 _2252_/B _3342_/Q VPWR VGND sg13cmos5l_dlygate4sd3_1
Xhold437 _2446_/B _3374_/Q VPWR VGND sg13cmos5l_dlygate4sd3_1
X_3355_ _3355_/Q _3355_/CLK _3355_/D _3355_/RESET_B VPWR VGND sg13cmos5l_dfrbpq_1
X_2306_ _2307_/C _2308_/S _2299_/B VPWR VGND sg13cmos5l_nor2b_1
X_3286_ _3286_/Q clkload8/A _3286_/D _3286_/RESET_B VPWR VGND sg13cmos5l_dfrbpq_1
X_2237_ _2237_/Y _3341_/Q _2237_/B VPWR VGND sg13cmos5l_nor2_1
XFILLER_39_875 VPWR VGND sg13cmos5l_decap_4
X_2168_ _2168_/Y _2162_/C _2166_/Y _2161_/X VPWR VGND sg13cmos5l_o21ai_1
X_2099_ _2099_/Y _2214_/A _2095_/A _2097_/X _2263_/A _2098_/Y VPWR VGND sg13cmos5l_a221oi_1
XFILLER_10_926 VPWR VGND sg13cmos5l_decap_8
XFILLER_21_285 VPWR VGND sg13cmos5l_decap_4
XFILLER_5_407 VPWR VGND sg13cmos5l_fill_1
XFILLER_17_503 VPWR VGND sg13cmos5l_decap_4
Xheichips26_dna_sequencer uio_oe[0] VPWR VGND sg13cmos5l_tielo
XFILLER_28_85 VPWR VGND sg13cmos5l_decap_8
XFILLER_29_396 VPWR VGND sg13cmos5l_fill_1
XFILLER_12_230 VPWR VGND sg13cmos5l_decap_4
XFILLER_8_245 VPWR VGND sg13cmos5l_decap_8
XFILLER_9_746 VPWR VGND sg13cmos5l_decap_8
X_3332__342 _3332_/RESET_B VPWR VGND sg13cmos5l_tiehi
XFILLER_5_952 VPWR VGND sg13cmos5l_decap_8
XFILLER_5_45 VPWR VGND sg13cmos5l_decap_4
XFILLER_5_78 VPWR VGND sg13cmos5l_decap_8
X_3469__186 _3469_/RESET_B VPWR VGND sg13cmos5l_tiehi
X_3140_ _3141_/B _3530_/Q _3143_/B _3138_/Y _3207_/B VPWR VGND sg13cmos5l_a22oi_1
XFILLER_36_801 VPWR VGND sg13cmos5l_decap_4
XFILLER_10_4 VPWR VGND sg13cmos5l_fill_2
X_3071_ _3205_/A _3045_/Y _3070_/A _3070_/Y VPWR VGND sg13cmos5l_o21ai_1
X_2022_ _2115_/A _2147_/A _2162_/A VPWR VGND sg13cmos5l_nand2b_1
XFILLER_39_1028 VPWR VGND sg13cmos5l_fill_1
XFILLER_39_1017 VPWR VGND sg13cmos5l_decap_8
XFILLER_36_889 VPWR VGND sg13cmos5l_decap_8
X_3476__179 _3476_/RESET_B VPWR VGND sg13cmos5l_tiehi
X_2924_ _2924_/Y _3509_/Q _2930_/A _3459_/Q _3124_/A VPWR VGND sg13cmos5l_a22oi_1
X_2855_ _2855_/Y _3121_/A _3478_/Q VPWR VGND sg13cmos5l_nand2_1
X_1806_ _3086_/B _3488_/Q VPWR VGND sg13cmos5l_inv_1
X_2786_ _3468_/D _2786_/A _2786_/B VPWR VGND sg13cmos5l_and2_1
X_3407_ _3407_/Q _3409_/CLK _3407_/D _3407_/RESET_B VPWR VGND sg13cmos5l_dfrbpq_1
X_3338_ _3338_/Q _3408_/CLK _3338_/D _3338_/RESET_B VPWR VGND sg13cmos5l_dfrbpq_1
XFILLER_27_801 VPWR VGND sg13cmos5l_decap_8
X_3269_ _3269_/Q clkload7/A _3269_/D _3269_/RESET_B VPWR VGND sg13cmos5l_dfrbpq_1
XFILLER_45_119 VPWR VGND sg13cmos5l_decap_8
XFILLER_39_683 VPWR VGND sg13cmos5l_decap_8
XFILLER_38_193 VPWR VGND sg13cmos5l_decap_8
XFILLER_27_856 VPWR VGND sg13cmos5l_decap_8
XFILLER_41_314 VPWR VGND sg13cmos5l_decap_4
XFILLER_22_561 VPWR VGND sg13cmos5l_fill_1
XFILLER_22_594 VPWR VGND sg13cmos5l_decap_8
XFILLER_5_215 VPWR VGND sg13cmos5l_decap_8
XFILLER_30_53 VPWR VGND sg13cmos5l_decap_8
XFILLER_1_410 VPWR VGND sg13cmos5l_decap_8
XFILLER_2_966 VPWR VGND sg13cmos5l_decap_8
XFILLER_1_421 VPWR VGND sg13cmos5l_fill_1
XFILLER_49_403 VPWR VGND sg13cmos5l_decap_8
X_3286__414 _3286_/RESET_B VPWR VGND sg13cmos5l_tiehi
XFILLER_7_1004 VPWR VGND sg13cmos5l_decap_8
XFILLER_36_119 VPWR VGND sg13cmos5l_decap_8
XFILLER_45_664 VPWR VGND sg13cmos5l_decap_8
XFILLER_44_141 VPWR VGND sg13cmos5l_fill_2
XFILLER_18_856 VPWR VGND sg13cmos5l_decap_8
XFILLER_29_182 VPWR VGND sg13cmos5l_decap_8
XFILLER_44_174 VPWR VGND sg13cmos5l_fill_1
XFILLER_18_889 VPWR VGND sg13cmos5l_fill_1
XFILLER_44_185 VPWR VGND sg13cmos5l_decap_4
X_3293__407 _3293_/RESET_B VPWR VGND sg13cmos5l_tiehi
XFILLER_9_576 VPWR VGND sg13cmos5l_decap_8
X_2640_ _2641_/B _2640_/A _2646_/A VPWR VGND sg13cmos5l_nor2_1
X_2571_ _2571_/Y _3445_/Q _2417_/A _3396_/Q _2789_/A VPWR VGND sg13cmos5l_a22oi_1
XFILLER_5_771 VPWR VGND sg13cmos5l_fill_2
XFILLER_5_760 VPWR VGND sg13cmos5l_decap_8
XFILLER_4_270 VPWR VGND sg13cmos5l_fill_2
X_3123_ _3528_/D _3123_/A _3125_/B VPWR VGND sg13cmos5l_nor2_1
XFILLER_49_981 VPWR VGND sg13cmos5l_decap_8
X_3054_ _3069_/B _3536_/Q _3054_/B VPWR VGND sg13cmos5l_xnor2_1
XFILLER_36_664 VPWR VGND sg13cmos5l_decap_8
XFILLER_36_631 VPWR VGND sg13cmos5l_fill_2
X_2005_ _2005_/Y _2005_/A _2038_/B _2005_/C VPWR VGND sg13cmos5l_nor3_1
XFILLER_24_815 VPWR VGND sg13cmos5l_decap_8
XFILLER_35_196 VPWR VGND sg13cmos5l_decap_8
X_2907_ _2908_/B _2907_/A _2907_/B VPWR VGND sg13cmos5l_nor2_1
XFILLER_31_391 VPWR VGND sg13cmos5l_decap_4
X_2838_ _2839_/C _2838_/A _2844_/S VPWR VGND sg13cmos5l_nor2b_1
XFILLER_3_708 VPWR VGND sg13cmos5l_decap_8
X_2769_ _2769_/Y _2752_/Y _2767_/Y _2768_/Y VPWR VGND sg13cmos5l_a21oi_1
XFILLER_2_218 VPWR VGND sg13cmos5l_fill_2
XFILLER_46_417 VPWR VGND sg13cmos5l_decap_8
XFILLER_27_620 VPWR VGND sg13cmos5l_decap_4
XFILLER_14_303 VPWR VGND sg13cmos5l_decap_8
XFILLER_15_826 VPWR VGND sg13cmos5l_decap_8
XFILLER_15_837 VPWR VGND sg13cmos5l_fill_2
XFILLER_26_141 VPWR VGND sg13cmos5l_decap_8
XFILLER_25_31 VPWR VGND sg13cmos5l_fill_2
XFILLER_25_86 VPWR VGND sg13cmos5l_decap_8
XFILLER_22_380 VPWR VGND sg13cmos5l_decap_4
XFILLER_10_542 VPWR VGND sg13cmos5l_fill_2
XFILLER_10_586 VPWR VGND sg13cmos5l_decap_8
XFILLER_2_763 VPWR VGND sg13cmos5l_decap_8
XFILLER_1_240 VPWR VGND sg13cmos5l_decap_4
XFILLER_38_929 VPWR VGND sg13cmos5l_decap_8
X_3466__189 _3466_/RESET_B VPWR VGND sg13cmos5l_tiehi
XFILLER_49_299 VPWR VGND sg13cmos5l_decap_8
XFILLER_37_428 VPWR VGND sg13cmos5l_fill_1
XFILLER_46_962 VPWR VGND sg13cmos5l_decap_8
XFILLER_17_141 VPWR VGND sg13cmos5l_decap_4
XFILLER_17_185 VPWR VGND sg13cmos5l_fill_2
XFILLER_33_623 VPWR VGND sg13cmos5l_fill_1
XFILLER_20_339 VPWR VGND sg13cmos5l_decap_4
XFILLER_32_188 VPWR VGND sg13cmos5l_decap_8
XFILLER_12_1020 VPWR VGND sg13cmos5l_decap_8
X_2623_ _2651_/B _2620_/Y _2622_/Y _2616_/X VPWR VGND sg13cmos5l_o21ai_1
X_2554_ _2555_/B _2618_/C _2618_/D VPWR VGND sg13cmos5l_nand2_1
X_2485_ _2485_/Y _2498_/A _2498_/B VPWR VGND sg13cmos5l_nand2_1
X_3106_ _3107_/B _3085_/Y _1802_/Y _3110_/S VPWR VGND sg13cmos5l_mux2_1
XFILLER_28_428 VPWR VGND sg13cmos5l_decap_4
XFILLER_37_951 VPWR VGND sg13cmos5l_decap_8
X_3037_ _3038_/C _3063_/A _3035_/B _3036_/X VPWR VGND sg13cmos5l_o21ai_1
X_3421__240 _3421_/RESET_B VPWR VGND sg13cmos5l_tiehi
XFILLER_36_483 VPWR VGND sg13cmos5l_fill_2
XFILLER_36_494 VPWR VGND sg13cmos5l_fill_2
XFILLER_24_656 VPWR VGND sg13cmos5l_decap_8
XFILLER_11_317 VPWR VGND sg13cmos5l_decap_8
XFILLER_11_11 VPWR VGND sg13cmos5l_fill_2
X_3283__417 _3283_/RESET_B VPWR VGND sg13cmos5l_tiehi
XFILLER_47_759 VPWR VGND sg13cmos5l_decap_8
XFILLER_28_962 VPWR VGND sg13cmos5l_decap_8
XFILLER_27_472 VPWR VGND sg13cmos5l_fill_1
XFILLER_15_645 VPWR VGND sg13cmos5l_decap_8
XFILLER_36_74 VPWR VGND sg13cmos5l_decap_8
XFILLER_43_965 VPWR VGND sg13cmos5l_decap_8
XFILLER_14_144 VPWR VGND sg13cmos5l_decap_8
XFILLER_42_475 VPWR VGND sg13cmos5l_decap_8
XFILLER_7_822 VPWR VGND sg13cmos5l_decap_8
XFILLER_11_873 VPWR VGND sg13cmos5l_decap_8
XFILLER_6_321 VPWR VGND sg13cmos5l_decap_8
XFILLER_7_899 VPWR VGND sg13cmos5l_decap_8
XFILLER_6_387 VPWR VGND sg13cmos5l_fill_2
XFILLER_6_398 VPWR VGND sg13cmos5l_decap_8
XFILLER_2_571 VPWR VGND sg13cmos5l_fill_2
X_2270_ _2283_/C _2268_/Y _2269_/Y _2285_/A VPWR VGND sg13cmos5l_a21oi_1
X_3544__128 _3544_/RESET_B VPWR VGND sg13cmos5l_tiehi
XFILLER_38_726 VPWR VGND sg13cmos5l_decap_8
XFILLER_37_214 VPWR VGND sg13cmos5l_fill_1
XFILLER_19_962 VPWR VGND sg13cmos5l_decap_8
XFILLER_34_910 VPWR VGND sg13cmos5l_fill_2
XFILLER_34_932 VPWR VGND sg13cmos5l_fill_1
XFILLER_21_604 VPWR VGND sg13cmos5l_fill_2
XFILLER_33_464 VPWR VGND sg13cmos5l_decap_8
XFILLER_34_976 VPWR VGND sg13cmos5l_decap_8
X_1985_ _3309_/D _3257_/A _1985_/B VPWR VGND sg13cmos5l_nor2_1
XFILLER_9_170 VPWR VGND sg13cmos5l_fill_1
XFILLER_20_158 VPWR VGND sg13cmos5l_decap_8
XFILLER_9_192 VPWR VGND sg13cmos5l_decap_8
X_2606_ _2606_/Y _2446_/A _2963_/A2 _2784_/A VPWR VGND sg13cmos5l_o21ai_1
X_2537_ _2537_/X _3391_/Q _2538_/B VPWR VGND sg13cmos5l_xor2_1
X_2468_ _2468_/X _2468_/A _2468_/B _2468_/C VPWR VGND sg13cmos5l_and3_1
X_2399_ _2399_/Y _3367_/Q _2399_/B _2399_/C VPWR VGND sg13cmos5l_nor3_1
XFILLER_43_206 VPWR VGND sg13cmos5l_decap_8
XFILLER_40_902 VPWR VGND sg13cmos5l_decap_8
XFILLER_19_1004 VPWR VGND sg13cmos5l_decap_8
XFILLER_24_453 VPWR VGND sg13cmos5l_decap_8
XFILLER_25_965 VPWR VGND sg13cmos5l_decap_8
XFILLER_40_979 VPWR VGND sg13cmos5l_decap_8
XFILLER_11_136 VPWR VGND sg13cmos5l_decap_8
XFILLER_12_648 VPWR VGND sg13cmos5l_decap_8
XFILLER_20_681 VPWR VGND sg13cmos5l_decap_8
XFILLER_20_692 VPWR VGND sg13cmos5l_fill_1
XFILLER_22_87 VPWR VGND sg13cmos5l_fill_1
XFILLER_4_847 VPWR VGND sg13cmos5l_decap_8
XFILLER_47_512 VPWR VGND sg13cmos5l_decap_8
XFILLER_47_501 VPWR VGND sg13cmos5l_decap_8
XFILLER_47_62 VPWR VGND sg13cmos5l_decap_4
XFILLER_47_51 VPWR VGND sg13cmos5l_fill_2
XFILLER_47_589 VPWR VGND sg13cmos5l_decap_8
XFILLER_47_567 VPWR VGND sg13cmos5l_fill_2
XFILLER_28_770 VPWR VGND sg13cmos5l_fill_2
XFILLER_35_718 VPWR VGND sg13cmos5l_decap_8
XFILLER_16_932 VPWR VGND sg13cmos5l_decap_8
XFILLER_28_781 VPWR VGND sg13cmos5l_fill_1
XFILLER_31_902 VPWR VGND sg13cmos5l_decap_8
XFILLER_43_784 VPWR VGND sg13cmos5l_decap_8
XFILLER_8_12 VPWR VGND sg13cmos5l_decap_8
XFILLER_30_423 VPWR VGND sg13cmos5l_decap_8
XFILLER_30_456 VPWR VGND sg13cmos5l_decap_8
XFILLER_7_630 VPWR VGND sg13cmos5l_decap_4
Xhold608 _2774_/B _3459_/Q VPWR VGND sg13cmos5l_dlygate4sd3_1
Xhold619 _3504_/D _2971_/Y VPWR VGND sg13cmos5l_dlygate4sd3_1
X_3440_ _3440_/Q _3444_/CLK _3440_/D _3440_/RESET_B VPWR VGND sg13cmos5l_dfrbpq_1
XFILLER_40_4 VPWR VGND sg13cmos5l_fill_2
X_3371_ _3371_/Q _3463_/CLK _3371_/D _3371_/RESET_B VPWR VGND sg13cmos5l_dfrbpq_1
X_2322_ _2322_/X _2324_/A _2324_/C VPWR VGND sg13cmos5l_and2_1
XFILLER_3_891 VPWR VGND sg13cmos5l_decap_8
X_3411__250 _3411_/RESET_B VPWR VGND sg13cmos5l_tiehi
X_3329__122 _3329_/D VPWR VGND sg13cmos5l_tielo
X_2253_ _2253_/Y hold487/X _2958_/A2 _2776_/A VPWR VGND sg13cmos5l_o21ai_1
X_2184_ _2184_/Y _3356_/Q _3357_/Q _3358_/Q VPWR VGND sg13cmos5l_o21ai_1
XFILLER_38_545 VPWR VGND sg13cmos5l_fill_1
XFILLER_19_770 VPWR VGND sg13cmos5l_fill_2
XFILLER_19_792 VPWR VGND sg13cmos5l_decap_8
XFILLER_25_217 VPWR VGND sg13cmos5l_decap_8
XFILLER_33_261 VPWR VGND sg13cmos5l_decap_8
XFILLER_22_946 VPWR VGND sg13cmos5l_decap_8
X_1968_ _1968_/Y _1961_/X _1966_/X _1967_/Y VPWR VGND sg13cmos5l_o21ai_1
XFILLER_30_990 VPWR VGND sg13cmos5l_decap_8
X_1899_ _3546_/D _2018_/A _1899_/B VPWR VGND sg13cmos5l_and2_1
XFILLER_0_327 VPWR VGND sg13cmos5l_decap_8
XFILLER_0_338 VPWR VGND sg13cmos5l_fill_1
XFILLER_0_349 VPWR VGND sg13cmos5l_decap_8
XFILLER_17_729 VPWR VGND sg13cmos5l_decap_8
XFILLER_44_537 VPWR VGND sg13cmos5l_decap_4
XFILLER_40_710 VPWR VGND sg13cmos5l_fill_2
XFILLER_13_968 VPWR VGND sg13cmos5l_decap_8
XFILLER_33_31 VPWR VGND sg13cmos5l_fill_1
XFILLER_8_405 VPWR VGND sg13cmos5l_fill_1
XFILLER_9_928 VPWR VGND sg13cmos5l_decap_8
XFILLER_21_990 VPWR VGND sg13cmos5l_decap_8
XFILLER_4_644 VPWR VGND sg13cmos5l_decap_4
XFILLER_4_666 VPWR VGND sg13cmos5l_decap_8
XFILLER_3_132 VPWR VGND sg13cmos5l_decap_8
XFILLER_48_810 VPWR VGND sg13cmos5l_decap_8
XFILLER_0_861 VPWR VGND sg13cmos5l_decap_8
XFILLER_48_887 VPWR VGND sg13cmos5l_decap_8
XFILLER_35_548 VPWR VGND sg13cmos5l_decap_8
X_3359__115 _3359_/D VPWR VGND sg13cmos5l_tielo
X_2940_ _2940_/Y _3491_/Q _2942_/B VPWR VGND sg13cmos5l_nand2_1
XFILLER_31_721 VPWR VGND sg13cmos5l_decap_8
XFILLER_43_592 VPWR VGND sg13cmos5l_decap_8
X_2871_ _2879_/C _2864_/Y _2869_/Y _2882_/B VPWR VGND sg13cmos5l_o21ai_1
XFILLER_15_272 VPWR VGND sg13cmos5l_decap_8
XFILLER_31_732 VPWR VGND sg13cmos5l_fill_1
X_1822_ _2429_/A _2196_/A VPWR VGND sg13cmos5l_inv_1
XFILLER_7_493 VPWR VGND sg13cmos5l_decap_8
Xhold427 _2014_/B _3313_/Q VPWR VGND sg13cmos5l_dlygate4sd3_1
Xhold438 _2114_/A _3327_/Q VPWR VGND sg13cmos5l_dlygate4sd3_1
Xhold449 _2162_/A _3328_/Q VPWR VGND sg13cmos5l_dlygate4sd3_1
X_3423_ _3423_/Q _3453_/CLK _3423_/D _3423_/RESET_B VPWR VGND sg13cmos5l_dfrbpq_1
X_3354_ _3354_/Q _3378_/CLK _3354_/D _3354_/RESET_B VPWR VGND sg13cmos5l_dfrbpq_1
X_3285_ _3285_/Q clkload9/A _3285_/D _3285_/RESET_B VPWR VGND sg13cmos5l_dfrbpq_1
X_2305_ _2307_/B _2305_/A _2308_/S VPWR VGND sg13cmos5l_nor2b_1
X_3485__170 _3485_/RESET_B VPWR VGND sg13cmos5l_tiehi
X_2236_ _2240_/B _2232_/Y _2233_/Y _2234_/Y _2235_/Y VPWR VGND sg13cmos5l_a22oi_1
XFILLER_39_854 VPWR VGND sg13cmos5l_fill_2
XFILLER_38_353 VPWR VGND sg13cmos5l_decap_4
X_2167_ _2167_/Y _2162_/C _2166_/Y _2159_/Y VPWR VGND sg13cmos5l_a21oi_1
X_2098_ _2098_/Y _2123_/B _3331_/Q _2096_/Y VPWR VGND sg13cmos5l_a21oi_1
XFILLER_41_529 VPWR VGND sg13cmos5l_decap_8
X_3494__406 _3494_/RESET_B VPWR VGND sg13cmos5l_tiehi
XFILLER_22_743 VPWR VGND sg13cmos5l_fill_2
XFILLER_10_905 VPWR VGND sg13cmos5l_decap_8
XFILLER_22_787 VPWR VGND sg13cmos5l_decap_8
XFILLER_6_909 VPWR VGND sg13cmos5l_decap_8
XFILLER_0_124 VPWR VGND sg13cmos5l_decap_4
XFILLER_1_647 VPWR VGND sg13cmos5l_decap_8
XFILLER_1_658 VPWR VGND sg13cmos5l_fill_1
XFILLER_28_64 VPWR VGND sg13cmos5l_decap_8
XFILLER_29_342 VPWR VGND sg13cmos5l_decap_8
XFILLER_45_846 VPWR VGND sg13cmos5l_decap_8
XFILLER_17_515 VPWR VGND sg13cmos5l_fill_2
XFILLER_45_879 VPWR VGND sg13cmos5l_decap_8
XFILLER_40_551 VPWR VGND sg13cmos5l_fill_1
XFILLER_9_714 VPWR VGND sg13cmos5l_fill_1
XFILLER_40_595 VPWR VGND sg13cmos5l_decap_8
XFILLER_8_279 VPWR VGND sg13cmos5l_decap_4
XFILLER_5_931 VPWR VGND sg13cmos5l_decap_8
XFILLER_39_106 VPWR VGND sg13cmos5l_fill_1
X_3070_ _3070_/Y _3070_/A _3070_/B VPWR VGND sg13cmos5l_nand2_1
XFILLER_48_651 VPWR VGND sg13cmos5l_decap_8
X_2021_ _2021_/Y _2021_/A _2025_/B VPWR VGND sg13cmos5l_nor2b_1
XFILLER_47_172 VPWR VGND sg13cmos5l_decap_8
XFILLER_36_868 VPWR VGND sg13cmos5l_decap_8
XFILLER_36_857 VPWR VGND sg13cmos5l_decap_8
X_2923_ _2923_/Y _3124_/A _3459_/Q _2922_/Y VPWR VGND sg13cmos5l_o21ai_1
X_2854_ _2854_/X _2854_/A _2854_/B VPWR VGND sg13cmos5l_xor2_1
XFILLER_31_584 VPWR VGND sg13cmos5l_decap_8
X_1805_ _2948_/B _1805_/A VPWR VGND sg13cmos5l_inv_1
X_2785_ _3467_/D _2966_/A _2785_/B VPWR VGND sg13cmos5l_and2_1
X_3406_ _3406_/Q _3463_/CLK _3406_/D _3406_/RESET_B VPWR VGND sg13cmos5l_dfrbpq_1
X_3337_ _3337_/Q _3378_/CLK _3337_/D _3337_/RESET_B VPWR VGND sg13cmos5l_dfrbpq_1
X_3268_ _3268_/Q clkload8/A _3268_/D _3268_/RESET_B VPWR VGND sg13cmos5l_dfrbpq_1
X_2219_ _2220_/B _2106_/Y _2215_/Y _2218_/Y VPWR VGND sg13cmos5l_o21ai_1
X_3199_ _3199_/X _3199_/A _3199_/B VPWR VGND sg13cmos5l_or2_1
XFILLER_27_846 VPWR VGND sg13cmos5l_fill_1
XFILLER_26_334 VPWR VGND sg13cmos5l_decap_8
XFILLER_41_304 VPWR VGND sg13cmos5l_fill_1
XFILLER_41_337 VPWR VGND sg13cmos5l_fill_2
XFILLER_10_735 VPWR VGND sg13cmos5l_decap_8
XFILLER_22_573 VPWR VGND sg13cmos5l_decap_8
XFILLER_6_717 VPWR VGND sg13cmos5l_fill_2
XFILLER_6_706 VPWR VGND sg13cmos5l_decap_8
XFILLER_10_779 VPWR VGND sg13cmos5l_decap_8
XFILLER_6_739 VPWR VGND sg13cmos5l_decap_4
XFILLER_6_728 VPWR VGND sg13cmos5l_fill_2
XFILLER_2_945 VPWR VGND sg13cmos5l_decap_8
XFILLER_1_444 VPWR VGND sg13cmos5l_fill_2
XFILLER_49_459 VPWR VGND sg13cmos5l_decap_8
XFILLER_17_312 VPWR VGND sg13cmos5l_decap_8
XFILLER_44_120 VPWR VGND sg13cmos5l_decap_8
XFILLER_17_323 VPWR VGND sg13cmos5l_fill_1
XFILLER_18_868 VPWR VGND sg13cmos5l_decap_8
XFILLER_44_153 VPWR VGND sg13cmos5l_decap_8
XFILLER_13_595 VPWR VGND sg13cmos5l_decap_8
X_3475__180 _3475_/RESET_B VPWR VGND sg13cmos5l_tiehi
X_2570_ _2570_/Y _2789_/A _3396_/Q _2569_/Y VPWR VGND sg13cmos5l_o21ai_1
X_3122_ _3527_/D _3122_/A _3125_/B VPWR VGND sg13cmos5l_nor2_1
XFILLER_49_960 VPWR VGND sg13cmos5l_decap_8
X_3053_ _3053_/Y _3069_/A _3044_/X _3047_/Y _3038_/Y _3052_/Y VPWR VGND sg13cmos5l_a221oi_1
X_3482__173 _3482_/RESET_B VPWR VGND sg13cmos5l_tiehi
X_2004_ _2005_/C _2004_/A _2004_/B VPWR VGND sg13cmos5l_nand2_1
XFILLER_24_838 VPWR VGND sg13cmos5l_fill_1
XFILLER_23_315 VPWR VGND sg13cmos5l_decap_8
X_2906_ _2907_/B _2904_/A _2904_/B _2697_/Y VPWR VGND sg13cmos5l_a21oi_1
XFILLER_31_370 VPWR VGND sg13cmos5l_decap_8
X_2837_ _2839_/B _2844_/S _2822_/A VPWR VGND sg13cmos5l_nor2b_1
X_2768_ _2768_/Y hold604/X _2767_/Y _2786_/B VPWR VGND sg13cmos5l_o21ai_1
X_2699_ _3446_/D _2839_/A _2699_/B VPWR VGND sg13cmos5l_nor2_1
XFILLER_18_109 VPWR VGND sg13cmos5l_fill_2
XFILLER_39_492 VPWR VGND sg13cmos5l_fill_2
XFILLER_42_635 VPWR VGND sg13cmos5l_decap_8
XFILLER_42_679 VPWR VGND sg13cmos5l_fill_1
XFILLER_42_657 VPWR VGND sg13cmos5l_decap_8
XFILLER_30_808 VPWR VGND sg13cmos5l_decap_8
XFILLER_22_370 VPWR VGND sg13cmos5l_decap_4
XFILLER_23_882 VPWR VGND sg13cmos5l_decap_8
XFILLER_6_525 VPWR VGND sg13cmos5l_decap_8
XFILLER_10_565 VPWR VGND sg13cmos5l_fill_2
X_3316__124 _3316_/D VPWR VGND sg13cmos5l_tielo
XFILLER_6_547 VPWR VGND sg13cmos5l_decap_8
XFILLER_2_742 VPWR VGND sg13cmos5l_decap_8
XFILLER_29_1028 VPWR VGND sg13cmos5l_fill_1
XFILLER_49_245 VPWR VGND sg13cmos5l_decap_8
XFILLER_38_908 VPWR VGND sg13cmos5l_decap_8
XFILLER_2_36 VPWR VGND sg13cmos5l_decap_8
XFILLER_49_267 VPWR VGND sg13cmos5l_fill_1
XFILLER_18_610 VPWR VGND sg13cmos5l_fill_2
XFILLER_46_941 VPWR VGND sg13cmos5l_decap_8
XFILLER_17_120 VPWR VGND sg13cmos5l_decap_8
XFILLER_32_145 VPWR VGND sg13cmos5l_fill_2
XFILLER_33_679 VPWR VGND sg13cmos5l_fill_2
XFILLER_20_318 VPWR VGND sg13cmos5l_decap_8
XFILLER_9_341 VPWR VGND sg13cmos5l_decap_4
XFILLER_13_392 VPWR VGND sg13cmos5l_decap_8
X_2622_ _2622_/Y _2520_/B _2651_/A _2621_/Y VPWR VGND sg13cmos5l_o21ai_1
X_2553_ _2618_/D _2550_/A _2550_/B _2551_/Y VPWR VGND sg13cmos5l_o21ai_1
XFILLER_5_591 VPWR VGND sg13cmos5l_decap_8
X_2484_ _2498_/B _3414_/Q _3415_/Q _3416_/Q VPWR VGND sg13cmos5l_o21ai_1
X_3105_ _3105_/Y _3089_/A _3110_/S _3104_/Y VPWR VGND sg13cmos5l_a21oi_1
XFILLER_37_930 VPWR VGND sg13cmos5l_decap_8
X_3036_ _3036_/X _3510_/Q _3511_/Q VPWR VGND sg13cmos5l_xor2_1
XFILLER_12_819 VPWR VGND sg13cmos5l_decap_4
XFILLER_23_123 VPWR VGND sg13cmos5l_fill_2
XFILLER_20_830 VPWR VGND sg13cmos5l_decap_8
XFILLER_20_885 VPWR VGND sg13cmos5l_decap_4
XFILLER_11_78 VPWR VGND sg13cmos5l_decap_8
XFILLER_47_738 VPWR VGND sg13cmos5l_decap_8
XFILLER_46_215 VPWR VGND sg13cmos5l_decap_8
XFILLER_4_1008 VPWR VGND sg13cmos5l_decap_8
XFILLER_19_418 VPWR VGND sg13cmos5l_decap_8
XFILLER_19_429 VPWR VGND sg13cmos5l_decap_8
XFILLER_46_248 VPWR VGND sg13cmos5l_fill_1
XFILLER_46_226 VPWR VGND sg13cmos5l_fill_2
X_3465__190 _3465_/RESET_B VPWR VGND sg13cmos5l_tiehi
XFILLER_28_941 VPWR VGND sg13cmos5l_decap_8
XFILLER_27_451 VPWR VGND sg13cmos5l_decap_8
XFILLER_43_944 VPWR VGND sg13cmos5l_decap_8
XFILLER_27_495 VPWR VGND sg13cmos5l_decap_8
XFILLER_35_1021 VPWR VGND sg13cmos5l_decap_8
XFILLER_7_801 VPWR VGND sg13cmos5l_decap_8
XFILLER_11_852 VPWR VGND sg13cmos5l_decap_8
XFILLER_10_384 VPWR VGND sg13cmos5l_decap_8
X_3472__183 _3472_/RESET_B VPWR VGND sg13cmos5l_tiehi
XFILLER_7_878 VPWR VGND sg13cmos5l_decap_8
XFILLER_38_705 VPWR VGND sg13cmos5l_decap_8
XFILLER_37_226 VPWR VGND sg13cmos5l_decap_4
XFILLER_46_793 VPWR VGND sg13cmos5l_decap_8
XFILLER_34_955 VPWR VGND sg13cmos5l_decap_8
XFILLER_20_104 VPWR VGND sg13cmos5l_decap_8
XFILLER_21_638 VPWR VGND sg13cmos5l_decap_8
X_1984_ _1984_/Y _1945_/A _1953_/B _3027_/A VPWR VGND sg13cmos5l_a21oi_1
X_2605_ _2605_/Y _1808_/Y _2963_/A2 _2604_/Y VPWR VGND sg13cmos5l_a21oi_1
X_2536_ _2544_/B _3390_/Q _3391_/Q _3389_/Q _3388_/Q VPWR VGND sg13cmos5l_nor4_1
X_2467_ _2467_/Y _2456_/Y _2475_/A _2463_/Y _2466_/A VPWR VGND sg13cmos5l_a22oi_1
XFILLER_29_738 VPWR VGND sg13cmos5l_decap_8
X_2398_ _2412_/A _2399_/C _2397_/Y _2396_/Y VPWR VGND sg13cmos5l_a21oi_1
XFILLER_44_719 VPWR VGND sg13cmos5l_decap_8
X_3019_ _3019_/Y _2980_/X _3017_/Y _2968_/B VPWR VGND sg13cmos5l_a21oi_1
XFILLER_25_944 VPWR VGND sg13cmos5l_decap_8
X_3503__382 _3503_/RESET_B VPWR VGND sg13cmos5l_tiehi
XFILLER_24_432 VPWR VGND sg13cmos5l_decap_8
XFILLER_36_281 VPWR VGND sg13cmos5l_decap_8
XFILLER_24_476 VPWR VGND sg13cmos5l_fill_1
XFILLER_40_958 VPWR VGND sg13cmos5l_decap_8
XFILLER_4_826 VPWR VGND sg13cmos5l_decap_8
XFILLER_3_347 VPWR VGND sg13cmos5l_decap_8
XFILLER_19_237 VPWR VGND sg13cmos5l_decap_8
XFILLER_34_218 VPWR VGND sg13cmos5l_decap_8
XFILLER_34_229 VPWR VGND sg13cmos5l_fill_1
XFILLER_15_443 VPWR VGND sg13cmos5l_decap_8
XFILLER_16_988 VPWR VGND sg13cmos5l_decap_8
XFILLER_30_402 VPWR VGND sg13cmos5l_decap_8
XFILLER_15_498 VPWR VGND sg13cmos5l_fill_1
XFILLER_7_675 VPWR VGND sg13cmos5l_decap_4
XFILLER_6_141 VPWR VGND sg13cmos5l_decap_8
Xhold609 hold609/X _2774_/Y VPWR VGND sg13cmos5l_dlygate4sd3_1
XFILLER_6_185 VPWR VGND sg13cmos5l_decap_8
X_3370_ _3370_/Q _3463_/CLK _3370_/D _3370_/RESET_B VPWR VGND sg13cmos5l_dfrbpq_1
X_2321_ _2324_/C _3383_/Q _3384_/Q _3385_/Q VPWR VGND sg13cmos5l_o21ai_1
XFILLER_3_870 VPWR VGND sg13cmos5l_decap_8
X_2252_ _3368_/D _2776_/A _2252_/B VPWR VGND sg13cmos5l_and2_1
X_2183_ _2183_/Y _2359_/A _3381_/Q VPWR VGND sg13cmos5l_xnor2_1
XFILLER_38_557 VPWR VGND sg13cmos5l_decap_8
XFILLER_34_730 VPWR VGND sg13cmos5l_fill_2
XFILLER_22_925 VPWR VGND sg13cmos5l_decap_4
X_1967_ _1967_/Y _1962_/A _1970_/B _1966_/X VPWR VGND sg13cmos5l_o21ai_1
X_1898_ _1898_/Y _1883_/B _3228_/A hold686/X VPWR VGND sg13cmos5l_o21ai_1
XFILLER_49_1009 VPWR VGND sg13cmos5l_decap_8
X_2519_ _2520_/B _2518_/X _2485_/Y _2519_/S VPWR VGND sg13cmos5l_mux2_1
X_3499_ _3499_/Q clkload3/A _3499_/D _3499_/RESET_B VPWR VGND sg13cmos5l_dfrbpq_1
XFILLER_29_568 VPWR VGND sg13cmos5l_decap_8
XFILLER_9_907 VPWR VGND sg13cmos5l_decap_8
XFILLER_13_947 VPWR VGND sg13cmos5l_decap_8
XFILLER_24_284 VPWR VGND sg13cmos5l_decap_8
XFILLER_33_43 VPWR VGND sg13cmos5l_decap_8
XFILLER_32_1013 VPWR VGND sg13cmos5l_decap_8
XFILLER_33_98 VPWR VGND sg13cmos5l_decap_8
XFILLER_3_111 VPWR VGND sg13cmos5l_decap_8
XFILLER_3_155 VPWR VGND sg13cmos5l_fill_1
XFILLER_0_840 VPWR VGND sg13cmos5l_decap_8
XFILLER_47_321 VPWR VGND sg13cmos5l_decap_4
XFILLER_48_866 VPWR VGND sg13cmos5l_decap_8
XFILLER_47_354 VPWR VGND sg13cmos5l_decap_4
XFILLER_35_505 VPWR VGND sg13cmos5l_fill_2
XFILLER_35_527 VPWR VGND sg13cmos5l_decap_8
XFILLER_16_741 VPWR VGND sg13cmos5l_decap_4
X_2870_ _2882_/B _2870_/A _2870_/B VPWR VGND sg13cmos5l_xnor2_1
XFILLER_15_295 VPWR VGND sg13cmos5l_fill_1
XFILLER_30_221 VPWR VGND sg13cmos5l_fill_1
X_1821_ _2430_/A _2359_/A VPWR VGND sg13cmos5l_inv_1
Xclkbuf_leaf_10_clk _3408_/CLK clkload1/A VPWR VGND sg13cmos5l_buf_8
XFILLER_8_995 VPWR VGND sg13cmos5l_decap_8
XFILLER_48_1020 VPWR VGND sg13cmos5l_decap_8
Xhold439 _3349_/D _2114_/X VPWR VGND sg13cmos5l_dlygate4sd3_1
X_3422_ _3422_/Q _3472_/CLK _3422_/D _3422_/RESET_B VPWR VGND sg13cmos5l_dfrbpq_1
Xhold428 _2018_/B _1870_/B VPWR VGND sg13cmos5l_dlygate4sd3_1
X_3353_ _3353_/Q _3378_/CLK _3353_/D _3353_/RESET_B VPWR VGND sg13cmos5l_dfrbpq_1
X_2304_ _2308_/S _2304_/A _2304_/B _2304_/C VPWR VGND sg13cmos5l_nor3_1
X_3284_ _3284_/Q clkload7/A _3284_/D _3284_/RESET_B VPWR VGND sg13cmos5l_dfrbpq_1
X_2235_ _2235_/Y _3341_/Q _2235_/B VPWR VGND sg13cmos5l_nor2_1
XFILLER_39_822 VPWR VGND sg13cmos5l_decap_8
X_2166_ _2166_/Y _2166_/A _2166_/B VPWR VGND sg13cmos5l_nor2_1
X_2097_ _2097_/X _3330_/Q _2097_/B VPWR VGND sg13cmos5l_xor2_1
XFILLER_0_1022 VPWR VGND sg13cmos5l_decap_8
XFILLER_41_508 VPWR VGND sg13cmos5l_decap_8
XFILLER_22_711 VPWR VGND sg13cmos5l_fill_1
X_2999_ _2999_/X _2912_/B _2974_/A _3005_/B VPWR VGND sg13cmos5l_mux2_1
XFILLER_1_626 VPWR VGND sg13cmos5l_decap_8
XFILLER_0_136 VPWR VGND sg13cmos5l_decap_8
XFILLER_49_619 VPWR VGND sg13cmos5l_decap_4
XFILLER_0_169 VPWR VGND sg13cmos5l_decap_8
XFILLER_48_129 VPWR VGND sg13cmos5l_fill_2
XFILLER_28_43 VPWR VGND sg13cmos5l_decap_8
XFILLER_45_858 VPWR VGND sg13cmos5l_decap_8
XFILLER_44_324 VPWR VGND sg13cmos5l_decap_4
XFILLER_44_75 VPWR VGND sg13cmos5l_fill_2
X_3401__261 _3401_/RESET_B VPWR VGND sg13cmos5l_tiehi
XFILLER_12_287 VPWR VGND sg13cmos5l_decap_8
XFILLER_5_910 VPWR VGND sg13cmos5l_decap_8
XFILLER_4_442 VPWR VGND sg13cmos5l_decap_8
XFILLER_5_987 VPWR VGND sg13cmos5l_decap_8
XFILLER_4_475 VPWR VGND sg13cmos5l_decap_8
XFILLER_39_118 VPWR VGND sg13cmos5l_decap_8
X_2020_ _2020_/Y _2162_/A _2147_/A VPWR VGND sg13cmos5l_nor2b_1
XFILLER_10_6 VPWR VGND sg13cmos5l_fill_1
XFILLER_35_313 VPWR VGND sg13cmos5l_decap_8
XFILLER_23_519 VPWR VGND sg13cmos5l_fill_2
XFILLER_35_368 VPWR VGND sg13cmos5l_decap_4
X_2922_ _2922_/Y _3507_/Q _2922_/B VPWR VGND sg13cmos5l_nand2_1
XFILLER_16_571 VPWR VGND sg13cmos5l_decap_8
XFILLER_31_530 VPWR VGND sg13cmos5l_decap_4
X_2853_ _2853_/Y _3479_/Q _3478_/Q VPWR VGND sg13cmos5l_xnor2_1
X_1804_ _2951_/B _3490_/Q VPWR VGND sg13cmos5l_inv_1
X_2784_ _3466_/D _2784_/A _2784_/B VPWR VGND sg13cmos5l_and2_1
X_3405_ _3405_/Q _3408_/CLK _3405_/D _3405_/RESET_B VPWR VGND sg13cmos5l_dfrbpq_1
X_3336_ _3336_/Q _3355_/CLK _3336_/D _3336_/RESET_B VPWR VGND sg13cmos5l_dfrbpq_1
XFILLER_22_1023 VPWR VGND sg13cmos5l_decap_4
X_3267_ _3267_/Q clkload7/A _3267_/D _3267_/RESET_B VPWR VGND sg13cmos5l_dfrbpq_1
X_2218_ _2218_/Y _2215_/Y _2216_/Y _2217_/Y VPWR VGND sg13cmos5l_o21ai_1
X_3198_ _3199_/B _3209_/A _3143_/X _3202_/S _3062_/B _3196_/Y VPWR VGND sg13cmos5l_a221oi_1
XFILLER_27_825 VPWR VGND sg13cmos5l_decap_8
X_2149_ _2149_/Y _3343_/Q _3324_/Q VPWR VGND sg13cmos5l_xnor2_1
XFILLER_22_552 VPWR VGND sg13cmos5l_decap_8
XFILLER_10_747 VPWR VGND sg13cmos5l_decap_4
XFILLER_2_924 VPWR VGND sg13cmos5l_decap_8
XFILLER_39_31 VPWR VGND sg13cmos5l_decap_8
XFILLER_49_438 VPWR VGND sg13cmos5l_decap_8
XFILLER_18_825 VPWR VGND sg13cmos5l_decap_8
XFILLER_45_644 VPWR VGND sg13cmos5l_fill_1
XFILLER_32_305 VPWR VGND sg13cmos5l_fill_2
XFILLER_33_817 VPWR VGND sg13cmos5l_decap_8
XFILLER_26_880 VPWR VGND sg13cmos5l_fill_1
XFILLER_32_316 VPWR VGND sg13cmos5l_decap_8
XFILLER_41_850 VPWR VGND sg13cmos5l_decap_8
XFILLER_9_501 VPWR VGND sg13cmos5l_fill_2
XFILLER_13_530 VPWR VGND sg13cmos5l_decap_8
XFILLER_25_390 VPWR VGND sg13cmos5l_decap_8
XFILLER_9_523 VPWR VGND sg13cmos5l_decap_4
XFILLER_5_784 VPWR VGND sg13cmos5l_decap_8
XFILLER_4_294 VPWR VGND sg13cmos5l_decap_8
XFILLER_4_272 VPWR VGND sg13cmos5l_fill_1
XFILLER_45_1012 VPWR VGND sg13cmos5l_decap_8
X_3121_ _3526_/D _3121_/A _3121_/B VPWR VGND sg13cmos5l_and2_1
X_3052_ _3052_/Y _3056_/A _3056_/B VPWR VGND sg13cmos5l_nor2_1
X_2003_ _2004_/B _3320_/Q _3368_/Q _3342_/Q _3429_/Q VPWR VGND sg13cmos5l_nor4_1
XFILLER_36_699 VPWR VGND sg13cmos5l_decap_8
XFILLER_23_338 VPWR VGND sg13cmos5l_decap_8
XFILLER_23_349 VPWR VGND sg13cmos5l_fill_2
X_2905_ _2907_/A _2905_/A _2916_/A _2913_/C VPWR VGND sg13cmos5l_nor3_1
XFILLER_32_872 VPWR VGND sg13cmos5l_fill_2
XFILLER_32_883 VPWR VGND sg13cmos5l_decap_4
X_2836_ _2844_/S _2813_/A _2810_/Y _2827_/Y _2834_/Y _2835_/Y VPWR VGND sg13cmos5l_a221oi_1
X_2767_ _2767_/Y _2766_/Y _2767_/B VPWR VGND sg13cmos5l_nand2b_1
X_2698_ _2698_/X hold703/X _2697_/Y _2701_/S VPWR VGND sg13cmos5l_mux2_1
X_3319_ _3319_/Q _3355_/CLK _3319_/D _3319_/RESET_B VPWR VGND sg13cmos5l_dfrbpq_1
XFILLER_27_644 VPWR VGND sg13cmos5l_decap_8
XFILLER_42_625 VPWR VGND sg13cmos5l_fill_2
XFILLER_41_102 VPWR VGND sg13cmos5l_fill_2
X_3322__354 _3322_/RESET_B VPWR VGND sg13cmos5l_tiehi
XFILLER_41_157 VPWR VGND sg13cmos5l_decap_8
XFILLER_23_861 VPWR VGND sg13cmos5l_decap_8
XFILLER_41_168 VPWR VGND sg13cmos5l_fill_2
XFILLER_10_500 VPWR VGND sg13cmos5l_fill_1
XFILLER_10_522 VPWR VGND sg13cmos5l_fill_2
XFILLER_10_544 VPWR VGND sg13cmos5l_fill_1
XFILLER_41_98 VPWR VGND sg13cmos5l_decap_4
XFILLER_41_76 VPWR VGND sg13cmos5l_decap_4
XFILLER_2_721 VPWR VGND sg13cmos5l_decap_8
XFILLER_29_1007 VPWR VGND sg13cmos5l_decap_8
XFILLER_49_224 VPWR VGND sg13cmos5l_decap_8
XFILLER_49_202 VPWR VGND sg13cmos5l_decap_8
XFILLER_2_798 VPWR VGND sg13cmos5l_decap_8
XFILLER_46_920 VPWR VGND sg13cmos5l_decap_8
XFILLER_45_463 VPWR VGND sg13cmos5l_decap_4
XFILLER_18_655 VPWR VGND sg13cmos5l_fill_1
XFILLER_46_997 VPWR VGND sg13cmos5l_decap_8
XFILLER_17_198 VPWR VGND sg13cmos5l_decap_8
XFILLER_32_124 VPWR VGND sg13cmos5l_decap_8
XFILLER_33_658 VPWR VGND sg13cmos5l_decap_8
XFILLER_9_320 VPWR VGND sg13cmos5l_decap_8
XFILLER_13_371 VPWR VGND sg13cmos5l_decap_8
XFILLER_9_397 VPWR VGND sg13cmos5l_fill_2
X_2621_ _2621_/Y _2621_/A _2655_/B VPWR VGND sg13cmos5l_nand2_1
X_2552_ _2618_/C _2552_/A _2557_/B _2557_/C VPWR VGND sg13cmos5l_nand3_1
X_2483_ _2498_/A _3416_/Q _3414_/Q _3415_/Q VPWR VGND sg13cmos5l_or3_1
XFILLER_29_909 VPWR VGND sg13cmos5l_decap_8
X_3104_ _3104_/Y _3089_/B _3110_/S _3121_/B VPWR VGND sg13cmos5l_o21ai_1
X_3035_ _3038_/B _3063_/A _3035_/B VPWR VGND sg13cmos5l_nand2_1
XFILLER_37_986 VPWR VGND sg13cmos5l_decap_8
XFILLER_36_452 VPWR VGND sg13cmos5l_decap_8
XFILLER_36_463 VPWR VGND sg13cmos5l_fill_2
XFILLER_23_179 VPWR VGND sg13cmos5l_fill_2
XFILLER_32_691 VPWR VGND sg13cmos5l_decap_8
XFILLER_20_864 VPWR VGND sg13cmos5l_fill_2
X_2819_ _2819_/Y _2819_/A _2819_/B VPWR VGND sg13cmos5l_nor2_1
XFILLER_3_518 VPWR VGND sg13cmos5l_decap_8
XFILLER_3_507 VPWR VGND sg13cmos5l_fill_2
XFILLER_11_35 VPWR VGND sg13cmos5l_fill_2
XFILLER_2_8 VPWR VGND sg13cmos5l_fill_1
XFILLER_28_920 VPWR VGND sg13cmos5l_decap_8
XFILLER_36_32 VPWR VGND sg13cmos5l_decap_4
XFILLER_43_923 VPWR VGND sg13cmos5l_decap_8
XFILLER_42_400 VPWR VGND sg13cmos5l_decap_8
XFILLER_28_997 VPWR VGND sg13cmos5l_decap_8
XFILLER_35_1000 VPWR VGND sg13cmos5l_decap_8
XFILLER_11_831 VPWR VGND sg13cmos5l_fill_2
XFILLER_23_680 VPWR VGND sg13cmos5l_fill_2
XFILLER_10_341 VPWR VGND sg13cmos5l_decap_8
XFILLER_7_857 VPWR VGND sg13cmos5l_decap_8
XFILLER_6_356 VPWR VGND sg13cmos5l_decap_8
XFILLER_6_389 VPWR VGND sg13cmos5l_fill_1
XFILLER_2_551 VPWR VGND sg13cmos5l_fill_2
XFILLER_42_1015 VPWR VGND sg13cmos5l_decap_8
XFILLER_37_205 VPWR VGND sg13cmos5l_decap_8
XFILLER_46_772 VPWR VGND sg13cmos5l_decap_8
XFILLER_18_474 VPWR VGND sg13cmos5l_decap_8
XFILLER_18_485 VPWR VGND sg13cmos5l_decap_8
XFILLER_19_997 VPWR VGND sg13cmos5l_decap_8
XFILLER_33_422 VPWR VGND sg13cmos5l_decap_8
XFILLER_33_433 VPWR VGND sg13cmos5l_fill_1
XFILLER_21_606 VPWR VGND sg13cmos5l_fill_1
XFILLER_33_488 VPWR VGND sg13cmos5l_fill_2
X_1983_ _1983_/Y _3112_/A _1983_/A2 _1982_/Y VPWR VGND sg13cmos5l_a21oi_1
X_2604_ _2604_/Y _3400_/Q _2963_/A2 _2427_/A VPWR VGND sg13cmos5l_o21ai_1
X_2535_ _2535_/Y _2535_/A _2535_/B _2535_/C VPWR VGND sg13cmos5l_nand3_1
X_2466_ _2466_/Y _2466_/A VPWR VGND sg13cmos5l_inv_1
X_2397_ _2397_/Y _2612_/A _3413_/Q VPWR VGND sg13cmos5l_nor2_1
XFILLER_28_249 VPWR VGND sg13cmos5l_decap_8
XFILLER_37_783 VPWR VGND sg13cmos5l_fill_2
XFILLER_37_772 VPWR VGND sg13cmos5l_fill_1
X_3018_ _3020_/A _3003_/A _3001_/Y _3017_/Y VPWR VGND sg13cmos5l_a21oi_1
XFILLER_36_260 VPWR VGND sg13cmos5l_fill_2
XFILLER_40_937 VPWR VGND sg13cmos5l_decap_8
XFILLER_22_67 VPWR VGND sg13cmos5l_decap_8
XFILLER_4_805 VPWR VGND sg13cmos5l_decap_8
XFILLER_3_326 VPWR VGND sg13cmos5l_decap_8
XFILLER_3_337 VPWR VGND sg13cmos5l_fill_1
XFILLER_47_31 VPWR VGND sg13cmos5l_decap_4
XFILLER_47_20 VPWR VGND sg13cmos5l_fill_2
XFILLER_47_547 VPWR VGND sg13cmos5l_decap_8
XFILLER_28_772 VPWR VGND sg13cmos5l_fill_1
XFILLER_15_422 VPWR VGND sg13cmos5l_decap_4
XFILLER_16_967 VPWR VGND sg13cmos5l_decap_8
XFILLER_27_282 VPWR VGND sg13cmos5l_decap_8
XFILLER_43_764 VPWR VGND sg13cmos5l_fill_2
XFILLER_42_263 VPWR VGND sg13cmos5l_decap_8
XFILLER_31_959 VPWR VGND sg13cmos5l_decap_8
XFILLER_8_36 VPWR VGND sg13cmos5l_fill_2
XFILLER_8_69 VPWR VGND sg13cmos5l_decap_8
XFILLER_11_672 VPWR VGND sg13cmos5l_fill_2
XFILLER_7_665 VPWR VGND sg13cmos5l_fill_2
XFILLER_6_153 VPWR VGND sg13cmos5l_decap_4
XFILLER_6_120 VPWR VGND sg13cmos5l_fill_1
X_3550__134 _3550_/RESET_B VPWR VGND sg13cmos5l_tiehi
XFILLER_7_698 VPWR VGND sg13cmos5l_decap_8
XFILLER_6_164 VPWR VGND sg13cmos5l_decap_8
X_2320_ _2529_/A _3411_/Q _3410_/Q VPWR VGND sg13cmos5l_xnor2_1
XFILLER_2_370 VPWR VGND sg13cmos5l_decap_8
XFILLER_2_381 VPWR VGND sg13cmos5l_fill_2
X_2251_ _2251_/Y _2241_/Y hold638/X _2309_/A VPWR VGND sg13cmos5l_a21oi_1
XFILLER_26_4 VPWR VGND sg13cmos5l_decap_4
X_2182_ _2373_/C _2359_/A _3381_/Q VPWR VGND sg13cmos5l_nor2_1
XFILLER_38_514 VPWR VGND sg13cmos5l_decap_4
XFILLER_18_293 VPWR VGND sg13cmos5l_decap_8
XFILLER_22_904 VPWR VGND sg13cmos5l_decap_8
XFILLER_34_797 VPWR VGND sg13cmos5l_fill_1
X_1966_ _1966_/X _1966_/A _3299_/Q VPWR VGND sg13cmos5l_xor2_1
X_1897_ _1897_/Y _1988_/B _1986_/A _1987_/B VPWR VGND sg13cmos5l_a21oi_1
XFILLER_0_307 VPWR VGND sg13cmos5l_decap_8
X_2518_ _2518_/X _2518_/A _2521_/B VPWR VGND sg13cmos5l_and2_1
X_3498_ _3498_/Q _3527_/CLK _3498_/D _3498_/RESET_B VPWR VGND sg13cmos5l_dfrbpq_1
X_2449_ _2449_/Y _2468_/B _2468_/C VPWR VGND sg13cmos5l_nand2_1
XFILLER_25_1021 VPWR VGND sg13cmos5l_decap_8
XFILLER_44_506 VPWR VGND sg13cmos5l_decap_4
XFILLER_13_926 VPWR VGND sg13cmos5l_decap_8
XFILLER_24_263 VPWR VGND sg13cmos5l_decap_8
XFILLER_12_414 VPWR VGND sg13cmos5l_fill_2
XFILLER_33_22 VPWR VGND sg13cmos5l_decap_8
X_3319__359 _3319_/RESET_B VPWR VGND sg13cmos5l_tiehi
XFILLER_48_845 VPWR VGND sg13cmos5l_decap_8
XFILLER_47_300 VPWR VGND sg13cmos5l_decap_8
XFILLER_0_896 VPWR VGND sg13cmos5l_decap_8
XFILLER_47_333 VPWR VGND sg13cmos5l_decap_8
XFILLER_47_388 VPWR VGND sg13cmos5l_fill_1
XFILLER_47_377 VPWR VGND sg13cmos5l_decap_8
XFILLER_15_230 VPWR VGND sg13cmos5l_fill_1
XFILLER_16_786 VPWR VGND sg13cmos5l_fill_2
XFILLER_15_263 VPWR VGND sg13cmos5l_decap_4
XFILLER_30_200 VPWR VGND sg13cmos5l_fill_1
X_1820_ _1951_/B input4/X VPWR VGND sg13cmos5l_inv_1
XFILLER_12_992 VPWR VGND sg13cmos5l_decap_8
XFILLER_30_288 VPWR VGND sg13cmos5l_fill_1
XFILLER_31_789 VPWR VGND sg13cmos5l_fill_2
XFILLER_8_974 VPWR VGND sg13cmos5l_decap_8
XFILLER_7_451 VPWR VGND sg13cmos5l_decap_8
XFILLER_7_462 VPWR VGND sg13cmos5l_fill_1
X_3421_ _3421_/Q _3453_/CLK _3421_/D _3421_/RESET_B VPWR VGND sg13cmos5l_dfrbpq_1
Xhold429 hold429/X _1962_/A VPWR VGND sg13cmos5l_dlygate4sd3_1
X_3352_ _3352_/Q _3378_/CLK _3352_/D _3352_/RESET_B VPWR VGND sg13cmos5l_dfrbpq_1
X_2303_ _2304_/C _2303_/A _2303_/B VPWR VGND sg13cmos5l_nor2_1
X_3283_ _3283_/Q clkload9/A _3283_/D _3283_/RESET_B VPWR VGND sg13cmos5l_dfrbpq_1
X_2234_ _2234_/Y _2432_/A _3341_/Q _2232_/Y VPWR VGND sg13cmos5l_o21ai_1
XFILLER_39_856 VPWR VGND sg13cmos5l_fill_1
XFILLER_17_0 VPWR VGND sg13cmos5l_fill_2
X_2165_ _2166_/B _2165_/A _2165_/B VPWR VGND sg13cmos5l_xnor2_1
XFILLER_0_1001 VPWR VGND sg13cmos5l_decap_8
X_3526__191 _3526_/RESET_B VPWR VGND sg13cmos5l_tiehi
X_2096_ _2096_/Y _3352_/Q _3330_/Q VPWR VGND sg13cmos5l_nand2_1
XFILLER_19_580 VPWR VGND sg13cmos5l_fill_1
XFILLER_0_92 VPWR VGND sg13cmos5l_decap_8
XFILLER_16_1009 VPWR VGND sg13cmos5l_decap_8
XFILLER_21_233 VPWR VGND sg13cmos5l_decap_8
X_2998_ _2998_/Y _3007_/B VPWR VGND sg13cmos5l_inv_1
X_1949_ _1949_/Y _1951_/B _3294_/Q _1943_/Y hold573/X VPWR VGND sg13cmos5l_a22oi_1
XFILLER_29_300 VPWR VGND sg13cmos5l_decap_4
XFILLER_28_33 VPWR VGND sg13cmos5l_fill_1
XFILLER_17_517 VPWR VGND sg13cmos5l_fill_1
XFILLER_28_99 VPWR VGND sg13cmos5l_decap_8
XFILLER_44_87 VPWR VGND sg13cmos5l_fill_2
XFILLER_13_712 VPWR VGND sg13cmos5l_fill_2
XFILLER_25_583 VPWR VGND sg13cmos5l_decap_8
X_3278__137 _3278_/RESET_B VPWR VGND sg13cmos5l_tiehi
XFILLER_9_705 VPWR VGND sg13cmos5l_decap_8
XFILLER_12_266 VPWR VGND sg13cmos5l_decap_8
X_3319__123 _3319_/D VPWR VGND sg13cmos5l_tielo
XFILLER_5_966 VPWR VGND sg13cmos5l_decap_8
XFILLER_4_421 VPWR VGND sg13cmos5l_decap_8
XFILLER_4_410 VPWR VGND sg13cmos5l_decap_4
XFILLER_4_498 VPWR VGND sg13cmos5l_fill_2
XFILLER_0_693 VPWR VGND sg13cmos5l_decap_8
X_2921_ _2921_/Y _3123_/A _3458_/Q _3457_/Q _3122_/A _2920_/Y VPWR VGND sg13cmos5l_a221oi_1
XFILLER_43_391 VPWR VGND sg13cmos5l_decap_8
X_2852_ _2852_/X _2863_/B _2858_/C _2879_/A VPWR VGND sg13cmos5l_a21o_1
X_1803_ _3089_/A _1803_/A VPWR VGND sg13cmos5l_inv_1
X_2783_ _3465_/D _2966_/A _2783_/B VPWR VGND sg13cmos5l_and2_1
XFILLER_8_782 VPWR VGND sg13cmos5l_decap_8
X_3404_ _3404_/Q _3463_/CLK _3404_/D _3404_/RESET_B VPWR VGND sg13cmos5l_dfrbpq_1
X_3335_ _3335_/Q _3355_/CLK _3335_/D _3335_/RESET_B VPWR VGND sg13cmos5l_dfrbpq_1
X_3266_ _3266_/Q clkload9/A _3266_/D _3266_/RESET_B VPWR VGND sg13cmos5l_dfrbpq_1
X_2217_ _2217_/Y _2217_/A _2221_/A VPWR VGND sg13cmos5l_nor2_1
XFILLER_22_1002 VPWR VGND sg13cmos5l_decap_8
XFILLER_38_152 VPWR VGND sg13cmos5l_decap_8
X_3197_ _3197_/X _3062_/B _3202_/S _3196_/Y VPWR VGND sg13cmos5l_a21o_1
XFILLER_26_303 VPWR VGND sg13cmos5l_decap_8
XFILLER_27_815 VPWR VGND sg13cmos5l_decap_4
X_2148_ _2164_/A _2155_/A _2155_/B VPWR VGND sg13cmos5l_nand2_1
X_2079_ _3326_/D _2081_/B VPWR VGND sg13cmos5l_inv_1
XFILLER_41_339 VPWR VGND sg13cmos5l_fill_1
XFILLER_10_704 VPWR VGND sg13cmos5l_decap_8
XFILLER_5_229 VPWR VGND sg13cmos5l_decap_4
XFILLER_2_903 VPWR VGND sg13cmos5l_decap_8
XFILLER_30_67 VPWR VGND sg13cmos5l_fill_2
XFILLER_30_78 VPWR VGND sg13cmos5l_decap_8
XFILLER_30_89 VPWR VGND sg13cmos5l_fill_2
XFILLER_39_21 VPWR VGND sg13cmos5l_fill_1
XFILLER_1_446 VPWR VGND sg13cmos5l_fill_1
XFILLER_49_417 VPWR VGND sg13cmos5l_decap_8
XFILLER_39_65 VPWR VGND sg13cmos5l_decap_8
XFILLER_7_1018 VPWR VGND sg13cmos5l_decap_8
XFILLER_18_804 VPWR VGND sg13cmos5l_decap_8
XFILLER_18_815 VPWR VGND sg13cmos5l_fill_1
XFILLER_29_196 VPWR VGND sg13cmos5l_decap_8
XFILLER_45_689 VPWR VGND sg13cmos5l_decap_8
XFILLER_38_1020 VPWR VGND sg13cmos5l_decap_8
XFILLER_13_542 VPWR VGND sg13cmos5l_fill_2
XFILLER_41_884 VPWR VGND sg13cmos5l_decap_8
XFILLER_40_372 VPWR VGND sg13cmos5l_decap_8
XFILLER_13_575 VPWR VGND sg13cmos5l_decap_8
XFILLER_40_383 VPWR VGND sg13cmos5l_fill_2
XFILLER_9_546 VPWR VGND sg13cmos5l_decap_8
XFILLER_5_741 VPWR VGND sg13cmos5l_fill_1
XFILLER_5_730 VPWR VGND sg13cmos5l_decap_8
X_3120_ _3120_/Y _1795_/Y _3120_/A2 _3119_/Y VPWR VGND sg13cmos5l_a21oi_1
XFILLER_1_991 VPWR VGND sg13cmos5l_decap_8
XFILLER_49_995 VPWR VGND sg13cmos5l_decap_8
XFILLER_48_461 VPWR VGND sg13cmos5l_decap_8
X_3051_ _3056_/B _3514_/Q _3051_/B VPWR VGND sg13cmos5l_xor2_1
X_2002_ _2004_/A _3398_/Q _3493_/Q _3461_/Q VPWR VGND sg13cmos5l_nor3_1
XFILLER_36_678 VPWR VGND sg13cmos5l_decap_8
XFILLER_24_829 VPWR VGND sg13cmos5l_decap_8
XFILLER_35_166 VPWR VGND sg13cmos5l_fill_2
X_2904_ _2904_/Y _2904_/A _2904_/B VPWR VGND sg13cmos5l_nand2_1
X_2835_ _2835_/Y _2835_/A _2835_/B VPWR VGND sg13cmos5l_nor2_1
X_2766_ _2766_/Y _2774_/B _2763_/Y _2930_/A VPWR VGND sg13cmos5l_o21ai_1
X_2697_ _2697_/Y _3473_/Q _2708_/B VPWR VGND sg13cmos5l_nand2_1
X_3318_ _3318_/Q _3355_/CLK _3318_/D _3318_/RESET_B VPWR VGND sg13cmos5l_dfrbpq_1
X_3268__147 _3268_/RESET_B VPWR VGND sg13cmos5l_tiehi
X_3249_ _3540_/D _3245_/Y _3248_/Y _3253_/A VPWR VGND sg13cmos5l_a21oi_1
XFILLER_39_494 VPWR VGND sg13cmos5l_fill_1
XFILLER_26_122 VPWR VGND sg13cmos5l_decap_4
XFILLER_26_155 VPWR VGND sg13cmos5l_decap_4
XFILLER_27_667 VPWR VGND sg13cmos5l_decap_8
XFILLER_41_114 VPWR VGND sg13cmos5l_fill_2
XFILLER_26_166 VPWR VGND sg13cmos5l_decap_4
XFILLER_26_177 VPWR VGND sg13cmos5l_decap_8
XFILLER_26_188 VPWR VGND sg13cmos5l_fill_1
XFILLER_14_339 VPWR VGND sg13cmos5l_fill_2
XFILLER_23_840 VPWR VGND sg13cmos5l_decap_8
XFILLER_41_22 VPWR VGND sg13cmos5l_decap_8
X_3459__199 _3459_/RESET_B VPWR VGND sg13cmos5l_tiehi
XFILLER_10_567 VPWR VGND sg13cmos5l_fill_1
XFILLER_2_700 VPWR VGND sg13cmos5l_decap_8
Xhold590 _2262_/A _3352_/Q VPWR VGND sg13cmos5l_dlygate4sd3_1
XFILLER_2_777 VPWR VGND sg13cmos5l_decap_8
XFILLER_1_276 VPWR VGND sg13cmos5l_decap_8
XFILLER_45_420 VPWR VGND sg13cmos5l_decap_4
XFILLER_46_976 VPWR VGND sg13cmos5l_decap_8
XFILLER_45_442 VPWR VGND sg13cmos5l_fill_2
XFILLER_45_497 VPWR VGND sg13cmos5l_fill_1
XFILLER_45_486 VPWR VGND sg13cmos5l_decap_8
XFILLER_33_637 VPWR VGND sg13cmos5l_decap_4
XFILLER_14_873 VPWR VGND sg13cmos5l_decap_8
XFILLER_32_158 VPWR VGND sg13cmos5l_decap_8
XFILLER_41_681 VPWR VGND sg13cmos5l_decap_8
X_2620_ _2620_/Y _2520_/B _2651_/A _2617_/Y _2618_/Y _2619_/Y VPWR VGND sg13cmos5l_a221oi_1
X_2551_ _2551_/Y hold734/X _2556_/B VPWR VGND sg13cmos5l_nand2b_1
X_2482_ _2482_/Y _3429_/Q _2784_/A VPWR VGND sg13cmos5l_nand2b_1
X_3103_ _3110_/S _3103_/A _3103_/B VPWR VGND sg13cmos5l_nor2_1
XFILLER_28_409 VPWR VGND sg13cmos5l_fill_1
XFILLER_49_792 VPWR VGND sg13cmos5l_decap_8
X_3034_ _3035_/B _3531_/Q _3510_/Q VPWR VGND sg13cmos5l_and2_1
XFILLER_37_965 VPWR VGND sg13cmos5l_decap_8
XFILLER_36_442 VPWR VGND sg13cmos5l_decap_4
XFILLER_23_158 VPWR VGND sg13cmos5l_fill_2
XFILLER_20_843 VPWR VGND sg13cmos5l_decap_8
XFILLER_31_180 VPWR VGND sg13cmos5l_decap_4
X_2818_ _2819_/B _2702_/Y _2734_/X _2825_/S VPWR VGND sg13cmos5l_mux2_1
X_2749_ _2749_/Y _3428_/Q _2749_/B VPWR VGND sg13cmos5l_nor2_1
XFILLER_47_707 VPWR VGND sg13cmos5l_decap_8
XFILLER_46_239 VPWR VGND sg13cmos5l_decap_8
XFILLER_43_902 VPWR VGND sg13cmos5l_decap_8
XFILLER_28_976 VPWR VGND sg13cmos5l_decap_8
XFILLER_27_486 VPWR VGND sg13cmos5l_decap_4
XFILLER_36_88 VPWR VGND sg13cmos5l_decap_8
XFILLER_43_979 VPWR VGND sg13cmos5l_decap_8
XFILLER_42_445 VPWR VGND sg13cmos5l_decap_8
XFILLER_42_423 VPWR VGND sg13cmos5l_fill_1
XFILLER_15_659 VPWR VGND sg13cmos5l_decap_8
XFILLER_42_489 VPWR VGND sg13cmos5l_decap_8
XFILLER_22_180 VPWR VGND sg13cmos5l_decap_4
XFILLER_7_836 VPWR VGND sg13cmos5l_decap_8
XFILLER_6_335 VPWR VGND sg13cmos5l_fill_2
XFILLER_10_364 VPWR VGND sg13cmos5l_decap_8
XFILLER_11_887 VPWR VGND sg13cmos5l_decap_8
XFILLER_6_368 VPWR VGND sg13cmos5l_fill_2
XFILLER_10_397 VPWR VGND sg13cmos5l_decap_8
XFILLER_19_943 VPWR VGND sg13cmos5l_fill_1
XFILLER_46_751 VPWR VGND sg13cmos5l_decap_8
XFILLER_19_976 VPWR VGND sg13cmos5l_decap_8
XFILLER_45_272 VPWR VGND sg13cmos5l_decap_4
XFILLER_33_445 VPWR VGND sg13cmos5l_decap_8
X_3305__383 _3305_/RESET_B VPWR VGND sg13cmos5l_tiehi
X_1982_ _1982_/Y _1983_/A2 _3308_/Q _3028_/B VPWR VGND sg13cmos5l_o21ai_1
X_2603_ _2603_/Y _1809_/Y _2958_/A2 _2602_/Y VPWR VGND sg13cmos5l_a21oi_1
X_2534_ _2534_/X _2535_/A _2535_/B _2535_/C VPWR VGND sg13cmos5l_and3_1
XFILLER_47_0 VPWR VGND sg13cmos5l_decap_4
X_2465_ _2466_/A _2468_/B _2465_/B _2465_/C VPWR VGND sg13cmos5l_nand3b_1
X_2396_ _2396_/Y _3367_/Q _2396_/B _2399_/C VPWR VGND sg13cmos5l_nor3_1
XFILLER_3_92 VPWR VGND sg13cmos5l_fill_1
XFILLER_29_707 VPWR VGND sg13cmos5l_decap_8
XFILLER_29_718 VPWR VGND sg13cmos5l_fill_2
XFILLER_3_1010 VPWR VGND sg13cmos5l_decap_8
X_3017_ _3017_/Y _3016_/Y _3017_/B VPWR VGND sg13cmos5l_nand2b_1
XFILLER_19_1018 VPWR VGND sg13cmos5l_decap_8
XFILLER_40_916 VPWR VGND sg13cmos5l_decap_8
XFILLER_24_467 VPWR VGND sg13cmos5l_decap_8
XFILLER_25_979 VPWR VGND sg13cmos5l_decap_8
XFILLER_22_46 VPWR VGND sg13cmos5l_decap_8
XFILLER_47_526 VPWR VGND sg13cmos5l_decap_8
XFILLER_28_751 VPWR VGND sg13cmos5l_decap_4
XFILLER_16_913 VPWR VGND sg13cmos5l_decap_8
XFILLER_16_946 VPWR VGND sg13cmos5l_decap_8
XFILLER_43_798 VPWR VGND sg13cmos5l_fill_1
XFILLER_30_437 VPWR VGND sg13cmos5l_decap_8
XFILLER_8_26 VPWR VGND sg13cmos5l_decap_4
X_2250_ _2250_/Y _3367_/Q _2250_/B VPWR VGND sg13cmos5l_nand2b_1
X_2181_ _2181_/Y _3359_/Q _2185_/A VPWR VGND sg13cmos5l_xnor2_1
XFILLER_19_4 VPWR VGND sg13cmos5l_decap_8
XFILLER_18_272 VPWR VGND sg13cmos5l_decap_8
XFILLER_33_275 VPWR VGND sg13cmos5l_decap_8
XFILLER_33_286 VPWR VGND sg13cmos5l_decap_8
XFILLER_21_459 VPWR VGND sg13cmos5l_decap_8
X_1965_ _1965_/Y _1966_/A _1965_/B VPWR VGND sg13cmos5l_nand2_1
X_1896_ _3550_/D _3548_/D _3545_/D VPWR VGND sg13cmos5l_or2_1
XFILLER_1_809 VPWR VGND sg13cmos5l_decap_8
X_3497_ _3497_/Q clkload3/A _3497_/D _3497_/RESET_B VPWR VGND sg13cmos5l_dfrbpq_1
X_2517_ _3415_/D _2673_/A _2517_/B VPWR VGND sg13cmos5l_nor2_1
X_2448_ _2468_/C _2448_/A _2459_/B VPWR VGND sg13cmos5l_nor2_1
XFILLER_25_1000 VPWR VGND sg13cmos5l_decap_8
X_2379_ _2433_/D _2371_/A _2372_/C _2378_/Y VPWR VGND sg13cmos5l_o21ai_1
XFILLER_17_46 VPWR VGND sg13cmos5l_fill_2
XFILLER_13_905 VPWR VGND sg13cmos5l_decap_8
XFILLER_24_231 VPWR VGND sg13cmos5l_fill_1
XFILLER_24_242 VPWR VGND sg13cmos5l_decap_8
XFILLER_4_603 VPWR VGND sg13cmos5l_decap_8
XFILLER_3_168 VPWR VGND sg13cmos5l_decap_8
XFILLER_3_146 VPWR VGND sg13cmos5l_decap_8
XFILLER_0_875 VPWR VGND sg13cmos5l_decap_8
XFILLER_48_824 VPWR VGND sg13cmos5l_decap_8
XFILLER_47_367 VPWR VGND sg13cmos5l_fill_1
XFILLER_15_242 VPWR VGND sg13cmos5l_decap_8
XFILLER_16_765 VPWR VGND sg13cmos5l_decap_8
XFILLER_31_702 VPWR VGND sg13cmos5l_decap_4
XFILLER_15_286 VPWR VGND sg13cmos5l_decap_8
X_3517__328 _3517_/RESET_B VPWR VGND sg13cmos5l_tiehi
XFILLER_12_971 VPWR VGND sg13cmos5l_decap_8
XFILLER_8_953 VPWR VGND sg13cmos5l_decap_8
XFILLER_11_470 VPWR VGND sg13cmos5l_fill_1
X_3420_ _3420_/Q _3453_/CLK _3420_/D _3420_/RESET_B VPWR VGND sg13cmos5l_dfrbpq_1
Xhold419 _2143_/B _3324_/Q VPWR VGND sg13cmos5l_dlygate4sd3_1
X_3351_ _3351_/Q _3355_/CLK _3351_/D _3351_/RESET_B VPWR VGND sg13cmos5l_dfrbpq_1
X_2302_ _2302_/Y _2303_/A _2302_/B VPWR VGND sg13cmos5l_nand2_1
X_3282_ _3282_/Q clkload8/A _3282_/D _3282_/RESET_B VPWR VGND sg13cmos5l_dfrbpq_1
XFILLER_2_190 VPWR VGND sg13cmos5l_decap_8
X_2233_ _2233_/Y _2429_/A _3382_/Q VPWR VGND sg13cmos5l_nor2_1
XFILLER_39_868 VPWR VGND sg13cmos5l_decap_8
X_2164_ _2165_/B _2164_/A _2164_/B VPWR VGND sg13cmos5l_nor2_1
X_2095_ _2095_/Y _2095_/A VPWR VGND sg13cmos5l_inv_1
XFILLER_0_60 VPWR VGND sg13cmos5l_decap_8
XFILLER_21_201 VPWR VGND sg13cmos5l_decap_8
XFILLER_22_724 VPWR VGND sg13cmos5l_fill_2
XFILLER_34_595 VPWR VGND sg13cmos5l_decap_8
XFILLER_10_919 VPWR VGND sg13cmos5l_decap_8
X_2997_ _3007_/B _2994_/A _2994_/B _2996_/X VPWR VGND sg13cmos5l_o21ai_1
XFILLER_21_267 VPWR VGND sg13cmos5l_fill_2
XFILLER_21_278 VPWR VGND sg13cmos5l_decap_8
X_1948_ _1948_/X _1948_/A _1953_/B VPWR VGND sg13cmos5l_or2_1
X_1879_ _1884_/B _1879_/A _1879_/B _3230_/A VPWR VGND sg13cmos5l_nor3_1
X_3549_ _3549_/Q clkload7/A _3549_/D _3549_/RESET_B VPWR VGND sg13cmos5l_dfrbpq_1
XFILLER_28_12 VPWR VGND sg13cmos5l_decap_8
XFILLER_29_323 VPWR VGND sg13cmos5l_decap_8
XFILLER_29_356 VPWR VGND sg13cmos5l_fill_2
XFILLER_44_33 VPWR VGND sg13cmos5l_decap_8
XFILLER_44_22 VPWR VGND sg13cmos5l_fill_2
XFILLER_44_11 VPWR VGND sg13cmos5l_fill_2
XFILLER_13_735 VPWR VGND sg13cmos5l_decap_4
XFILLER_12_223 VPWR VGND sg13cmos5l_decap_8
XFILLER_12_234 VPWR VGND sg13cmos5l_fill_1
XFILLER_13_757 VPWR VGND sg13cmos5l_decap_4
XFILLER_8_238 VPWR VGND sg13cmos5l_decap_8
XFILLER_5_945 VPWR VGND sg13cmos5l_decap_8
XFILLER_5_49 VPWR VGND sg13cmos5l_fill_1
XFILLER_4_466 VPWR VGND sg13cmos5l_fill_1
XFILLER_48_621 VPWR VGND sg13cmos5l_fill_2
XFILLER_0_650 VPWR VGND sg13cmos5l_decap_8
XFILLER_0_672 VPWR VGND sg13cmos5l_decap_8
XFILLER_47_120 VPWR VGND sg13cmos5l_decap_4
Xclkbuf_2_3__f_clk clkload1/A clkbuf_0_clk/X VPWR VGND sg13cmos5l_buf_8
XFILLER_47_197 VPWR VGND sg13cmos5l_decap_8
XFILLER_16_540 VPWR VGND sg13cmos5l_decap_8
XFILLER_44_882 VPWR VGND sg13cmos5l_decap_8
X_2920_ _2920_/Y _3506_/Q _1854_/Y _1855_/Y _3121_/A VPWR VGND sg13cmos5l_a22oi_1
X_2851_ _2858_/C _3479_/Q _3478_/Q _3480_/Q VPWR VGND sg13cmos5l_o21ai_1
X_1802_ _1802_/Y _1802_/A VPWR VGND sg13cmos5l_inv_1
X_2782_ _2782_/Y _1807_/Y _3118_/A2 _2781_/Y VPWR VGND sg13cmos5l_a21oi_1
XFILLER_31_598 VPWR VGND sg13cmos5l_decap_4
XFILLER_8_761 VPWR VGND sg13cmos5l_decap_8
XFILLER_7_293 VPWR VGND sg13cmos5l_decap_8
X_3403_ _3403_/Q _3463_/CLK _3403_/D _3403_/RESET_B VPWR VGND sg13cmos5l_dfrbpq_1
X_3334_ _3334_/Q _3355_/CLK _3334_/D _3334_/RESET_B VPWR VGND sg13cmos5l_dfrbpq_1
X_3265_ _3265_/Q clkload8/A _3265_/D _3265_/RESET_B VPWR VGND sg13cmos5l_dfrbpq_1
X_2216_ _2216_/Y _2216_/A _2221_/A VPWR VGND sg13cmos5l_nor2_1
X_3196_ _3196_/Y _3179_/X _3180_/Y _3188_/Y _3190_/Y _3191_/Y VPWR VGND sg13cmos5l_a221oi_1
X_2147_ _2147_/X _2147_/A _2147_/B VPWR VGND sg13cmos5l_and2_1
XFILLER_26_348 VPWR VGND sg13cmos5l_fill_2
XFILLER_26_359 VPWR VGND sg13cmos5l_decap_4
X_2078_ _2081_/B _3543_/D _2084_/B VPWR VGND sg13cmos5l_or2_1
XFILLER_34_370 VPWR VGND sg13cmos5l_fill_1
XFILLER_30_46 VPWR VGND sg13cmos5l_decap_8
XFILLER_2_959 VPWR VGND sg13cmos5l_decap_8
XFILLER_39_99 VPWR VGND sg13cmos5l_fill_1
XFILLER_29_153 VPWR VGND sg13cmos5l_fill_2
XFILLER_18_849 VPWR VGND sg13cmos5l_decap_8
XFILLER_45_657 VPWR VGND sg13cmos5l_decap_8
XFILLER_44_167 VPWR VGND sg13cmos5l_decap_8
XFILLER_26_871 VPWR VGND sg13cmos5l_decap_8
XFILLER_32_307 VPWR VGND sg13cmos5l_fill_1
XFILLER_40_351 VPWR VGND sg13cmos5l_decap_8
XFILLER_9_503 VPWR VGND sg13cmos5l_fill_1
XFILLER_5_720 VPWR VGND sg13cmos5l_fill_2
XFILLER_5_753 VPWR VGND sg13cmos5l_decap_8
XFILLER_4_230 VPWR VGND sg13cmos5l_decap_8
XFILLER_4_263 VPWR VGND sg13cmos5l_decap_8
XFILLER_1_970 VPWR VGND sg13cmos5l_decap_8
X_3050_ _3058_/B _3514_/Q _3051_/B VPWR VGND sg13cmos5l_nor2b_1
XFILLER_49_974 VPWR VGND sg13cmos5l_decap_8
X_2001_ _2038_/B _2001_/A _2040_/A _2001_/C _2001_/D VPWR VGND sg13cmos5l_nor4_1
XFILLER_36_657 VPWR VGND sg13cmos5l_decap_8
XFILLER_24_808 VPWR VGND sg13cmos5l_decap_8
XFILLER_35_145 VPWR VGND sg13cmos5l_decap_8
XFILLER_35_189 VPWR VGND sg13cmos5l_decap_8
XFILLER_16_370 VPWR VGND sg13cmos5l_decap_8
XFILLER_32_841 VPWR VGND sg13cmos5l_fill_2
XFILLER_32_852 VPWR VGND sg13cmos5l_decap_4
X_2903_ _2904_/B _2899_/X _2900_/Y _2901_/Y VPWR VGND sg13cmos5l_a21o_1
X_2834_ _2834_/Y _2835_/A _2835_/B _2833_/Y VPWR VGND sg13cmos5l_a21oi_1
XFILLER_31_384 VPWR VGND sg13cmos5l_decap_8
XFILLER_31_395 VPWR VGND sg13cmos5l_fill_2
X_2765_ _2767_/B _2761_/Y _2762_/Y _2764_/Y VPWR VGND sg13cmos5l_o21ai_1
X_2696_ _2701_/S _2693_/Y _2695_/Y _2678_/Y VPWR VGND sg13cmos5l_o21ai_1
X_3317_ _3317_/Q _3355_/CLK _3317_/D _3317_/RESET_B VPWR VGND sg13cmos5l_dfrbpq_1
X_3248_ _3248_/Y _3246_/Y _3247_/Y _3255_/A VPWR VGND sg13cmos5l_o21ai_1
X_3179_ _3179_/X _3121_/A _2865_/Y _3180_/A VPWR VGND sg13cmos5l_a21o_1
XFILLER_27_624 VPWR VGND sg13cmos5l_fill_1
XFILLER_15_819 VPWR VGND sg13cmos5l_decap_8
XFILLER_42_649 VPWR VGND sg13cmos5l_decap_4
XFILLER_25_57 VPWR VGND sg13cmos5l_fill_2
XFILLER_35_690 VPWR VGND sg13cmos5l_decap_8
XFILLER_10_535 VPWR VGND sg13cmos5l_fill_1
XFILLER_22_384 VPWR VGND sg13cmos5l_fill_1
XFILLER_23_896 VPWR VGND sg13cmos5l_decap_8
XFILLER_6_539 VPWR VGND sg13cmos5l_decap_4
XFILLER_10_579 VPWR VGND sg13cmos5l_fill_2
XFILLER_1_200 VPWR VGND sg13cmos5l_fill_2
XFILLER_2_756 VPWR VGND sg13cmos5l_decap_8
XFILLER_1_233 VPWR VGND sg13cmos5l_decap_8
Xhold580 _2599_/B _3427_/Q VPWR VGND sg13cmos5l_dlygate4sd3_1
XFILLER_1_244 VPWR VGND sg13cmos5l_fill_1
Xhold591 _2614_/A _3412_/Q VPWR VGND sg13cmos5l_dlygate4sd3_1
XFILLER_18_602 VPWR VGND sg13cmos5l_fill_2
XFILLER_45_410 VPWR VGND sg13cmos5l_fill_2
XFILLER_46_955 VPWR VGND sg13cmos5l_decap_8
XFILLER_17_134 VPWR VGND sg13cmos5l_decap_8
XFILLER_9_300 VPWR VGND sg13cmos5l_decap_8
XFILLER_13_351 VPWR VGND sg13cmos5l_fill_2
XFILLER_14_852 VPWR VGND sg13cmos5l_decap_8
XFILLER_13_384 VPWR VGND sg13cmos5l_decap_4
X_3297__399 _3297_/RESET_B VPWR VGND sg13cmos5l_tiehi
XFILLER_9_399 VPWR VGND sg13cmos5l_fill_1
XFILLER_12_1013 VPWR VGND sg13cmos5l_decap_8
XFILLER_5_550 VPWR VGND sg13cmos5l_decap_8
X_2550_ _2550_/Y _2550_/A _2550_/B VPWR VGND sg13cmos5l_nor2_1
X_2481_ _2615_/B _3543_/D _2776_/B VPWR VGND sg13cmos5l_nor2_1
XFILLER_49_4 VPWR VGND sg13cmos5l_decap_8
X_3102_ _3103_/B _3112_/B _3100_/Y _3112_/A VPWR VGND sg13cmos5l_o21ai_1
XFILLER_49_771 VPWR VGND sg13cmos5l_decap_8
XFILLER_37_944 VPWR VGND sg13cmos5l_decap_8
X_3033_ _3038_/A _3066_/A _3045_/B _3033_/C VPWR VGND sg13cmos5l_nand3_1
XFILLER_36_476 VPWR VGND sg13cmos5l_decap_8
X_3274__141 _3274_/RESET_B VPWR VGND sg13cmos5l_tiehi
X_2817_ _2819_/A _2817_/A VPWR VGND sg13cmos5l_inv_1
X_2748_ _2753_/B _3476_/Q _1857_/Y _2747_/Y VPWR VGND sg13cmos5l_o21ai_1
X_2679_ _2692_/B _3446_/Q _3447_/Q _3448_/Q VPWR VGND sg13cmos5l_o21ai_1
XFILLER_39_270 VPWR VGND sg13cmos5l_decap_8
XFILLER_28_955 VPWR VGND sg13cmos5l_decap_8
XFILLER_14_104 VPWR VGND sg13cmos5l_fill_2
XFILLER_27_465 VPWR VGND sg13cmos5l_decap_8
XFILLER_43_958 VPWR VGND sg13cmos5l_decap_8
XFILLER_14_126 VPWR VGND sg13cmos5l_decap_4
XFILLER_14_137 VPWR VGND sg13cmos5l_decap_8
XFILLER_15_638 VPWR VGND sg13cmos5l_decap_8
XFILLER_11_833 VPWR VGND sg13cmos5l_fill_1
XFILLER_23_682 VPWR VGND sg13cmos5l_fill_1
XFILLER_7_815 VPWR VGND sg13cmos5l_decap_8
XFILLER_11_866 VPWR VGND sg13cmos5l_decap_8
XFILLER_6_314 VPWR VGND sg13cmos5l_decap_8
XFILLER_7_0 VPWR VGND sg13cmos5l_fill_2
XFILLER_2_564 VPWR VGND sg13cmos5l_decap_8
XFILLER_38_719 VPWR VGND sg13cmos5l_decap_8
XFILLER_46_730 VPWR VGND sg13cmos5l_decap_8
XFILLER_19_955 VPWR VGND sg13cmos5l_decap_8
XFILLER_34_925 VPWR VGND sg13cmos5l_decap_8
XFILLER_34_969 VPWR VGND sg13cmos5l_decap_8
XFILLER_33_457 VPWR VGND sg13cmos5l_decap_8
XFILLER_42_980 VPWR VGND sg13cmos5l_decap_8
X_1981_ _3307_/D _1799_/Y _1983_/A2 _1980_/Y VPWR VGND sg13cmos5l_a21oi_1
XFILLER_20_118 VPWR VGND sg13cmos5l_fill_1
XFILLER_9_152 VPWR VGND sg13cmos5l_decap_8
XFILLER_9_130 VPWR VGND sg13cmos5l_decap_8
XFILLER_9_185 VPWR VGND sg13cmos5l_decap_8
X_2602_ _2602_/Y _3399_/Q _2958_/A2 _2608_/A VPWR VGND sg13cmos5l_o21ai_1
XFILLER_6_881 VPWR VGND sg13cmos5l_decap_8
X_2533_ _2535_/C _3410_/Q _2533_/B VPWR VGND sg13cmos5l_or2_1
X_2464_ _2465_/C _2464_/A _2464_/B _2464_/C VPWR VGND sg13cmos5l_nand3_1
X_2395_ _2395_/Y _2569_/B _2395_/B VPWR VGND sg13cmos5l_nand2_1
XFILLER_37_785 VPWR VGND sg13cmos5l_fill_1
X_3016_ _3016_/Y _3009_/Y _3012_/Y _3015_/X VPWR VGND sg13cmos5l_o21ai_1
XFILLER_36_262 VPWR VGND sg13cmos5l_fill_1
XFILLER_25_958 VPWR VGND sg13cmos5l_decap_8
XFILLER_36_295 VPWR VGND sg13cmos5l_fill_2
XFILLER_11_129 VPWR VGND sg13cmos5l_decap_8
XFILLER_33_980 VPWR VGND sg13cmos5l_decap_8
XFILLER_20_674 VPWR VGND sg13cmos5l_decap_8
XFILLER_0_7 VPWR VGND sg13cmos5l_decap_8
XFILLER_47_66 VPWR VGND sg13cmos5l_fill_2
XFILLER_16_925 VPWR VGND sg13cmos5l_decap_8
XFILLER_27_251 VPWR VGND sg13cmos5l_decap_8
XFILLER_43_766 VPWR VGND sg13cmos5l_fill_1
XFILLER_30_416 VPWR VGND sg13cmos5l_decap_8
XFILLER_8_38 VPWR VGND sg13cmos5l_fill_1
XFILLER_30_449 VPWR VGND sg13cmos5l_decap_8
XFILLER_7_634 VPWR VGND sg13cmos5l_fill_1
XFILLER_7_623 VPWR VGND sg13cmos5l_decap_8
XFILLER_11_674 VPWR VGND sg13cmos5l_fill_1
XFILLER_7_667 VPWR VGND sg13cmos5l_fill_1
XFILLER_6_199 VPWR VGND sg13cmos5l_decap_8
XFILLER_3_884 VPWR VGND sg13cmos5l_decap_8
XFILLER_33_7 VPWR VGND sg13cmos5l_decap_4
X_2180_ _2185_/A _3356_/Q _3357_/Q _3358_/Q VPWR VGND sg13cmos5l_nor3_1
X_3264__151 _3264_/RESET_B VPWR VGND sg13cmos5l_tiehi
XFILLER_18_251 VPWR VGND sg13cmos5l_decap_8
XFILLER_19_785 VPWR VGND sg13cmos5l_decap_8
XFILLER_46_593 VPWR VGND sg13cmos5l_decap_8
XFILLER_33_254 VPWR VGND sg13cmos5l_decap_8
XFILLER_15_980 VPWR VGND sg13cmos5l_decap_8
XFILLER_22_939 VPWR VGND sg13cmos5l_decap_8
X_1964_ _3299_/D _1902_/B _1965_/B _1963_/Y VPWR VGND sg13cmos5l_a21oi_1
Xclkbuf_leaf_13_clk _3444_/CLK clkbuf_2_2__f_clk/X VPWR VGND sg13cmos5l_buf_8
X_3336__119 _3336_/D VPWR VGND sg13cmos5l_tielo
XFILLER_30_983 VPWR VGND sg13cmos5l_decap_8
X_1895_ _3545_/D _2018_/A _3241_/B VPWR VGND sg13cmos5l_and2_1
X_3271__144 _3271_/RESET_B VPWR VGND sg13cmos5l_tiehi
X_3496_ _3496_/Q _3527_/CLK _3496_/D _3496_/RESET_B VPWR VGND sg13cmos5l_dfrbpq_1
X_2516_ _2516_/Y _2517_/B VPWR VGND sg13cmos5l_inv_1
X_2447_ _2468_/B _2464_/B _2464_/C _2464_/A VPWR VGND sg13cmos5l_a21oi_1
X_2378_ _2378_/Y _2378_/A _3382_/Q _2431_/A VPWR VGND sg13cmos5l_nor3_1
XFILLER_37_560 VPWR VGND sg13cmos5l_fill_1
X_3462__196 _3462_/RESET_B VPWR VGND sg13cmos5l_tiehi
XFILLER_12_416 VPWR VGND sg13cmos5l_fill_1
XFILLER_24_298 VPWR VGND sg13cmos5l_decap_8
XFILLER_21_983 VPWR VGND sg13cmos5l_decap_8
XFILLER_32_1027 VPWR VGND sg13cmos5l_fill_2
XFILLER_4_626 VPWR VGND sg13cmos5l_decap_4
XFILLER_4_659 VPWR VGND sg13cmos5l_decap_8
XFILLER_4_648 VPWR VGND sg13cmos5l_fill_1
XFILLER_4_637 VPWR VGND sg13cmos5l_decap_8
XFILLER_3_125 VPWR VGND sg13cmos5l_fill_2
XFILLER_48_803 VPWR VGND sg13cmos5l_decap_8
XFILLER_0_854 VPWR VGND sg13cmos5l_decap_8
XFILLER_16_700 VPWR VGND sg13cmos5l_decap_8
XFILLER_16_711 VPWR VGND sg13cmos5l_fill_2
XFILLER_28_593 VPWR VGND sg13cmos5l_decap_8
X_3521__293 _3521_/RESET_B VPWR VGND sg13cmos5l_tiehi
XFILLER_16_799 VPWR VGND sg13cmos5l_decap_8
XFILLER_31_714 VPWR VGND sg13cmos5l_decap_8
XFILLER_12_950 VPWR VGND sg13cmos5l_decap_8
XFILLER_8_932 VPWR VGND sg13cmos5l_decap_8
XFILLER_30_268 VPWR VGND sg13cmos5l_fill_2
XFILLER_7_420 VPWR VGND sg13cmos5l_decap_8
XFILLER_11_493 VPWR VGND sg13cmos5l_fill_2
XFILLER_7_475 VPWR VGND sg13cmos5l_fill_2
X_3350_ _3350_/Q _3378_/CLK _3350_/D _3350_/RESET_B VPWR VGND sg13cmos5l_dfrbpq_1
XFILLER_3_681 VPWR VGND sg13cmos5l_decap_8
X_2301_ _2302_/B _2304_/A _2304_/B VPWR VGND sg13cmos5l_nor2_1
X_3281_ _3281_/Q clkload9/A _3281_/D _3281_/RESET_B VPWR VGND sg13cmos5l_dfrbpq_1
XFILLER_31_4 VPWR VGND sg13cmos5l_decap_8
X_2232_ _2232_/Y _2229_/Y _2230_/Y _2231_/Y VPWR VGND sg13cmos5l_o21ai_1
XFILLER_38_313 VPWR VGND sg13cmos5l_decap_4
Xclkbuf_leaf_2_clk clkload3/A clkbuf_leaf_2_clk/A VPWR VGND sg13cmos5l_buf_8
X_2163_ _2163_/Y _2163_/A _2163_/B VPWR VGND sg13cmos5l_nand2_1
XFILLER_39_847 VPWR VGND sg13cmos5l_decap_8
XFILLER_38_346 VPWR VGND sg13cmos5l_decap_8
XFILLER_17_2 VPWR VGND sg13cmos5l_fill_1
XFILLER_38_357 VPWR VGND sg13cmos5l_fill_1
X_2094_ _2095_/A _2104_/B _2093_/Y VPWR VGND sg13cmos5l_nor2b_1
XFILLER_22_736 VPWR VGND sg13cmos5l_decap_8
X_3500__388 _3500_/RESET_B VPWR VGND sg13cmos5l_tiehi
XFILLER_9_70 VPWR VGND sg13cmos5l_fill_1
X_2996_ _2996_/X _2996_/A _2996_/B VPWR VGND sg13cmos5l_xor2_1
X_1947_ _3293_/D _1945_/Y hold469/X _3239_/A VPWR VGND sg13cmos5l_a21oi_1
X_3318__361 _3318_/RESET_B VPWR VGND sg13cmos5l_tiehi
X_1878_ _3551_/D _3547_/D _3544_/D VPWR VGND sg13cmos5l_or2_1
X_3548_ _3548_/Q clkload2/A _3548_/D _3548_/RESET_B VPWR VGND sg13cmos5l_dfrbpq_1
XFILLER_0_117 VPWR VGND sg13cmos5l_decap_8
XFILLER_0_106 VPWR VGND sg13cmos5l_decap_4
X_3479_ _3479_/Q _3504_/CLK _3479_/D _3479_/RESET_B VPWR VGND sg13cmos5l_dfrbpq_1
XFILLER_28_57 VPWR VGND sg13cmos5l_decap_8
XFILLER_29_335 VPWR VGND sg13cmos5l_fill_2
XFILLER_45_839 VPWR VGND sg13cmos5l_decap_8
XFILLER_44_316 VPWR VGND sg13cmos5l_decap_4
XFILLER_44_89 VPWR VGND sg13cmos5l_fill_1
XFILLER_40_544 VPWR VGND sg13cmos5l_decap_8
XFILLER_40_533 VPWR VGND sg13cmos5l_fill_1
XFILLER_5_924 VPWR VGND sg13cmos5l_decap_8
X_3516__351 _3516_/RESET_B VPWR VGND sg13cmos5l_tiehi
XFILLER_5_28 VPWR VGND sg13cmos5l_fill_2
XFILLER_47_165 VPWR VGND sg13cmos5l_decap_8
XFILLER_35_327 VPWR VGND sg13cmos5l_fill_2
XFILLER_35_338 VPWR VGND sg13cmos5l_fill_2
X_3261__154 _3261_/RESET_B VPWR VGND sg13cmos5l_tiehi
X_2850_ _2863_/B _3480_/Q _3479_/Q _3478_/Q VPWR VGND sg13cmos5l_or3_1
XFILLER_16_596 VPWR VGND sg13cmos5l_decap_8
XFILLER_31_544 VPWR VGND sg13cmos5l_fill_1
X_1801_ _1801_/Y _1801_/A VPWR VGND sg13cmos5l_inv_1
XFILLER_15_1022 VPWR VGND sg13cmos5l_decap_8
XFILLER_31_577 VPWR VGND sg13cmos5l_fill_2
XFILLER_12_791 VPWR VGND sg13cmos5l_decap_8
X_2781_ _2781_/Y _3464_/Q _3118_/A2 _2784_/A VPWR VGND sg13cmos5l_o21ai_1
XFILLER_7_272 VPWR VGND sg13cmos5l_decap_8
X_3402_ _3402_/Q _3463_/CLK _3402_/D _3402_/RESET_B VPWR VGND sg13cmos5l_dfrbpq_1
X_3333_ _3333_/Q _3378_/CLK _3333_/D _3333_/RESET_B VPWR VGND sg13cmos5l_dfrbpq_1
X_3264_ _3264_/Q clkload9/A _3264_/D _3264_/RESET_B VPWR VGND sg13cmos5l_dfrbpq_1
X_2215_ _2215_/Y _2208_/X _2212_/Y _2221_/A _2216_/A _2214_/X VPWR VGND sg13cmos5l_a221oi_1
X_3195_ _3199_/A _3209_/A _3148_/Y _3202_/S _3187_/A _3193_/Y VPWR VGND sg13cmos5l_a221oi_1
X_2146_ _2146_/X _2162_/A _2147_/B VPWR VGND sg13cmos5l_and2_1
XFILLER_26_327 VPWR VGND sg13cmos5l_decap_8
XFILLER_27_839 VPWR VGND sg13cmos5l_decap_8
XFILLER_19_390 VPWR VGND sg13cmos5l_decap_8
X_2077_ _3323_/D _2077_/A VPWR VGND sg13cmos5l_inv_1
XFILLER_22_566 VPWR VGND sg13cmos5l_decap_8
X_2979_ _3005_/B _2975_/Y _2977_/Y _2978_/Y VPWR VGND sg13cmos5l_o21ai_1
XFILLER_10_728 VPWR VGND sg13cmos5l_decap_8
XFILLER_2_938 VPWR VGND sg13cmos5l_decap_8
XFILLER_29_132 VPWR VGND sg13cmos5l_decap_8
XFILLER_44_113 VPWR VGND sg13cmos5l_decap_8
XFILLER_17_305 VPWR VGND sg13cmos5l_decap_8
XFILLER_18_839 VPWR VGND sg13cmos5l_decap_4
XFILLER_26_850 VPWR VGND sg13cmos5l_fill_1
XFILLER_13_511 VPWR VGND sg13cmos5l_decap_8
XFILLER_13_544 VPWR VGND sg13cmos5l_fill_1
XFILLER_40_396 VPWR VGND sg13cmos5l_decap_8
XFILLER_13_588 VPWR VGND sg13cmos5l_decap_8
XFILLER_4_242 VPWR VGND sg13cmos5l_decap_8
XFILLER_5_798 VPWR VGND sg13cmos5l_decap_8
XFILLER_45_1026 VPWR VGND sg13cmos5l_fill_2
XFILLER_49_953 VPWR VGND sg13cmos5l_decap_8
XFILLER_0_492 VPWR VGND sg13cmos5l_decap_8
X_2000_ _2084_/B _2040_/A _2001_/C _2001_/D VPWR VGND sg13cmos5l_nand3_1
XFILLER_48_496 VPWR VGND sg13cmos5l_decap_8
XFILLER_23_308 VPWR VGND sg13cmos5l_decap_8
XFILLER_35_168 VPWR VGND sg13cmos5l_fill_1
XFILLER_44_691 VPWR VGND sg13cmos5l_decap_8
X_2902_ _2913_/C _2899_/X _2900_/Y _2901_/Y VPWR VGND sg13cmos5l_a21oi_1
XFILLER_32_820 VPWR VGND sg13cmos5l_decap_8
X_2833_ _2833_/Y _2833_/A _2833_/B VPWR VGND sg13cmos5l_nor2_1
X_2764_ _2764_/Y _2926_/A _2756_/Y _2763_/Y _2774_/B VPWR VGND sg13cmos5l_a22oi_1
X_2695_ _2695_/Y _2708_/A _2691_/A _2708_/B VPWR VGND sg13cmos5l_o21ai_1
X_3316_ _3316_/Q clkload9/A _3316_/D _3316_/RESET_B VPWR VGND sg13cmos5l_dfrbpq_1
XFILLER_39_430 VPWR VGND sg13cmos5l_decap_8
X_3247_ _3247_/Y _3250_/B _1876_/A VPWR VGND sg13cmos5l_nor2b_1
XFILLER_39_485 VPWR VGND sg13cmos5l_decap_8
X_3178_ _3180_/B _3483_/Q _3183_/B VPWR VGND sg13cmos5l_nand2b_1
XFILLER_26_102 VPWR VGND sg13cmos5l_fill_2
X_2129_ _2129_/Y _2129_/A _2129_/B VPWR VGND sg13cmos5l_nor2_1
XFILLER_15_809 VPWR VGND sg13cmos5l_fill_2
XFILLER_14_319 VPWR VGND sg13cmos5l_fill_1
XFILLER_23_875 VPWR VGND sg13cmos5l_decap_8
XFILLER_10_514 VPWR VGND sg13cmos5l_fill_1
XFILLER_22_363 VPWR VGND sg13cmos5l_decap_8
XFILLER_22_374 VPWR VGND sg13cmos5l_fill_1
XFILLER_41_57 VPWR VGND sg13cmos5l_fill_2
XFILLER_6_518 VPWR VGND sg13cmos5l_decap_8
XFILLER_9_4 VPWR VGND sg13cmos5l_decap_8
XFILLER_2_735 VPWR VGND sg13cmos5l_decap_8
Xhold581 hold581/X _2599_/Y VPWR VGND sg13cmos5l_dlygate4sd3_1
Xhold570 _3525_/D _3120_/Y VPWR VGND sg13cmos5l_dlygate4sd3_1
Xhold592 hold592/X _3312_/Q VPWR VGND sg13cmos5l_dlygate4sd3_1
XFILLER_49_238 VPWR VGND sg13cmos5l_decap_8
XFILLER_1_289 VPWR VGND sg13cmos5l_decap_4
X_3546__130 _3546_/RESET_B VPWR VGND sg13cmos5l_tiehi
XFILLER_46_934 VPWR VGND sg13cmos5l_decap_8
XFILLER_17_113 VPWR VGND sg13cmos5l_decap_8
XFILLER_18_669 VPWR VGND sg13cmos5l_decap_8
XFILLER_13_330 VPWR VGND sg13cmos5l_decap_8
XFILLER_41_672 VPWR VGND sg13cmos5l_decap_4
XFILLER_9_334 VPWR VGND sg13cmos5l_decap_8
XFILLER_40_182 VPWR VGND sg13cmos5l_decap_8
XFILLER_9_345 VPWR VGND sg13cmos5l_fill_2
X_2480_ _3412_/D _2468_/A hold621/X _2383_/A VPWR VGND sg13cmos5l_a21oi_1
XFILLER_5_584 VPWR VGND sg13cmos5l_decap_8
X_3101_ _3103_/A _1800_/A _3098_/B _3100_/Y _3520_/Q _3099_/Y VPWR VGND sg13cmos5l_a221oi_1
XFILLER_49_750 VPWR VGND sg13cmos5l_decap_8
XFILLER_37_923 VPWR VGND sg13cmos5l_decap_8
X_3032_ _3032_/X _3045_/B _3033_/C VPWR VGND sg13cmos5l_and2_1
XFILLER_24_628 VPWR VGND sg13cmos5l_fill_1
XFILLER_23_116 VPWR VGND sg13cmos5l_decap_8
XFILLER_23_138 VPWR VGND sg13cmos5l_fill_2
XFILLER_20_823 VPWR VGND sg13cmos5l_decap_8
XFILLER_32_672 VPWR VGND sg13cmos5l_fill_1
X_2816_ _2817_/A _2831_/A _2816_/B VPWR VGND sg13cmos5l_nor2_1
XFILLER_20_878 VPWR VGND sg13cmos5l_decap_8
XFILLER_20_889 VPWR VGND sg13cmos5l_fill_1
X_2747_ _2747_/Y _3477_/Q _2599_/A _2746_/Y VPWR VGND sg13cmos5l_a21oi_1
X_2678_ _2678_/Y _2678_/A _2678_/B VPWR VGND sg13cmos5l_xnor2_1
XFILLER_27_400 VPWR VGND sg13cmos5l_decap_4
XFILLER_28_934 VPWR VGND sg13cmos5l_decap_8
XFILLER_27_444 VPWR VGND sg13cmos5l_decap_8
XFILLER_15_606 VPWR VGND sg13cmos5l_fill_1
XFILLER_43_937 VPWR VGND sg13cmos5l_decap_8
XFILLER_14_116 VPWR VGND sg13cmos5l_decap_4
XFILLER_42_469 VPWR VGND sg13cmos5l_fill_2
XFILLER_22_160 VPWR VGND sg13cmos5l_decap_4
XFILLER_35_1014 VPWR VGND sg13cmos5l_decap_8
XFILLER_11_845 VPWR VGND sg13cmos5l_decap_8
XFILLER_22_171 VPWR VGND sg13cmos5l_fill_1
XFILLER_6_337 VPWR VGND sg13cmos5l_fill_1
XFILLER_37_219 VPWR VGND sg13cmos5l_decap_8
XFILLER_19_912 VPWR VGND sg13cmos5l_decap_8
XFILLER_18_433 VPWR VGND sg13cmos5l_decap_8
XFILLER_46_786 VPWR VGND sg13cmos5l_decap_8
XFILLER_18_499 VPWR VGND sg13cmos5l_fill_1
XFILLER_34_948 VPWR VGND sg13cmos5l_decap_8
X_1980_ _1980_/Y _1983_/A2 hold451/X _3028_/B VPWR VGND sg13cmos5l_o21ai_1
XFILLER_9_175 VPWR VGND sg13cmos5l_decap_8
X_2601_ _3429_/D _2601_/A _2601_/B VPWR VGND sg13cmos5l_and2_1
XFILLER_6_860 VPWR VGND sg13cmos5l_decap_8
X_2532_ _2533_/B _3409_/Q _3389_/Q _3388_/Q VPWR VGND sg13cmos5l_nor3_1
X_2463_ _2463_/Y _2463_/A VPWR VGND sg13cmos5l_inv_1
X_2394_ _2394_/Y _2395_/B VPWR VGND sg13cmos5l_inv_1
XFILLER_49_591 VPWR VGND sg13cmos5l_decap_8
X_3521__93 _3521_/D VPWR VGND sg13cmos5l_tielo
X_3015_ _3015_/X _3504_/Q _3015_/B _3015_/C VPWR VGND sg13cmos5l_or3_1
XFILLER_25_904 VPWR VGND sg13cmos5l_decap_4
XFILLER_25_937 VPWR VGND sg13cmos5l_decap_8
XFILLER_36_274 VPWR VGND sg13cmos5l_decap_8
XFILLER_11_119 VPWR VGND sg13cmos5l_decap_4
XFILLER_20_620 VPWR VGND sg13cmos5l_fill_1
XFILLER_20_631 VPWR VGND sg13cmos5l_decap_8
XFILLER_20_642 VPWR VGND sg13cmos5l_fill_1
XFILLER_32_491 VPWR VGND sg13cmos5l_decap_8
XFILLER_20_697 VPWR VGND sg13cmos5l_fill_2
XFILLER_4_819 VPWR VGND sg13cmos5l_decap_8
X_3510__368 _3510_/RESET_B VPWR VGND sg13cmos5l_tiehi
XFILLER_47_78 VPWR VGND sg13cmos5l_decap_4
XFILLER_28_786 VPWR VGND sg13cmos5l_fill_2
XFILLER_27_296 VPWR VGND sg13cmos5l_fill_1
XFILLER_42_277 VPWR VGND sg13cmos5l_fill_2
XFILLER_10_130 VPWR VGND sg13cmos5l_fill_1
XFILLER_7_602 VPWR VGND sg13cmos5l_decap_8
XFILLER_7_657 VPWR VGND sg13cmos5l_decap_4
XFILLER_6_134 VPWR VGND sg13cmos5l_decap_8
XFILLER_10_163 VPWR VGND sg13cmos5l_fill_2
XFILLER_10_174 VPWR VGND sg13cmos5l_fill_2
XFILLER_10_196 VPWR VGND sg13cmos5l_decap_8
XFILLER_6_178 VPWR VGND sg13cmos5l_decap_8
XFILLER_3_863 VPWR VGND sg13cmos5l_decap_8
XFILLER_2_340 VPWR VGND sg13cmos5l_decap_8
XFILLER_2_395 VPWR VGND sg13cmos5l_decap_4
XFILLER_38_528 VPWR VGND sg13cmos5l_decap_4
XFILLER_19_731 VPWR VGND sg13cmos5l_fill_1
XFILLER_46_561 VPWR VGND sg13cmos5l_decap_4
XFILLER_34_712 VPWR VGND sg13cmos5l_decap_8
XFILLER_22_929 VPWR VGND sg13cmos5l_fill_1
XFILLER_14_480 VPWR VGND sg13cmos5l_decap_8
XFILLER_21_439 VPWR VGND sg13cmos5l_decap_8
X_1963_ _1963_/Y _1902_/B _1965_/B _2018_/A VPWR VGND sg13cmos5l_o21ai_1
X_1894_ _3241_/B _2006_/B _2005_/A _1996_/B VPWR VGND sg13cmos5l_o21ai_1
XFILLER_30_962 VPWR VGND sg13cmos5l_decap_8
X_2515_ _2517_/B _2515_/A _2617_/B VPWR VGND sg13cmos5l_and2_1
X_3495_ _3495_/Q _3527_/CLK _3495_/D _3495_/RESET_B VPWR VGND sg13cmos5l_dfrbpq_1
X_2446_ _2464_/C _2446_/A _2446_/B _3406_/Q VPWR VGND sg13cmos5l_nand3_1
X_2377_ _2433_/C _2372_/C _2377_/B _2377_/C VPWR VGND sg13cmos5l_nand3b_1
XFILLER_29_506 VPWR VGND sg13cmos5l_fill_2
XFILLER_17_48 VPWR VGND sg13cmos5l_fill_1
XFILLER_24_222 VPWR VGND sg13cmos5l_decap_8
XFILLER_12_428 VPWR VGND sg13cmos5l_decap_4
XFILLER_24_277 VPWR VGND sg13cmos5l_decap_8
XFILLER_40_748 VPWR VGND sg13cmos5l_decap_4
XFILLER_33_36 VPWR VGND sg13cmos5l_decap_8
XFILLER_21_962 VPWR VGND sg13cmos5l_decap_8
XFILLER_32_1006 VPWR VGND sg13cmos5l_decap_8
XFILLER_20_472 VPWR VGND sg13cmos5l_decap_8
XFILLER_3_104 VPWR VGND sg13cmos5l_decap_8
XFILLER_0_833 VPWR VGND sg13cmos5l_decap_8
X_3365__305 _3365_/RESET_B VPWR VGND sg13cmos5l_tiehi
XFILLER_48_859 VPWR VGND sg13cmos5l_decap_8
XFILLER_47_347 VPWR VGND sg13cmos5l_decap_8
XFILLER_47_314 VPWR VGND sg13cmos5l_decap_8
XFILLER_47_358 VPWR VGND sg13cmos5l_fill_1
XFILLER_16_734 VPWR VGND sg13cmos5l_decap_8
XFILLER_16_745 VPWR VGND sg13cmos5l_fill_2
XFILLER_30_214 VPWR VGND sg13cmos5l_decap_8
XFILLER_8_911 VPWR VGND sg13cmos5l_decap_8
X_3335__120 _3335_/D VPWR VGND sg13cmos5l_tielo
XFILLER_8_988 VPWR VGND sg13cmos5l_decap_8
XFILLER_48_1013 VPWR VGND sg13cmos5l_decap_8
X_3280_ _3280_/Q _3355_/CLK _3280_/D _3280_/RESET_B VPWR VGND sg13cmos5l_dfrbpq_1
X_2300_ _2304_/B _2303_/A _2303_/B _2295_/Y _2299_/X VPWR VGND sg13cmos5l_a22oi_1
X_2231_ _2231_/Y _2432_/A _3341_/Q _1849_/Y _3381_/Q VPWR VGND sg13cmos5l_a22oi_1
XFILLER_39_815 VPWR VGND sg13cmos5l_decap_8
XFILLER_39_804 VPWR VGND sg13cmos5l_fill_1
XFILLER_24_4 VPWR VGND sg13cmos5l_decap_8
X_2162_ _2163_/B _2162_/A _2162_/B _2162_/C _2162_/D VPWR VGND sg13cmos5l_nand4_1
X_2093_ _2093_/Y _3330_/Q _3331_/Q _3332_/Q VPWR VGND sg13cmos5l_o21ai_1
XFILLER_19_550 VPWR VGND sg13cmos5l_fill_1
XFILLER_47_892 VPWR VGND sg13cmos5l_decap_8
XFILLER_0_1015 VPWR VGND sg13cmos5l_decap_8
XFILLER_34_531 VPWR VGND sg13cmos5l_fill_2
XFILLER_22_704 VPWR VGND sg13cmos5l_decap_8
X_2995_ _2996_/B _3500_/Q _3000_/B _2981_/Y VPWR VGND sg13cmos5l_a21oi_1
XFILLER_21_247 VPWR VGND sg13cmos5l_decap_8
X_1946_ _1946_/Y _1951_/B _3293_/Q _1943_/Y hold468/X VPWR VGND sg13cmos5l_a22oi_1
X_1877_ _3544_/D _2601_/A _3241_/A VPWR VGND sg13cmos5l_and2_1
X_3547_ _3547_/Q clkload7/A _3547_/D _3547_/RESET_B VPWR VGND sg13cmos5l_dfrbpq_1
XFILLER_1_619 VPWR VGND sg13cmos5l_decap_8
X_3478_ _3478_/Q _3504_/CLK _3478_/D _3478_/RESET_B VPWR VGND sg13cmos5l_dfrbpq_1
X_2429_ _3405_/D _2429_/A _2432_/B VPWR VGND sg13cmos5l_nor2_1
X_3509__370 _3509_/RESET_B VPWR VGND sg13cmos5l_tiehi
XFILLER_29_314 VPWR VGND sg13cmos5l_decap_4
XFILLER_45_829 VPWR VGND sg13cmos5l_decap_4
XFILLER_29_358 VPWR VGND sg13cmos5l_fill_1
XFILLER_44_339 VPWR VGND sg13cmos5l_decap_4
XFILLER_44_328 VPWR VGND sg13cmos5l_fill_2
XFILLER_38_892 VPWR VGND sg13cmos5l_decap_4
XFILLER_44_13 VPWR VGND sg13cmos5l_fill_1
XFILLER_25_542 VPWR VGND sg13cmos5l_fill_1
XFILLER_44_57 VPWR VGND sg13cmos5l_decap_4
XFILLER_25_553 VPWR VGND sg13cmos5l_fill_2
XFILLER_40_512 VPWR VGND sg13cmos5l_decap_4
XFILLER_40_567 VPWR VGND sg13cmos5l_fill_1
XFILLER_5_903 VPWR VGND sg13cmos5l_decap_8
XFILLER_4_435 VPWR VGND sg13cmos5l_fill_2
XFILLER_48_612 VPWR VGND sg13cmos5l_fill_1
XFILLER_48_623 VPWR VGND sg13cmos5l_fill_1
XFILLER_18_80 VPWR VGND sg13cmos5l_decap_8
XFILLER_16_520 VPWR VGND sg13cmos5l_decap_8
XFILLER_16_564 VPWR VGND sg13cmos5l_decap_8
XFILLER_31_523 VPWR VGND sg13cmos5l_decap_8
X_1800_ _1800_/Y _1800_/A VPWR VGND sg13cmos5l_inv_1
XFILLER_15_1001 VPWR VGND sg13cmos5l_decap_8
XFILLER_12_770 VPWR VGND sg13cmos5l_decap_8
X_2780_ _3463_/D _1808_/Y _3118_/A2 _2779_/Y VPWR VGND sg13cmos5l_a21oi_1
X_3401_ _3401_/Q _3463_/CLK _3401_/D _3401_/RESET_B VPWR VGND sg13cmos5l_dfrbpq_1
X_3332_ _3332_/Q _3378_/CLK _3332_/D _3332_/RESET_B VPWR VGND sg13cmos5l_dfrbpq_1
XFILLER_4_980 VPWR VGND sg13cmos5l_decap_8
X_3263_ _3263_/Q clkload8/A _3263_/D _3263_/RESET_B VPWR VGND sg13cmos5l_dfrbpq_1
X_2214_ _2214_/X _2214_/A _2214_/B _2214_/C VPWR VGND sg13cmos5l_and3_1
X_3194_ _3194_/X _3187_/A _3202_/S _3193_/Y VPWR VGND sg13cmos5l_a21o_1
XFILLER_22_1016 VPWR VGND sg13cmos5l_decap_8
XFILLER_39_667 VPWR VGND sg13cmos5l_decap_8
XFILLER_22_1027 VPWR VGND sg13cmos5l_fill_2
X_2145_ _3348_/D _2179_/B _2155_/B VPWR VGND sg13cmos5l_and2_1
XFILLER_38_166 VPWR VGND sg13cmos5l_fill_1
XFILLER_26_317 VPWR VGND sg13cmos5l_decap_4
X_2076_ _2077_/A _1815_/A _2140_/A2 _2019_/B VPWR VGND sg13cmos5l_o21ai_1
XFILLER_35_851 VPWR VGND sg13cmos5l_decap_8
XFILLER_34_361 VPWR VGND sg13cmos5l_decap_8
XFILLER_22_523 VPWR VGND sg13cmos5l_decap_8
XFILLER_34_383 VPWR VGND sg13cmos5l_fill_2
XFILLER_10_718 VPWR VGND sg13cmos5l_decap_4
XFILLER_22_545 VPWR VGND sg13cmos5l_decap_8
X_2978_ _2978_/Y _3009_/A _2978_/B VPWR VGND sg13cmos5l_nand2_1
X_1929_ _3280_/D hold535/X input10/X _1932_/S VPWR VGND sg13cmos5l_mux2_1
Xhold730 hold730/X _3382_/Q VPWR VGND sg13cmos5l_dlygate4sd3_1
XFILLER_2_917 VPWR VGND sg13cmos5l_decap_8
XFILLER_44_103 VPWR VGND sg13cmos5l_fill_1
XFILLER_13_501 VPWR VGND sg13cmos5l_decap_4
XFILLER_41_843 VPWR VGND sg13cmos5l_decap_8
X_3482__98 _3482_/D VPWR VGND sg13cmos5l_tielo
XFILLER_25_383 VPWR VGND sg13cmos5l_decap_8
XFILLER_9_516 VPWR VGND sg13cmos5l_decap_8
XFILLER_41_898 VPWR VGND sg13cmos5l_decap_8
XFILLER_9_527 VPWR VGND sg13cmos5l_fill_2
XFILLER_5_777 VPWR VGND sg13cmos5l_decap_8
XFILLER_45_1005 VPWR VGND sg13cmos5l_decap_8
XFILLER_4_287 VPWR VGND sg13cmos5l_decap_8
XFILLER_49_932 VPWR VGND sg13cmos5l_decap_8
XFILLER_48_442 VPWR VGND sg13cmos5l_decap_4
XFILLER_35_136 VPWR VGND sg13cmos5l_decap_4
XFILLER_17_884 VPWR VGND sg13cmos5l_fill_1
X_2901_ _2901_/Y _2708_/A _2916_/B _2708_/B VPWR VGND sg13cmos5l_o21ai_1
XFILLER_17_895 VPWR VGND sg13cmos5l_decap_8
X_2832_ _2832_/Y _2835_/B VPWR VGND sg13cmos5l_inv_1
XFILLER_32_887 VPWR VGND sg13cmos5l_fill_2
X_2763_ _2763_/Y _2970_/A _2971_/A _2599_/A _2599_/B VPWR VGND sg13cmos5l_a22oi_1
XFILLER_8_593 VPWR VGND sg13cmos5l_decap_8
X_2694_ _2708_/B _3477_/Q _2694_/B VPWR VGND sg13cmos5l_xnor2_1
X_3315__365 _3315_/RESET_B VPWR VGND sg13cmos5l_tiehi
X_3315_ _3315_/Q clkload9/A _3315_/D _3315_/RESET_B VPWR VGND sg13cmos5l_dfrbpq_1
XFILLER_6_1021 VPWR VGND sg13cmos5l_decap_8
X_3246_ _3246_/Y _3246_/A _3255_/B VPWR VGND sg13cmos5l_nor2_1
X_3177_ _3177_/Y _3483_/Q _3487_/Q _3177_/C VPWR VGND sg13cmos5l_nor3_1
X_2128_ _2129_/B _2134_/B _2100_/Y _2134_/A VPWR VGND sg13cmos5l_o21ai_1
X_3541__264 _3541_/RESET_B VPWR VGND sg13cmos5l_tiehi
XFILLER_27_637 VPWR VGND sg13cmos5l_decap_8
X_2059_ _2060_/B _3277_/Q _3260_/Q _3279_/Q _3262_/Q _2063_/A _1868_/B VPWR VGND sg13cmos5l_mux4_1
XFILLER_22_342 VPWR VGND sg13cmos5l_fill_1
XFILLER_41_36 VPWR VGND sg13cmos5l_decap_4
XFILLER_22_397 VPWR VGND sg13cmos5l_decap_8
XFILLER_41_69 VPWR VGND sg13cmos5l_decap_8
XFILLER_2_714 VPWR VGND sg13cmos5l_decap_8
Xhold571 _3250_/B _3540_/Q VPWR VGND sg13cmos5l_dlygate4sd3_1
Xhold560 _1966_/A _3300_/Q VPWR VGND sg13cmos5l_dlygate4sd3_1
Xhold593 _2081_/A _2082_/B VPWR VGND sg13cmos5l_dlygate4sd3_1
Xhold582 _3427_/D _2600_/Y VPWR VGND sg13cmos5l_dlygate4sd3_1
XFILLER_49_217 VPWR VGND sg13cmos5l_decap_8
XFILLER_46_913 VPWR VGND sg13cmos5l_decap_8
XFILLER_18_615 VPWR VGND sg13cmos5l_decap_4
XFILLER_45_467 VPWR VGND sg13cmos5l_fill_1
XFILLER_45_456 VPWR VGND sg13cmos5l_decap_8
XFILLER_25_180 VPWR VGND sg13cmos5l_fill_2
XFILLER_41_695 VPWR VGND sg13cmos5l_decap_8
XFILLER_13_353 VPWR VGND sg13cmos5l_fill_1
XFILLER_13_364 VPWR VGND sg13cmos5l_decap_8
XFILLER_14_887 VPWR VGND sg13cmos5l_fill_2
XFILLER_31_91 VPWR VGND sg13cmos5l_decap_8
X_3100_ _3100_/Y _3536_/Q _3100_/B VPWR VGND sg13cmos5l_nand2b_1
XFILLER_37_902 VPWR VGND sg13cmos5l_decap_8
X_3031_ _3033_/C _3510_/Q _3511_/Q _3512_/Q VPWR VGND sg13cmos5l_o21ai_1
XFILLER_37_979 VPWR VGND sg13cmos5l_decap_8
XFILLER_23_106 VPWR VGND sg13cmos5l_decap_8
XFILLER_36_489 VPWR VGND sg13cmos5l_fill_2
XFILLER_32_684 VPWR VGND sg13cmos5l_decap_8
X_2815_ _2815_/Y _2815_/A _2815_/B VPWR VGND sg13cmos5l_xnor2_1
XFILLER_20_857 VPWR VGND sg13cmos5l_decap_8
XFILLER_11_17 VPWR VGND sg13cmos5l_decap_8
X_2746_ _2746_/Y _3476_/Q _1857_/Y _2586_/A _3475_/Q _2745_/Y VPWR VGND sg13cmos5l_a221oi_1
X_2677_ _2678_/B _3449_/Q _2692_/A VPWR VGND sg13cmos5l_nor2_1
XFILLER_28_1011 VPWR VGND sg13cmos5l_decap_8
X_3229_ _3229_/Y _3229_/A _3225_/Y VPWR VGND sg13cmos5l_nor2b_1
XFILLER_28_913 VPWR VGND sg13cmos5l_decap_8
X_3281__125 _3281_/RESET_B VPWR VGND sg13cmos5l_tiehi
XFILLER_27_423 VPWR VGND sg13cmos5l_decap_4
XFILLER_36_36 VPWR VGND sg13cmos5l_fill_1
XFILLER_43_916 VPWR VGND sg13cmos5l_decap_8
XFILLER_14_106 VPWR VGND sg13cmos5l_fill_1
XFILLER_42_459 VPWR VGND sg13cmos5l_decap_4
XFILLER_11_824 VPWR VGND sg13cmos5l_decap_8
XFILLER_23_673 VPWR VGND sg13cmos5l_decap_8
X_3392__109 _3392_/D VPWR VGND sg13cmos5l_tielo
XFILLER_10_334 VPWR VGND sg13cmos5l_decap_8
XFILLER_23_695 VPWR VGND sg13cmos5l_decap_8
XFILLER_6_349 VPWR VGND sg13cmos5l_decap_8
XFILLER_10_378 VPWR VGND sg13cmos5l_fill_2
XFILLER_7_2 VPWR VGND sg13cmos5l_fill_1
XFILLER_2_544 VPWR VGND sg13cmos5l_decap_8
XFILLER_42_1008 VPWR VGND sg13cmos5l_decap_8
XFILLER_46_765 VPWR VGND sg13cmos5l_decap_8
XFILLER_18_467 VPWR VGND sg13cmos5l_decap_8
XFILLER_33_415 VPWR VGND sg13cmos5l_decap_8
X_2600_ _2600_/Y _2587_/Y hold581/X _2667_/A VPWR VGND sg13cmos5l_a21oi_1
X_2531_ _2535_/B _3409_/Q _3388_/Q _2530_/X VPWR VGND sg13cmos5l_o21ai_1
X_2462_ _2463_/A _2468_/A _2382_/Y _2347_/Y VPWR VGND sg13cmos5l_a21oi_1
XFILLER_5_393 VPWR VGND sg13cmos5l_decap_8
X_2393_ _2395_/B _2250_/Y _2399_/C _2392_/Y VPWR VGND sg13cmos5l_o21ai_1
XFILLER_37_743 VPWR VGND sg13cmos5l_fill_2
XFILLER_37_732 VPWR VGND sg13cmos5l_decap_8
XFILLER_3_1024 VPWR VGND sg13cmos5l_decap_4
X_3014_ _3017_/B _3002_/Y _3008_/Y _3013_/Y VPWR VGND sg13cmos5l_o21ai_1
XFILLER_37_765 VPWR VGND sg13cmos5l_decap_8
XFILLER_36_253 VPWR VGND sg13cmos5l_decap_8
XFILLER_24_404 VPWR VGND sg13cmos5l_fill_1
XFILLER_36_297 VPWR VGND sg13cmos5l_fill_1
XFILLER_20_654 VPWR VGND sg13cmos5l_decap_4
XFILLER_3_308 VPWR VGND sg13cmos5l_fill_2
X_2729_ _2731_/A _2729_/A _2737_/A _2737_/C VPWR VGND sg13cmos5l_nor3_1
XFILLER_3_319 VPWR VGND sg13cmos5l_decap_8
XFILLER_47_35 VPWR VGND sg13cmos5l_fill_2
XFILLER_43_702 VPWR VGND sg13cmos5l_fill_2
XFILLER_43_735 VPWR VGND sg13cmos5l_decap_4
XFILLER_15_415 VPWR VGND sg13cmos5l_decap_8
XFILLER_15_426 VPWR VGND sg13cmos5l_fill_2
XFILLER_27_275 VPWR VGND sg13cmos5l_decap_8
XFILLER_24_982 VPWR VGND sg13cmos5l_decap_8
XFILLER_11_654 VPWR VGND sg13cmos5l_decap_8
XFILLER_11_665 VPWR VGND sg13cmos5l_decap_8
XFILLER_6_113 VPWR VGND sg13cmos5l_decap_8
XFILLER_6_157 VPWR VGND sg13cmos5l_fill_2
XFILLER_12_82 VPWR VGND sg13cmos5l_decap_8
XFILLER_12_93 VPWR VGND sg13cmos5l_fill_1
XFILLER_3_842 VPWR VGND sg13cmos5l_decap_8
XFILLER_2_363 VPWR VGND sg13cmos5l_decap_8
XFILLER_26_8 VPWR VGND sg13cmos5l_fill_1
XFILLER_38_518 VPWR VGND sg13cmos5l_fill_1
XFILLER_38_507 VPWR VGND sg13cmos5l_decap_8
XFILLER_18_286 VPWR VGND sg13cmos5l_decap_8
XFILLER_33_245 VPWR VGND sg13cmos5l_fill_1
X_1962_ _1965_/B _1962_/A _1970_/B VPWR VGND sg13cmos5l_xor2_1
XFILLER_30_941 VPWR VGND sg13cmos5l_decap_8
X_1893_ _2005_/A _1988_/B _1893_/B VPWR VGND sg13cmos5l_nand2b_1
XFILLER_6_680 VPWR VGND sg13cmos5l_fill_2
X_2514_ _2617_/B _2506_/A _2522_/B _2512_/X VPWR VGND sg13cmos5l_o21ai_1
X_3494_ _3494_/Q _3527_/CLK _3494_/D _3494_/RESET_B VPWR VGND sg13cmos5l_dfrbpq_1
X_2445_ _2464_/B _3405_/Q _2459_/B VPWR VGND sg13cmos5l_nand2_1
XFILLER_25_1014 VPWR VGND sg13cmos5l_decap_8
X_2376_ _3388_/D _2383_/A _2376_/B VPWR VGND sg13cmos5l_nor2_1
X_3423__105 _3423_/D VPWR VGND sg13cmos5l_tielo
XFILLER_25_713 VPWR VGND sg13cmos5l_fill_2
XFILLER_37_595 VPWR VGND sg13cmos5l_decap_8
XFILLER_25_746 VPWR VGND sg13cmos5l_fill_2
XFILLER_12_407 VPWR VGND sg13cmos5l_decap_8
XFILLER_13_919 VPWR VGND sg13cmos5l_decap_8
XFILLER_24_256 VPWR VGND sg13cmos5l_decap_8
XFILLER_25_779 VPWR VGND sg13cmos5l_decap_8
XFILLER_33_15 VPWR VGND sg13cmos5l_decap_8
X_3358__313 _3358_/RESET_B VPWR VGND sg13cmos5l_tiehi
XFILLER_21_941 VPWR VGND sg13cmos5l_decap_8
XFILLER_4_617 VPWR VGND sg13cmos5l_decap_4
XFILLER_3_127 VPWR VGND sg13cmos5l_fill_1
XFILLER_0_812 VPWR VGND sg13cmos5l_decap_8
XFILLER_0_889 VPWR VGND sg13cmos5l_decap_8
XFILLER_48_838 VPWR VGND sg13cmos5l_decap_8
XFILLER_15_256 VPWR VGND sg13cmos5l_decap_8
XFILLER_15_267 VPWR VGND sg13cmos5l_fill_1
XFILLER_16_779 VPWR VGND sg13cmos5l_decap_8
X_3302__389 _3302_/RESET_B VPWR VGND sg13cmos5l_tiehi
XFILLER_7_411 VPWR VGND sg13cmos5l_fill_1
XFILLER_12_985 VPWR VGND sg13cmos5l_decap_8
XFILLER_8_967 VPWR VGND sg13cmos5l_decap_8
XFILLER_11_495 VPWR VGND sg13cmos5l_fill_1
XFILLER_23_92 VPWR VGND sg13cmos5l_decap_8
XFILLER_7_477 VPWR VGND sg13cmos5l_fill_1
XFILLER_3_661 VPWR VGND sg13cmos5l_decap_8
X_2230_ _2230_/Y _2359_/A _2237_/B _2228_/Y VPWR VGND sg13cmos5l_o21ai_1
XFILLER_2_171 VPWR VGND sg13cmos5l_decap_8
X_2161_ _2161_/X _2162_/D _2161_/B VPWR VGND sg13cmos5l_or2_1
X_2092_ _2104_/B _3330_/Q _3331_/Q _3332_/Q VPWR VGND sg13cmos5l_nor3_1
XFILLER_47_871 VPWR VGND sg13cmos5l_decap_8
XFILLER_19_573 VPWR VGND sg13cmos5l_decap_8
XFILLER_46_392 VPWR VGND sg13cmos5l_decap_8
XFILLER_0_85 VPWR VGND sg13cmos5l_decap_8
XFILLER_19_595 VPWR VGND sg13cmos5l_decap_8
X_3457__201 _3457_/RESET_B VPWR VGND sg13cmos5l_tiehi
X_2994_ _3012_/A _2994_/A _2994_/B VPWR VGND sg13cmos5l_nor2_1
XFILLER_15_790 VPWR VGND sg13cmos5l_fill_1
XFILLER_21_215 VPWR VGND sg13cmos5l_fill_1
XFILLER_9_61 VPWR VGND sg13cmos5l_decap_8
X_1945_ _1945_/Y _1945_/A input4/X input2/X VPWR VGND sg13cmos5l_nand3_1
XFILLER_30_771 VPWR VGND sg13cmos5l_decap_8
X_1876_ _3241_/A _1876_/A _1886_/A VPWR VGND sg13cmos5l_and2_1
X_3546_ _3546_/Q clkload2/A _3546_/D _3546_/RESET_B VPWR VGND sg13cmos5l_dfrbpq_1
X_3477_ _3477_/Q _3504_/CLK _3477_/D _3477_/RESET_B VPWR VGND sg13cmos5l_dfrbpq_1
X_2428_ _3404_/D _2784_/A _2446_/B VPWR VGND sg13cmos5l_and2_1
X_2359_ _2359_/Y _2359_/A _3361_/Q VPWR VGND sg13cmos5l_nor2b_1
XFILLER_28_26 VPWR VGND sg13cmos5l_decap_8
XFILLER_29_304 VPWR VGND sg13cmos5l_fill_1
XFILLER_29_337 VPWR VGND sg13cmos5l_fill_1
XFILLER_37_370 VPWR VGND sg13cmos5l_decap_8
XFILLER_25_532 VPWR VGND sg13cmos5l_fill_1
XFILLER_13_705 VPWR VGND sg13cmos5l_decap_8
XFILLER_12_204 VPWR VGND sg13cmos5l_decap_4
XFILLER_4_414 VPWR VGND sg13cmos5l_fill_1
XFILLER_5_959 VPWR VGND sg13cmos5l_decap_8
XFILLER_0_664 VPWR VGND sg13cmos5l_decap_4
XFILLER_0_686 VPWR VGND sg13cmos5l_decap_8
XFILLER_28_381 VPWR VGND sg13cmos5l_decap_8
XFILLER_28_392 VPWR VGND sg13cmos5l_fill_1
XFILLER_44_896 VPWR VGND sg13cmos5l_decap_8
XFILLER_8_731 VPWR VGND sg13cmos5l_fill_2
XFILLER_8_742 VPWR VGND sg13cmos5l_decap_8
XFILLER_8_775 VPWR VGND sg13cmos5l_decap_8
X_3400_ _3400_/Q _3463_/CLK _3400_/D _3400_/RESET_B VPWR VGND sg13cmos5l_dfrbpq_1
X_3331_ _3331_/Q _3378_/CLK _3331_/D _3331_/RESET_B VPWR VGND sg13cmos5l_dfrbpq_1
X_3262_ _3262_/Q clkload8/A _3262_/D _3262_/RESET_B VPWR VGND sg13cmos5l_dfrbpq_1
X_3348__323 _3348_/RESET_B VPWR VGND sg13cmos5l_tiehi
X_2213_ _2221_/A _3337_/Q _2214_/B VPWR VGND sg13cmos5l_xnor2_1
XFILLER_38_101 VPWR VGND sg13cmos5l_fill_1
X_3193_ _3193_/Y _3174_/X _3175_/Y _3188_/Y _3190_/Y _3191_/Y VPWR VGND sg13cmos5l_a221oi_1
XFILLER_27_808 VPWR VGND sg13cmos5l_decap_8
XFILLER_27_819 VPWR VGND sg13cmos5l_fill_2
X_2144_ _3347_/D _2179_/B _2144_/B VPWR VGND sg13cmos5l_and2_1
X_2075_ _3322_/D _2140_/A2 _2082_/B _2074_/Y VPWR VGND sg13cmos5l_a21oi_1
XFILLER_34_340 VPWR VGND sg13cmos5l_decap_8
X_3355__316 _3355_/RESET_B VPWR VGND sg13cmos5l_tiehi
X_2977_ _2977_/Y _2881_/B _3005_/A _2976_/Y VPWR VGND sg13cmos5l_o21ai_1
X_1928_ _3279_/D hold502/X input9/X _1932_/S VPWR VGND sg13cmos5l_mux2_1
X_1859_ _2758_/B _1859_/A VPWR VGND sg13cmos5l_inv_1
Xhold720 hold720/X _3414_/Q VPWR VGND sg13cmos5l_dlygate4sd3_1
Xhold731 hold731/X _3336_/Q VPWR VGND sg13cmos5l_dlygate4sd3_1
XFILLER_1_417 VPWR VGND sg13cmos5l_decap_4
X_3529_ _3529_/Q clkload4/A _3529_/D _3529_/RESET_B VPWR VGND sg13cmos5l_dfrbpq_1
X_3362__309 _3362_/RESET_B VPWR VGND sg13cmos5l_tiehi
XFILLER_26_841 VPWR VGND sg13cmos5l_decap_4
XFILLER_29_189 VPWR VGND sg13cmos5l_decap_8
XFILLER_38_1013 VPWR VGND sg13cmos5l_decap_8
XFILLER_41_822 VPWR VGND sg13cmos5l_decap_8
XFILLER_25_362 VPWR VGND sg13cmos5l_decap_8
X_3399__265 _3399_/RESET_B VPWR VGND sg13cmos5l_tiehi
XFILLER_41_877 VPWR VGND sg13cmos5l_decap_8
XFILLER_13_568 VPWR VGND sg13cmos5l_decap_8
XFILLER_40_365 VPWR VGND sg13cmos5l_decap_8
XFILLER_9_539 VPWR VGND sg13cmos5l_decap_8
XFILLER_21_590 VPWR VGND sg13cmos5l_decap_8
XFILLER_4_200 VPWR VGND sg13cmos5l_fill_2
XFILLER_45_1028 VPWR VGND sg13cmos5l_fill_1
X_3447__211 _3447_/RESET_B VPWR VGND sg13cmos5l_tiehi
XFILLER_49_911 VPWR VGND sg13cmos5l_decap_8
XFILLER_1_984 VPWR VGND sg13cmos5l_decap_8
XFILLER_49_988 VPWR VGND sg13cmos5l_decap_8
XFILLER_29_91 VPWR VGND sg13cmos5l_decap_8
XFILLER_29_690 VPWR VGND sg13cmos5l_fill_1
XFILLER_44_671 VPWR VGND sg13cmos5l_fill_1
X_2900_ _2900_/Y _2708_/A _2916_/B _2913_/B _2705_/A VPWR VGND sg13cmos5l_a22oi_1
XFILLER_16_384 VPWR VGND sg13cmos5l_fill_1
XFILLER_16_395 VPWR VGND sg13cmos5l_fill_1
X_3454__204 _3454_/RESET_B VPWR VGND sg13cmos5l_tiehi
X_2831_ _2835_/B _2831_/A _2831_/B VPWR VGND sg13cmos5l_nor2_1
XFILLER_31_354 VPWR VGND sg13cmos5l_fill_2
X_2762_ _2762_/Y _3457_/Q _2760_/Y _2757_/Y VPWR VGND sg13cmos5l_o21ai_1
X_2693_ _2693_/Y _2681_/X _2686_/Y _2708_/A _2691_/A _2692_/X VPWR VGND sg13cmos5l_a221oi_1
X_3314_ _3314_/Q clkload9/A _3314_/D _3314_/RESET_B VPWR VGND sg13cmos5l_dfrbpq_1
XFILLER_39_410 VPWR VGND sg13cmos5l_fill_2
XFILLER_6_1000 VPWR VGND sg13cmos5l_decap_8
X_3245_ _3245_/Y _3250_/B _3245_/B VPWR VGND sg13cmos5l_nand2_1
X_3176_ _3187_/B _3122_/A _3172_/Y _3184_/S VPWR VGND sg13cmos5l_mux2_1
X_2127_ _2129_/A _3340_/Q _2100_/Y _2125_/Y _1851_/A _2126_/Y VPWR VGND sg13cmos5l_a221oi_1
XFILLER_26_104 VPWR VGND sg13cmos5l_fill_1
XFILLER_26_126 VPWR VGND sg13cmos5l_fill_2
XFILLER_26_148 VPWR VGND sg13cmos5l_decap_8
XFILLER_26_159 VPWR VGND sg13cmos5l_fill_2
X_2058_ _3321_/D _2140_/A2 _2083_/B _2057_/Y VPWR VGND sg13cmos5l_a21oi_1
XFILLER_23_822 VPWR VGND sg13cmos5l_fill_1
XFILLER_23_833 VPWR VGND sg13cmos5l_decap_8
XFILLER_41_15 VPWR VGND sg13cmos5l_decap_8
XFILLER_41_59 VPWR VGND sg13cmos5l_fill_1
Xhold550 _3305_/D _1977_/Y VPWR VGND sg13cmos5l_dlygate4sd3_1
Xhold572 _1866_/B _3299_/Q VPWR VGND sg13cmos5l_dlygate4sd3_1
Xhold561 _3300_/D _1969_/Y VPWR VGND sg13cmos5l_dlygate4sd3_1
Xhold583 hold583/X _3314_/Q VPWR VGND sg13cmos5l_dlygate4sd3_1
Xhold594 hold594/X _3295_/Q VPWR VGND sg13cmos5l_dlygate4sd3_1
XFILLER_46_969 VPWR VGND sg13cmos5l_decap_8
XFILLER_14_866 VPWR VGND sg13cmos5l_decap_8
XFILLER_40_140 VPWR VGND sg13cmos5l_decap_4
XFILLER_9_314 VPWR VGND sg13cmos5l_fill_2
XFILLER_12_1027 VPWR VGND sg13cmos5l_fill_2
XFILLER_5_520 VPWR VGND sg13cmos5l_decap_8
XFILLER_5_564 VPWR VGND sg13cmos5l_fill_2
XFILLER_1_781 VPWR VGND sg13cmos5l_decap_8
XFILLER_49_785 VPWR VGND sg13cmos5l_decap_8
XFILLER_48_262 VPWR VGND sg13cmos5l_fill_1
X_3030_ _3045_/B _3512_/Q _3510_/Q _3511_/Q VPWR VGND sg13cmos5l_or3_1
XFILLER_37_958 VPWR VGND sg13cmos5l_decap_8
XFILLER_36_435 VPWR VGND sg13cmos5l_decap_8
XFILLER_36_446 VPWR VGND sg13cmos5l_fill_2
XFILLER_45_991 VPWR VGND sg13cmos5l_decap_8
XFILLER_16_170 VPWR VGND sg13cmos5l_decap_8
X_2814_ _2815_/B _2820_/A _2820_/B _2799_/Y VPWR VGND sg13cmos5l_a21oi_1
X_2745_ _2745_/Y _2969_/A _3426_/Q _3425_/Q _2968_/A _2744_/Y VPWR VGND sg13cmos5l_a221oi_1
X_3352__319 _3352_/RESET_B VPWR VGND sg13cmos5l_tiehi
X_2676_ _2692_/A _3448_/Q _3446_/Q _3447_/Q VPWR VGND sg13cmos5l_or3_1
X_3389__275 _3389_/RESET_B VPWR VGND sg13cmos5l_tiehi
X_3228_ _3229_/A _3228_/A _3237_/A VPWR VGND sg13cmos5l_nand2_1
XFILLER_28_903 VPWR VGND sg13cmos5l_decap_4
XFILLER_39_284 VPWR VGND sg13cmos5l_decap_4
X_3159_ _3177_/C _3486_/Q _3485_/Q _3483_/Q _3484_/Q VPWR VGND sg13cmos5l_nor4_1
XFILLER_28_969 VPWR VGND sg13cmos5l_decap_8
XFILLER_42_416 VPWR VGND sg13cmos5l_decap_8
XFILLER_36_980 VPWR VGND sg13cmos5l_decap_8
XFILLER_23_652 VPWR VGND sg13cmos5l_decap_8
XFILLER_23_663 VPWR VGND sg13cmos5l_fill_1
X_3396__268 _3396_/RESET_B VPWR VGND sg13cmos5l_tiehi
XFILLER_22_184 VPWR VGND sg13cmos5l_fill_1
X_3437__221 _3437_/RESET_B VPWR VGND sg13cmos5l_tiehi
XFILLER_7_829 VPWR VGND sg13cmos5l_decap_8
XFILLER_6_328 VPWR VGND sg13cmos5l_decap_8
XFILLER_2_512 VPWR VGND sg13cmos5l_decap_8
X_3444__214 _3444_/RESET_B VPWR VGND sg13cmos5l_tiehi
XFILLER_46_744 VPWR VGND sg13cmos5l_decap_8
XFILLER_46_722 VPWR VGND sg13cmos5l_fill_2
XFILLER_19_969 VPWR VGND sg13cmos5l_decap_8
XFILLER_34_906 VPWR VGND sg13cmos5l_decap_4
XFILLER_45_265 VPWR VGND sg13cmos5l_decap_8
XFILLER_33_405 VPWR VGND sg13cmos5l_decap_4
XFILLER_33_438 VPWR VGND sg13cmos5l_decap_8
XFILLER_41_460 VPWR VGND sg13cmos5l_decap_8
XFILLER_42_994 VPWR VGND sg13cmos5l_decap_8
XFILLER_41_471 VPWR VGND sg13cmos5l_fill_2
XFILLER_13_162 VPWR VGND sg13cmos5l_decap_8
XFILLER_14_696 VPWR VGND sg13cmos5l_decap_8
XFILLER_9_166 VPWR VGND sg13cmos5l_decap_4
XFILLER_42_91 VPWR VGND sg13cmos5l_decap_8
X_3451__207 _3451_/RESET_B VPWR VGND sg13cmos5l_tiehi
XFILLER_10_891 VPWR VGND sg13cmos5l_decap_8
X_2530_ _2530_/X _3389_/Q _3388_/Q VPWR VGND sg13cmos5l_xor2_1
X_2461_ _2461_/Y _2456_/Y _2475_/A _2460_/Y VPWR VGND sg13cmos5l_o21ai_1
XFILLER_6_895 VPWR VGND sg13cmos5l_decap_8
XFILLER_47_4 VPWR VGND sg13cmos5l_fill_2
X_3312__369 _3312_/RESET_B VPWR VGND sg13cmos5l_tiehi
X_2392_ _2392_/Y _3413_/Q _2399_/C _3411_/Q VPWR VGND sg13cmos5l_nand3b_1
XFILLER_49_560 VPWR VGND sg13cmos5l_decap_8
XFILLER_3_1003 VPWR VGND sg13cmos5l_decap_8
XFILLER_3_85 VPWR VGND sg13cmos5l_decap_8
X_3013_ _3013_/Y _3004_/Y _3006_/Y _3009_/Y _3012_/Y VPWR VGND sg13cmos5l_a22oi_1
XFILLER_40_909 VPWR VGND sg13cmos5l_decap_8
Xclkbuf_leaf_16_clk _3485_/CLK clkbuf_2_2__f_clk/X VPWR VGND sg13cmos5l_buf_8
XFILLER_33_994 VPWR VGND sg13cmos5l_decap_8
X_3391__110 _3391_/D VPWR VGND sg13cmos5l_tielo
XFILLER_20_688 VPWR VGND sg13cmos5l_decap_4
XFILLER_20_699 VPWR VGND sg13cmos5l_fill_1
X_2728_ _2728_/Y _2728_/A _2728_/B VPWR VGND sg13cmos5l_nand2_1
X_2659_ _2659_/Y _2659_/A VPWR VGND sg13cmos5l_inv_1
XFILLER_47_519 VPWR VGND sg13cmos5l_decap_8
XFILLER_28_700 VPWR VGND sg13cmos5l_decap_8
XFILLER_47_47 VPWR VGND sg13cmos5l_decap_4
XFILLER_16_906 VPWR VGND sg13cmos5l_decap_8
XFILLER_28_777 VPWR VGND sg13cmos5l_decap_4
XFILLER_15_405 VPWR VGND sg13cmos5l_decap_4
XFILLER_16_939 VPWR VGND sg13cmos5l_decap_8
XFILLER_27_265 VPWR VGND sg13cmos5l_decap_4
XFILLER_28_788 VPWR VGND sg13cmos5l_fill_1
XFILLER_31_909 VPWR VGND sg13cmos5l_fill_2
XFILLER_24_961 VPWR VGND sg13cmos5l_decap_8
XFILLER_8_19 VPWR VGND sg13cmos5l_decap_8
XFILLER_10_176 VPWR VGND sg13cmos5l_fill_1
XFILLER_12_50 VPWR VGND sg13cmos5l_fill_1
XFILLER_3_821 VPWR VGND sg13cmos5l_decap_8
XFILLER_5_0 VPWR VGND sg13cmos5l_fill_1
XFILLER_3_898 VPWR VGND sg13cmos5l_decap_8
XFILLER_19_766 VPWR VGND sg13cmos5l_decap_4
XFILLER_18_265 VPWR VGND sg13cmos5l_decap_8
XFILLER_19_799 VPWR VGND sg13cmos5l_fill_2
XFILLER_33_268 VPWR VGND sg13cmos5l_decap_8
X_3379__285 _3379_/RESET_B VPWR VGND sg13cmos5l_tiehi
XFILLER_15_994 VPWR VGND sg13cmos5l_decap_8
X_1961_ _1961_/X _1962_/A _1970_/B VPWR VGND sg13cmos5l_and2_1
X_1892_ _1996_/B _1884_/B _3545_/Q VPWR VGND sg13cmos5l_nand2b_1
XFILLER_30_997 VPWR VGND sg13cmos5l_decap_8
X_2513_ _2617_/A _2513_/A _2513_/B _2513_/C VPWR VGND sg13cmos5l_nand3_1
X_3493_ _3493_/Q clkload3/A _3493_/D _3493_/RESET_B VPWR VGND sg13cmos5l_dfrbpq_1
Xclkbuf_leaf_5_clk clkload8/A clkload0/A VPWR VGND sg13cmos5l_buf_8
X_2444_ _2464_/A _3407_/Q _2459_/B VPWR VGND sg13cmos5l_xnor2_1
X_2375_ _2434_/B _2371_/X _2373_/Y _2372_/Y VPWR VGND sg13cmos5l_a21o_1
X_3386__278 _3386_/RESET_B VPWR VGND sg13cmos5l_tiehi
XFILLER_49_390 VPWR VGND sg13cmos5l_fill_1
XFILLER_17_39 VPWR VGND sg13cmos5l_decap_8
XFILLER_24_235 VPWR VGND sg13cmos5l_decap_8
XFILLER_40_706 VPWR VGND sg13cmos5l_decap_4
XFILLER_21_997 VPWR VGND sg13cmos5l_decap_8
X_3434__224 _3434_/RESET_B VPWR VGND sg13cmos5l_tiehi
XFILLER_3_139 VPWR VGND sg13cmos5l_decap_8
XFILLER_48_817 VPWR VGND sg13cmos5l_decap_8
XFILLER_0_868 VPWR VGND sg13cmos5l_decap_8
X_3441__217 _3441_/RESET_B VPWR VGND sg13cmos5l_tiehi
XFILLER_15_202 VPWR VGND sg13cmos5l_fill_1
XFILLER_15_235 VPWR VGND sg13cmos5l_decap_8
XFILLER_31_706 VPWR VGND sg13cmos5l_fill_1
XFILLER_43_599 VPWR VGND sg13cmos5l_decap_4
XFILLER_15_279 VPWR VGND sg13cmos5l_decap_8
XFILLER_24_780 VPWR VGND sg13cmos5l_fill_2
XFILLER_12_964 VPWR VGND sg13cmos5l_decap_8
XFILLER_8_946 VPWR VGND sg13cmos5l_decap_8
XFILLER_11_463 VPWR VGND sg13cmos5l_decap_8
XFILLER_7_434 VPWR VGND sg13cmos5l_fill_2
XFILLER_2_150 VPWR VGND sg13cmos5l_decap_8
X_2160_ _2161_/B _2160_/A _2160_/B VPWR VGND sg13cmos5l_nor2_1
XFILLER_47_850 VPWR VGND sg13cmos5l_decap_8
X_2091_ _2214_/A _3354_/Q _2123_/B VPWR VGND sg13cmos5l_xnor2_1
XFILLER_0_53 VPWR VGND sg13cmos5l_decap_8
XFILLER_34_533 VPWR VGND sg13cmos5l_fill_1
X_2993_ _2994_/B _3504_/Q _3015_/B _3015_/C _2992_/Y VPWR VGND sg13cmos5l_a22oi_1
X_1944_ _1953_/B input4/X input2/X VPWR VGND sg13cmos5l_nand2_1
X_3492__159 _3492_/RESET_B VPWR VGND sg13cmos5l_tiehi
X_1875_ _2001_/A _1886_/A VPWR VGND sg13cmos5l_inv_1
XFILLER_7_990 VPWR VGND sg13cmos5l_decap_8
X_3545_ _3545_/Q clkload2/A _3545_/D _3545_/RESET_B VPWR VGND sg13cmos5l_dfrbpq_1
X_3476_ _3476_/Q _3504_/CLK _3476_/D _3476_/RESET_B VPWR VGND sg13cmos5l_dfrbpq_1
X_2427_ _3403_/D _2427_/A _2427_/B VPWR VGND sg13cmos5l_and2_1
X_2358_ _2364_/B _3363_/Q _2358_/B VPWR VGND sg13cmos5l_xnor2_1
X_2289_ _2289_/Y _2288_/B _2289_/B VPWR VGND sg13cmos5l_nand2b_1
XFILLER_29_349 VPWR VGND sg13cmos5l_decap_8
XFILLER_25_555 VPWR VGND sg13cmos5l_fill_1
XFILLER_13_739 VPWR VGND sg13cmos5l_fill_2
XFILLER_21_750 VPWR VGND sg13cmos5l_fill_1
XFILLER_21_783 VPWR VGND sg13cmos5l_fill_1
XFILLER_5_938 VPWR VGND sg13cmos5l_decap_8
XFILLER_4_459 VPWR VGND sg13cmos5l_decap_8
XFILLER_0_643 VPWR VGND sg13cmos5l_decap_8
XFILLER_48_658 VPWR VGND sg13cmos5l_decap_8
XFILLER_47_135 VPWR VGND sg13cmos5l_fill_2
XFILLER_47_124 VPWR VGND sg13cmos5l_fill_1
XFILLER_36_809 VPWR VGND sg13cmos5l_decap_8
XFILLER_47_179 VPWR VGND sg13cmos5l_fill_2
XFILLER_16_500 VPWR VGND sg13cmos5l_decap_8
XFILLER_28_360 VPWR VGND sg13cmos5l_decap_8
XFILLER_29_872 VPWR VGND sg13cmos5l_fill_1
XFILLER_44_875 VPWR VGND sg13cmos5l_decap_8
XFILLER_8_721 VPWR VGND sg13cmos5l_fill_1
XFILLER_12_750 VPWR VGND sg13cmos5l_decap_8
XFILLER_11_293 VPWR VGND sg13cmos5l_decap_8
X_3376__288 _3376_/RESET_B VPWR VGND sg13cmos5l_tiehi
X_3330_ _3330_/Q _3378_/CLK _3330_/D _3330_/RESET_B VPWR VGND sg13cmos5l_dfrbpq_1
X_3261_ _3261_/Q clkload7/A _3261_/D _3261_/RESET_B VPWR VGND sg13cmos5l_dfrbpq_1
X_2212_ _2212_/Y _2209_/Y _2210_/Y _2211_/Y _3353_/Q VPWR VGND sg13cmos5l_a22oi_1
X_3192_ _3202_/S _3188_/Y _3190_/Y _3191_/Y VPWR VGND sg13cmos5l_a21o_1
X_2143_ _3346_/D _2179_/B _2143_/B VPWR VGND sg13cmos5l_and2_1
X_2074_ _2074_/Y _2082_/A _2140_/A2 _2019_/B VPWR VGND sg13cmos5l_o21ai_1
XFILLER_35_886 VPWR VGND sg13cmos5l_fill_1
X_2976_ _2976_/Y _2976_/A _3009_/B VPWR VGND sg13cmos5l_nand2_1
X_1927_ _3278_/D hold507/X input8/X _1932_/S VPWR VGND sg13cmos5l_mux2_1
X_1858_ _2586_/A _3426_/Q VPWR VGND sg13cmos5l_inv_1
Xhold710 _2678_/A _3450_/Q VPWR VGND sg13cmos5l_dlygate4sd3_1
Xhold721 _2510_/B _2618_/B VPWR VGND sg13cmos5l_dlygate4sd3_1
Xhold732 _2187_/B _3357_/Q VPWR VGND sg13cmos5l_dlygate4sd3_1
X_3528_ _3528_/Q clkload3/A _3528_/D _3528_/RESET_B VPWR VGND sg13cmos5l_dfrbpq_1
X_3459_ _3459_/Q _3527_/CLK _3459_/D _3459_/RESET_B VPWR VGND sg13cmos5l_dfrbpq_1
XFILLER_17_319 VPWR VGND sg13cmos5l_decap_4
XFILLER_29_146 VPWR VGND sg13cmos5l_decap_8
XFILLER_44_127 VPWR VGND sg13cmos5l_fill_2
XFILLER_41_801 VPWR VGND sg13cmos5l_decap_8
XFILLER_40_311 VPWR VGND sg13cmos5l_decap_8
XFILLER_13_525 VPWR VGND sg13cmos5l_fill_1
XFILLER_40_344 VPWR VGND sg13cmos5l_decap_8
XFILLER_5_702 VPWR VGND sg13cmos5l_decap_8
XFILLER_5_746 VPWR VGND sg13cmos5l_decap_8
XFILLER_4_223 VPWR VGND sg13cmos5l_decap_8
XFILLER_4_212 VPWR VGND sg13cmos5l_fill_1
XFILLER_4_256 VPWR VGND sg13cmos5l_decap_8
XFILLER_1_963 VPWR VGND sg13cmos5l_decap_8
XFILLER_0_473 VPWR VGND sg13cmos5l_decap_4
XFILLER_49_967 VPWR VGND sg13cmos5l_decap_8
XFILLER_45_80 VPWR VGND sg13cmos5l_decap_4
XFILLER_16_363 VPWR VGND sg13cmos5l_decap_8
XFILLER_32_834 VPWR VGND sg13cmos5l_decap_8
X_2830_ _2831_/B _2830_/A _2830_/B VPWR VGND sg13cmos5l_xnor2_1
XFILLER_31_377 VPWR VGND sg13cmos5l_decap_8
XFILLER_12_591 VPWR VGND sg13cmos5l_decap_8
X_2761_ _2761_/Y hold604/X _2752_/Y _2760_/Y _3457_/Q VPWR VGND sg13cmos5l_a22oi_1
X_2692_ _2692_/X _2692_/A _2692_/B _2705_/A VPWR VGND sg13cmos5l_and3_1
X_3313_ _3313_/Q _3551_/CLK _3313_/D _3313_/RESET_B VPWR VGND sg13cmos5l_dfrbpq_1
X_3244_ _3245_/B _3255_/A _3255_/B VPWR VGND sg13cmos5l_nand2_1
XFILLER_39_444 VPWR VGND sg13cmos5l_fill_2
XFILLER_39_422 VPWR VGND sg13cmos5l_fill_2
XFILLER_39_455 VPWR VGND sg13cmos5l_fill_2
X_3175_ _3175_/Y _3172_/Y _3180_/A VPWR VGND sg13cmos5l_nand2b_1
X_3361__310 _3361_/RESET_B VPWR VGND sg13cmos5l_tiehi
X_2126_ _2126_/Y _2237_/B _2126_/B VPWR VGND sg13cmos5l_nor2_1
X_2057_ _2057_/Y _2083_/A _2140_/A2 _2601_/A VPWR VGND sg13cmos5l_o21ai_1
XFILLER_35_683 VPWR VGND sg13cmos5l_decap_8
XFILLER_23_889 VPWR VGND sg13cmos5l_decap_4
X_2959_ _3494_/D _1797_/Y _2962_/A2 _2958_/Y VPWR VGND sg13cmos5l_a21oi_1
Xhold551 hold551/X _3265_/Q VPWR VGND sg13cmos5l_dlygate4sd3_1
XFILLER_2_749 VPWR VGND sg13cmos5l_decap_8
Xhold562 _2970_/A _3476_/Q VPWR VGND sg13cmos5l_dlygate4sd3_1
Xhold540 _3344_/D _2140_/Y VPWR VGND sg13cmos5l_dlygate4sd3_1
Xhold573 hold573/X _3304_/Q VPWR VGND sg13cmos5l_dlygate4sd3_1
Xhold595 _2578_/A _3443_/Q VPWR VGND sg13cmos5l_dlygate4sd3_1
Xhold584 _1864_/A _3393_/Q VPWR VGND sg13cmos5l_dlygate4sd3_1
XFILLER_46_948 VPWR VGND sg13cmos5l_decap_8
XFILLER_17_127 VPWR VGND sg13cmos5l_decap_8
XFILLER_14_845 VPWR VGND sg13cmos5l_decap_8
XFILLER_25_193 VPWR VGND sg13cmos5l_fill_1
XFILLER_13_344 VPWR VGND sg13cmos5l_decap_8
XFILLER_15_72 VPWR VGND sg13cmos5l_decap_8
XFILLER_15_83 VPWR VGND sg13cmos5l_fill_2
XFILLER_13_388 VPWR VGND sg13cmos5l_fill_1
XFILLER_13_399 VPWR VGND sg13cmos5l_decap_8
XFILLER_40_196 VPWR VGND sg13cmos5l_decap_4
XFILLER_12_1006 VPWR VGND sg13cmos5l_decap_8
XFILLER_5_598 VPWR VGND sg13cmos5l_fill_1
XFILLER_1_760 VPWR VGND sg13cmos5l_decap_8
XFILLER_49_764 VPWR VGND sg13cmos5l_decap_8
X_3345__327 _3345_/RESET_B VPWR VGND sg13cmos5l_tiehi
XFILLER_37_937 VPWR VGND sg13cmos5l_decap_8
XFILLER_36_469 VPWR VGND sg13cmos5l_decap_8
XFILLER_45_970 VPWR VGND sg13cmos5l_decap_8
XFILLER_17_683 VPWR VGND sg13cmos5l_decap_4
XFILLER_32_631 VPWR VGND sg13cmos5l_decap_4
XFILLER_31_141 VPWR VGND sg13cmos5l_decap_4
X_2813_ _2831_/A _2813_/A _2813_/B VPWR VGND sg13cmos5l_nor2_1
XFILLER_20_837 VPWR VGND sg13cmos5l_fill_2
XFILLER_8_381 VPWR VGND sg13cmos5l_fill_2
XFILLER_9_893 VPWR VGND sg13cmos5l_decap_8
X_2744_ _2744_/Y _3474_/Q _2758_/B _2749_/B _3473_/Q VPWR VGND sg13cmos5l_a22oi_1
X_2675_ _2675_/Y _2957_/B _2966_/A VPWR VGND sg13cmos5l_nand2b_1
X_3227_ _3237_/A _2006_/B _3226_/Y _1986_/X VPWR VGND sg13cmos5l_a21oi_1
X_3158_ _3158_/X _2849_/Y _3183_/A _3154_/Y VPWR VGND sg13cmos5l_a21o_1
XFILLER_28_948 VPWR VGND sg13cmos5l_decap_8
XFILLER_36_16 VPWR VGND sg13cmos5l_decap_8
X_2109_ _2109_/Y _2263_/A _2216_/A VPWR VGND sg13cmos5l_nand2_1
XFILLER_27_458 VPWR VGND sg13cmos5l_decap_8
X_3089_ _3089_/Y _3089_/A _3089_/B VPWR VGND sg13cmos5l_nor2_1
XFILLER_35_1028 VPWR VGND sg13cmos5l_fill_1
XFILLER_10_303 VPWR VGND sg13cmos5l_decap_4
XFILLER_7_808 VPWR VGND sg13cmos5l_decap_8
XFILLER_11_859 VPWR VGND sg13cmos5l_decap_8
XFILLER_22_196 VPWR VGND sg13cmos5l_decap_8
XFILLER_2_502 VPWR VGND sg13cmos5l_decap_4
XFILLER_2_557 VPWR VGND sg13cmos5l_decap_8
XFILLER_19_926 VPWR VGND sg13cmos5l_fill_1
XFILLER_19_948 VPWR VGND sg13cmos5l_decap_8
XFILLER_34_918 VPWR VGND sg13cmos5l_decap_8
XFILLER_45_299 VPWR VGND sg13cmos5l_decap_8
XFILLER_14_631 VPWR VGND sg13cmos5l_decap_4
XFILLER_42_973 VPWR VGND sg13cmos5l_decap_8
XFILLER_13_141 VPWR VGND sg13cmos5l_decap_8
XFILLER_41_494 VPWR VGND sg13cmos5l_decap_8
XFILLER_9_123 VPWR VGND sg13cmos5l_decap_8
XFILLER_9_145 VPWR VGND sg13cmos5l_decap_8
XFILLER_10_870 VPWR VGND sg13cmos5l_decap_8
X_3351__320 _3351_/RESET_B VPWR VGND sg13cmos5l_tiehi
X_2460_ _2460_/Y _2465_/B _2459_/X _2439_/X VPWR VGND sg13cmos5l_a21oi_1
XFILLER_6_874 VPWR VGND sg13cmos5l_decap_8
X_2391_ _2399_/C _3413_/Q _2390_/Y _2389_/Y VPWR VGND sg13cmos5l_o21ai_1
XFILLER_3_97 VPWR VGND sg13cmos5l_decap_8
X_3012_ _3012_/Y _3012_/A _3012_/B VPWR VGND sg13cmos5l_nor2_1
XFILLER_18_981 VPWR VGND sg13cmos5l_decap_8
XFILLER_24_439 VPWR VGND sg13cmos5l_fill_1
XFILLER_36_288 VPWR VGND sg13cmos5l_fill_2
XFILLER_33_973 VPWR VGND sg13cmos5l_decap_8
XFILLER_20_667 VPWR VGND sg13cmos5l_decap_8
X_2727_ _2728_/B _2723_/X _2724_/Y _2725_/Y VPWR VGND sg13cmos5l_a21o_1
X_2658_ _2659_/A _2658_/A _2658_/B VPWR VGND sg13cmos5l_nor2_1
X_2589_ _2591_/B _2584_/Y _2585_/Y _2588_/Y VPWR VGND sg13cmos5l_o21ai_1
XFILLER_41_1010 VPWR VGND sg13cmos5l_decap_8
XFILLER_27_244 VPWR VGND sg13cmos5l_decap_8
XFILLER_24_940 VPWR VGND sg13cmos5l_decap_8
XFILLER_30_409 VPWR VGND sg13cmos5l_decap_8
XFILLER_7_616 VPWR VGND sg13cmos5l_decap_8
XFILLER_12_62 VPWR VGND sg13cmos5l_decap_8
XFILLER_3_800 VPWR VGND sg13cmos5l_decap_8
XFILLER_3_877 VPWR VGND sg13cmos5l_decap_8
XFILLER_2_354 VPWR VGND sg13cmos5l_decap_4
XFILLER_18_222 VPWR VGND sg13cmos5l_decap_8
XFILLER_46_586 VPWR VGND sg13cmos5l_decap_8
XFILLER_37_70 VPWR VGND sg13cmos5l_fill_2
XFILLER_18_244 VPWR VGND sg13cmos5l_decap_8
XFILLER_34_726 VPWR VGND sg13cmos5l_decap_4
XFILLER_34_759 VPWR VGND sg13cmos5l_fill_2
XFILLER_15_973 VPWR VGND sg13cmos5l_decap_8
X_1960_ _3298_/D _3239_/A _1960_/B VPWR VGND sg13cmos5l_nor2_1
XFILLER_18_1023 VPWR VGND sg13cmos5l_decap_4
XFILLER_30_921 VPWR VGND sg13cmos5l_decap_8
XFILLER_14_494 VPWR VGND sg13cmos5l_decap_8
X_1891_ _3548_/D _1891_/A VPWR VGND sg13cmos5l_inv_1
XFILLER_30_976 VPWR VGND sg13cmos5l_decap_8
XFILLER_6_660 VPWR VGND sg13cmos5l_fill_1
X_2512_ _2512_/X _2787_/A _2521_/B VPWR VGND sg13cmos5l_and2_1
X_3492_ _3492_/Q _3539_/CLK _3492_/D _3492_/RESET_B VPWR VGND sg13cmos5l_dfrbpq_1
X_2443_ _2459_/B _2441_/Y _2442_/Y _2440_/Y VPWR VGND sg13cmos5l_a21oi_1
X_2374_ _2376_/B _2371_/X _2373_/Y hold699/X VPWR VGND sg13cmos5l_a21oi_1
XFILLER_37_542 VPWR VGND sg13cmos5l_fill_2
XFILLER_24_203 VPWR VGND sg13cmos5l_fill_2
XFILLER_32_291 VPWR VGND sg13cmos5l_decap_8
XFILLER_21_976 VPWR VGND sg13cmos5l_decap_8
XFILLER_3_118 VPWR VGND sg13cmos5l_decap_8
XFILLER_0_847 VPWR VGND sg13cmos5l_decap_8
XFILLER_28_542 VPWR VGND sg13cmos5l_decap_4
XFILLER_43_523 VPWR VGND sg13cmos5l_fill_2
XFILLER_28_586 VPWR VGND sg13cmos5l_decap_8
XFILLER_11_442 VPWR VGND sg13cmos5l_decap_8
XFILLER_12_943 VPWR VGND sg13cmos5l_decap_8
XFILLER_23_280 VPWR VGND sg13cmos5l_fill_1
XFILLER_8_925 VPWR VGND sg13cmos5l_decap_8
XFILLER_11_475 VPWR VGND sg13cmos5l_fill_2
XFILLER_11_486 VPWR VGND sg13cmos5l_decap_8
XFILLER_48_1027 VPWR VGND sg13cmos5l_fill_2
XFILLER_3_641 VPWR VGND sg13cmos5l_decap_4
XFILLER_3_674 VPWR VGND sg13cmos5l_decap_8
XFILLER_39_829 VPWR VGND sg13cmos5l_fill_1
XFILLER_38_306 VPWR VGND sg13cmos5l_decap_8
X_2090_ _2101_/B _3354_/Q _2123_/B VPWR VGND sg13cmos5l_nor2_1
XFILLER_38_339 VPWR VGND sg13cmos5l_decap_8
XFILLER_0_21 VPWR VGND sg13cmos5l_decap_8
X_2992_ _2992_/Y _3503_/Q _3000_/B VPWR VGND sg13cmos5l_nand2_1
XFILLER_22_729 VPWR VGND sg13cmos5l_decap_8
X_1943_ _1943_/Y _1951_/B input2/X VPWR VGND sg13cmos5l_nor2_1
X_1874_ _1886_/A _1874_/A _3250_/A _3250_/B VPWR VGND sg13cmos5l_nor3_1
XFILLER_30_795 VPWR VGND sg13cmos5l_decap_8
X_3392__272 _3392_/RESET_B VPWR VGND sg13cmos5l_tiehi
X_3544_ _3544_/Q _3551_/CLK _3544_/D _3544_/RESET_B VPWR VGND sg13cmos5l_dfrbpq_1
X_3475_ _3475_/Q _3504_/CLK _3475_/D _3475_/RESET_B VPWR VGND sg13cmos5l_dfrbpq_1
X_2426_ _3402_/D _2776_/A _2426_/B VPWR VGND sg13cmos5l_and2_1
X_2357_ _2371_/A _2369_/A _2372_/B VPWR VGND sg13cmos5l_and2_1
X_2288_ _2288_/Y _2289_/B _2288_/B VPWR VGND sg13cmos5l_nand2b_1
XFILLER_44_309 VPWR VGND sg13cmos5l_fill_2
XFILLER_38_851 VPWR VGND sg13cmos5l_fill_1
XFILLER_37_394 VPWR VGND sg13cmos5l_decap_8
XFILLER_13_729 VPWR VGND sg13cmos5l_fill_2
XFILLER_21_740 VPWR VGND sg13cmos5l_fill_2
XFILLER_21_762 VPWR VGND sg13cmos5l_decap_8
X_3301__391 _3301_/RESET_B VPWR VGND sg13cmos5l_tiehi
XFILLER_20_283 VPWR VGND sg13cmos5l_fill_1
XFILLER_5_917 VPWR VGND sg13cmos5l_decap_8
XFILLER_0_622 VPWR VGND sg13cmos5l_decap_8
XFILLER_29_840 VPWR VGND sg13cmos5l_fill_1
XFILLER_47_158 VPWR VGND sg13cmos5l_decap_8
XFILLER_44_832 VPWR VGND sg13cmos5l_decap_8
XFILLER_18_72 VPWR VGND sg13cmos5l_decap_4
XFILLER_29_895 VPWR VGND sg13cmos5l_decap_8
XFILLER_43_342 VPWR VGND sg13cmos5l_decap_8
XFILLER_16_578 VPWR VGND sg13cmos5l_fill_2
XFILLER_16_589 VPWR VGND sg13cmos5l_decap_8
XFILLER_34_82 VPWR VGND sg13cmos5l_decap_8
XFILLER_15_1015 VPWR VGND sg13cmos5l_decap_8
XFILLER_12_784 VPWR VGND sg13cmos5l_decap_8
XFILLER_4_994 VPWR VGND sg13cmos5l_decap_8
X_3260_ _3260_/Q clkload8/A _3260_/D _3260_/RESET_B VPWR VGND sg13cmos5l_dfrbpq_1
X_2211_ _2211_/Y _3334_/Q _3335_/Q VPWR VGND sg13cmos5l_xnor2_1
X_3191_ _3191_/Y _3205_/A _3204_/B _3212_/A VPWR VGND sg13cmos5l_o21ai_1
XFILLER_22_4 VPWR VGND sg13cmos5l_fill_1
XFILLER_38_136 VPWR VGND sg13cmos5l_decap_8
X_2142_ _2142_/Y _2084_/A _3119_/A2 _2141_/Y VPWR VGND sg13cmos5l_a21oi_1
X_2073_ _2082_/B _2060_/X _2065_/Y _2072_/Y hold592/X VPWR VGND sg13cmos5l_a22oi_1
XFILLER_47_670 VPWR VGND sg13cmos5l_decap_8
XFILLER_19_383 VPWR VGND sg13cmos5l_decap_8
XFILLER_35_821 VPWR VGND sg13cmos5l_decap_8
XFILLER_22_559 VPWR VGND sg13cmos5l_fill_2
X_2975_ _2975_/Y _2881_/B _3005_/A _2972_/Y _2973_/Y _2974_/Y VPWR VGND sg13cmos5l_a221oi_1
X_1926_ _3277_/D hold506/X input7/X _1932_/S VPWR VGND sg13cmos5l_mux2_1
X_1857_ _1857_/Y _3427_/Q VPWR VGND sg13cmos5l_inv_1
Xhold700 _2854_/B _3478_/Q VPWR VGND sg13cmos5l_dlygate4sd3_1
Xhold711 _3147_/A _3527_/Q VPWR VGND sg13cmos5l_dlygate4sd3_1
Xhold722 _2283_/A _3378_/Q VPWR VGND sg13cmos5l_dlygate4sd3_1
Xhold733 _2905_/A _3451_/Q VPWR VGND sg13cmos5l_dlygate4sd3_1
X_3527_ _3527_/Q _3527_/CLK _3527_/D _3527_/RESET_B VPWR VGND sg13cmos5l_dfrbpq_1
X_3458_ _3458_/Q _3527_/CLK _3458_/D _3458_/RESET_B VPWR VGND sg13cmos5l_dfrbpq_1
X_2409_ _2409_/Y _2409_/A _2415_/S VPWR VGND sg13cmos5l_nand2_1
X_3389_ _3389_/Q _3442_/CLK _3389_/D _3389_/RESET_B VPWR VGND sg13cmos5l_dfrbpq_1
XFILLER_29_125 VPWR VGND sg13cmos5l_decap_8
XFILLER_41_857 VPWR VGND sg13cmos5l_decap_8
XFILLER_13_537 VPWR VGND sg13cmos5l_fill_1
XFILLER_25_397 VPWR VGND sg13cmos5l_fill_2
XFILLER_40_389 VPWR VGND sg13cmos5l_decap_8
XFILLER_45_1019 VPWR VGND sg13cmos5l_decap_8
XFILLER_1_942 VPWR VGND sg13cmos5l_decap_8
XFILLER_0_452 VPWR VGND sg13cmos5l_decap_8
XFILLER_49_946 VPWR VGND sg13cmos5l_decap_8
XFILLER_0_485 VPWR VGND sg13cmos5l_decap_8
X_3382__282 _3382_/RESET_B VPWR VGND sg13cmos5l_tiehi
XFILLER_44_684 VPWR VGND sg13cmos5l_decap_8
XFILLER_44_662 VPWR VGND sg13cmos5l_decap_8
XFILLER_32_813 VPWR VGND sg13cmos5l_decap_8
XFILLER_31_334 VPWR VGND sg13cmos5l_decap_4
XFILLER_12_570 VPWR VGND sg13cmos5l_decap_8
X_2760_ _2760_/Y _2753_/B _2758_/Y _2759_/Y _2754_/C VPWR VGND sg13cmos5l_a22oi_1
XFILLER_8_563 VPWR VGND sg13cmos5l_fill_2
X_2691_ _2691_/Y _2691_/A VPWR VGND sg13cmos5l_inv_1
X_3312_ _3312_/Q _3551_/CLK _3312_/D _3312_/RESET_B VPWR VGND sg13cmos5l_dfrbpq_1
X_3243_ _3255_/B _3243_/A VPWR VGND sg13cmos5l_inv_1
X_3174_ _3174_/X _3122_/A _2865_/Y _3180_/A VPWR VGND sg13cmos5l_a21o_1
X_2125_ _2125_/Y _2237_/B _2126_/B _2122_/X VPWR VGND sg13cmos5l_a21oi_1
X_3506__376 _3506_/RESET_B VPWR VGND sg13cmos5l_tiehi
X_2056_ _2083_/B _2056_/A _2056_/B VPWR VGND sg13cmos5l_and2_1
XFILLER_22_301 VPWR VGND sg13cmos5l_decap_8
XFILLER_34_150 VPWR VGND sg13cmos5l_fill_2
XFILLER_23_868 VPWR VGND sg13cmos5l_decap_8
XFILLER_10_518 VPWR VGND sg13cmos5l_decap_4
XFILLER_10_529 VPWR VGND sg13cmos5l_fill_1
X_2958_ _2958_/Y hold484/X _2958_/A2 _2608_/A VPWR VGND sg13cmos5l_o21ai_1
X_1909_ _3263_/D _2052_/B input10/X _1912_/S VPWR VGND sg13cmos5l_mux2_1
X_2889_ _2904_/A _3455_/Q _2890_/B VPWR VGND sg13cmos5l_xnor2_1
Xhold530 hold530/X _3271_/Q VPWR VGND sg13cmos5l_dlygate4sd3_1
X_3513__358 _3513_/RESET_B VPWR VGND sg13cmos5l_tiehi
Xhold541 hold541/X _3282_/Q VPWR VGND sg13cmos5l_dlygate4sd3_1
XFILLER_2_728 VPWR VGND sg13cmos5l_decap_8
Xhold563 _1801_/A _3518_/Q VPWR VGND sg13cmos5l_dlygate4sd3_1
Xhold552 _2776_/B _3429_/Q VPWR VGND sg13cmos5l_dlygate4sd3_1
Xhold574 hold574/X _1949_/Y VPWR VGND sg13cmos5l_dlygate4sd3_1
Xhold596 _3230_/A _3537_/Q VPWR VGND sg13cmos5l_dlygate4sd3_1
Xhold585 _2411_/B _2410_/Y VPWR VGND sg13cmos5l_dlygate4sd3_1
XFILLER_46_927 VPWR VGND sg13cmos5l_decap_8
XFILLER_14_813 VPWR VGND sg13cmos5l_fill_2
XFILLER_41_676 VPWR VGND sg13cmos5l_fill_1
XFILLER_41_665 VPWR VGND sg13cmos5l_decap_8
XFILLER_40_175 VPWR VGND sg13cmos5l_decap_8
XFILLER_9_327 VPWR VGND sg13cmos5l_decap_8
XFILLER_13_378 VPWR VGND sg13cmos5l_fill_1
XFILLER_5_566 VPWR VGND sg13cmos5l_fill_1
XFILLER_49_743 VPWR VGND sg13cmos5l_decap_8
XFILLER_37_916 VPWR VGND sg13cmos5l_decap_8
XFILLER_0_293 VPWR VGND sg13cmos5l_decap_8
XFILLER_36_459 VPWR VGND sg13cmos5l_decap_4
XFILLER_44_470 VPWR VGND sg13cmos5l_decap_8
XFILLER_31_120 VPWR VGND sg13cmos5l_decap_8
X_2812_ _2813_/B _3472_/Q _2829_/B _2810_/A _2811_/Y VPWR VGND sg13cmos5l_a22oi_1
XFILLER_32_698 VPWR VGND sg13cmos5l_decap_8
X_2743_ _3454_/D _2839_/A _2828_/B VPWR VGND sg13cmos5l_nor2_1
XFILLER_9_872 VPWR VGND sg13cmos5l_decap_8
XFILLER_8_360 VPWR VGND sg13cmos5l_decap_8
X_2674_ _2786_/B _3543_/D _2957_/B VPWR VGND sg13cmos5l_nor2_1
XFILLER_28_1025 VPWR VGND sg13cmos5l_decap_4
X_3226_ _3226_/Y _3545_/Q _3543_/Q VPWR VGND sg13cmos5l_nor2_1
X_3157_ _3183_/A _3485_/Q _3157_/B VPWR VGND sg13cmos5l_xor2_1
XFILLER_27_404 VPWR VGND sg13cmos5l_fill_1
XFILLER_28_927 VPWR VGND sg13cmos5l_decap_8
X_2108_ _3330_/D _2176_/A _2108_/B VPWR VGND sg13cmos5l_nor2_1
XFILLER_27_437 VPWR VGND sg13cmos5l_decap_8
X_3088_ _3089_/B _3086_/Y _3088_/B VPWR VGND sg13cmos5l_nand2b_1
X_2039_ _2039_/Y _2040_/A _2040_/B VPWR VGND sg13cmos5l_nor2_1
XFILLER_35_1007 VPWR VGND sg13cmos5l_decap_8
XFILLER_10_315 VPWR VGND sg13cmos5l_fill_1
XFILLER_11_838 VPWR VGND sg13cmos5l_decap_8
XFILLER_22_164 VPWR VGND sg13cmos5l_fill_1
XFILLER_10_348 VPWR VGND sg13cmos5l_decap_8
X_3372__292 _3372_/RESET_B VPWR VGND sg13cmos5l_tiehi
X_3515__94 _3515_/D VPWR VGND sg13cmos5l_tielo
XFILLER_19_905 VPWR VGND sg13cmos5l_decap_8
XFILLER_46_724 VPWR VGND sg13cmos5l_fill_1
XFILLER_18_426 VPWR VGND sg13cmos5l_decap_8
XFILLER_45_212 VPWR VGND sg13cmos5l_decap_8
XFILLER_46_779 VPWR VGND sg13cmos5l_decap_8
XFILLER_14_610 VPWR VGND sg13cmos5l_decap_8
XFILLER_27_993 VPWR VGND sg13cmos5l_decap_8
XFILLER_33_429 VPWR VGND sg13cmos5l_decap_4
XFILLER_42_952 VPWR VGND sg13cmos5l_decap_8
XFILLER_26_94 VPWR VGND sg13cmos5l_fill_1
XFILLER_13_197 VPWR VGND sg13cmos5l_decap_8
XFILLER_6_853 VPWR VGND sg13cmos5l_decap_8
XFILLER_5_352 VPWR VGND sg13cmos5l_decap_4
X_2390_ _2390_/Y _3367_/Q _3412_/Q VPWR VGND sg13cmos5l_nor2_1
X_3529__162 _3529_/RESET_B VPWR VGND sg13cmos5l_tiehi
XFILLER_49_540 VPWR VGND sg13cmos5l_decap_8
XFILLER_49_584 VPWR VGND sg13cmos5l_decap_8
XFILLER_37_702 VPWR VGND sg13cmos5l_decap_8
X_3011_ _3012_/B _3011_/A _3011_/B VPWR VGND sg13cmos5l_xnor2_1
XFILLER_25_908 VPWR VGND sg13cmos5l_fill_2
XFILLER_18_960 VPWR VGND sg13cmos5l_decap_8
XFILLER_36_267 VPWR VGND sg13cmos5l_decap_8
XFILLER_20_613 VPWR VGND sg13cmos5l_decap_8
XFILLER_32_484 VPWR VGND sg13cmos5l_decap_8
XFILLER_9_691 VPWR VGND sg13cmos5l_fill_2
X_2726_ _2737_/C _2723_/X _2724_/Y _2725_/Y VPWR VGND sg13cmos5l_a21oi_1
X_2657_ _2658_/B _2657_/A _2657_/B VPWR VGND sg13cmos5l_xnor2_1
X_2588_ _2588_/Y _2599_/B _2587_/Y _2586_/Y VPWR VGND sg13cmos5l_a21oi_1
XFILLER_47_16 VPWR VGND sg13cmos5l_decap_4
X_3209_ _3209_/Y _3209_/A _3209_/B VPWR VGND sg13cmos5l_nand2_1
XFILLER_27_223 VPWR VGND sg13cmos5l_fill_1
XFILLER_42_226 VPWR VGND sg13cmos5l_fill_2
XFILLER_27_289 VPWR VGND sg13cmos5l_decap_8
XFILLER_23_440 VPWR VGND sg13cmos5l_fill_1
XFILLER_11_624 VPWR VGND sg13cmos5l_fill_2
XFILLER_24_996 VPWR VGND sg13cmos5l_decap_8
XFILLER_10_123 VPWR VGND sg13cmos5l_decap_8
XFILLER_3_856 VPWR VGND sg13cmos5l_decap_8
XFILLER_2_333 VPWR VGND sg13cmos5l_decap_8
XFILLER_2_388 VPWR VGND sg13cmos5l_decap_8
XFILLER_2_399 VPWR VGND sg13cmos5l_fill_2
X_3311__371 _3311_/RESET_B VPWR VGND sg13cmos5l_tiehi
XFILLER_46_510 VPWR VGND sg13cmos5l_decap_4
XFILLER_46_521 VPWR VGND sg13cmos5l_fill_1
XFILLER_46_565 VPWR VGND sg13cmos5l_fill_1
XFILLER_46_554 VPWR VGND sg13cmos5l_decap_8
XFILLER_37_82 VPWR VGND sg13cmos5l_fill_2
XFILLER_34_705 VPWR VGND sg13cmos5l_decap_8
XFILLER_15_952 VPWR VGND sg13cmos5l_decap_8
XFILLER_18_1002 VPWR VGND sg13cmos5l_decap_8
XFILLER_42_760 VPWR VGND sg13cmos5l_fill_2
XFILLER_14_473 VPWR VGND sg13cmos5l_decap_8
XFILLER_42_793 VPWR VGND sg13cmos5l_decap_4
X_1890_ _1891_/A _1885_/Y _1889_/X _2018_/A VPWR VGND sg13cmos5l_o21ai_1
XFILLER_30_955 VPWR VGND sg13cmos5l_decap_8
XFILLER_10_690 VPWR VGND sg13cmos5l_decap_8
X_2511_ _3414_/D _2673_/A _2511_/B VPWR VGND sg13cmos5l_nor2_1
X_3491_ _3491_/Q clkload5/A _3491_/D _3491_/RESET_B VPWR VGND sg13cmos5l_dfrbpq_1
X_2442_ _2442_/Y _3400_/Q _3373_/Q VPWR VGND sg13cmos5l_xnor2_1
X_2373_ _2373_/Y _2429_/A _2373_/B _2373_/C VPWR VGND sg13cmos5l_nor3_1
XFILLER_25_1028 VPWR VGND sg13cmos5l_fill_1
XFILLER_18_790 VPWR VGND sg13cmos5l_decap_8
XFILLER_24_215 VPWR VGND sg13cmos5l_decap_8
XFILLER_33_29 VPWR VGND sg13cmos5l_fill_2
XFILLER_33_771 VPWR VGND sg13cmos5l_decap_8
XFILLER_20_432 VPWR VGND sg13cmos5l_decap_8
XFILLER_21_955 VPWR VGND sg13cmos5l_decap_8
XFILLER_32_270 VPWR VGND sg13cmos5l_decap_8
XFILLER_20_443 VPWR VGND sg13cmos5l_fill_2
X_2709_ _2828_/A _2678_/Y _2691_/Y _2917_/A VPWR VGND sg13cmos5l_a21oi_1
XFILLER_0_826 VPWR VGND sg13cmos5l_decap_8
XFILLER_47_307 VPWR VGND sg13cmos5l_decap_8
XFILLER_43_535 VPWR VGND sg13cmos5l_fill_2
XFILLER_16_727 VPWR VGND sg13cmos5l_decap_8
XFILLER_12_922 VPWR VGND sg13cmos5l_decap_8
XFILLER_24_782 VPWR VGND sg13cmos5l_fill_1
XFILLER_8_904 VPWR VGND sg13cmos5l_decap_8
XFILLER_11_421 VPWR VGND sg13cmos5l_decap_8
XFILLER_12_999 VPWR VGND sg13cmos5l_decap_8
XFILLER_23_51 VPWR VGND sg13cmos5l_decap_8
XFILLER_7_458 VPWR VGND sg13cmos5l_decap_4
XFILLER_7_436 VPWR VGND sg13cmos5l_fill_1
XFILLER_48_1006 VPWR VGND sg13cmos5l_decap_8
XFILLER_19_532 VPWR VGND sg13cmos5l_decap_8
XFILLER_46_351 VPWR VGND sg13cmos5l_decap_8
XFILLER_0_1008 VPWR VGND sg13cmos5l_decap_8
XFILLER_47_885 VPWR VGND sg13cmos5l_decap_8
XFILLER_34_524 VPWR VGND sg13cmos5l_decap_8
XFILLER_0_99 VPWR VGND sg13cmos5l_decap_8
X_2991_ _3015_/C _3503_/Q _3000_/B _3011_/A VPWR VGND sg13cmos5l_o21ai_1
X_1942_ _3292_/D input5/X hold501/X _1971_/A VPWR VGND sg13cmos5l_mux2_1
X_1873_ _3547_/D _2601_/A _1987_/A VPWR VGND sg13cmos5l_and2_1
XFILLER_30_763 VPWR VGND sg13cmos5l_decap_4
XFILLER_30_785 VPWR VGND sg13cmos5l_fill_1
X_3543_ _3543_/Q clkload2/A _3543_/D _3543_/RESET_B VPWR VGND sg13cmos5l_dfrbpq_1
X_3474_ _3474_/Q _3504_/CLK _3474_/D _3474_/RESET_B VPWR VGND sg13cmos5l_dfrbpq_1
X_2425_ _2425_/Y _1810_/Y _3117_/A2 _2424_/Y VPWR VGND sg13cmos5l_a21oi_1
X_2356_ _2372_/B _3363_/Q _2363_/A VPWR VGND sg13cmos5l_nand2b_1
X_2287_ _2298_/A _2287_/A _2287_/B VPWR VGND sg13cmos5l_or2_1
XFILLER_38_896 VPWR VGND sg13cmos5l_fill_1
XFILLER_38_885 VPWR VGND sg13cmos5l_decap_8
XFILLER_37_384 VPWR VGND sg13cmos5l_decap_4
X_3295__403 _3295_/RESET_B VPWR VGND sg13cmos5l_tiehi
XFILLER_21_796 VPWR VGND sg13cmos5l_decap_8
XFILLER_4_428 VPWR VGND sg13cmos5l_decap_8
XFILLER_0_601 VPWR VGND sg13cmos5l_decap_8
XFILLER_44_811 VPWR VGND sg13cmos5l_decap_8
XFILLER_16_513 VPWR VGND sg13cmos5l_decap_8
XFILLER_18_95 VPWR VGND sg13cmos5l_decap_8
XFILLER_43_365 VPWR VGND sg13cmos5l_fill_2
XFILLER_43_398 VPWR VGND sg13cmos5l_decap_8
XFILLER_24_590 VPWR VGND sg13cmos5l_fill_2
XFILLER_8_712 VPWR VGND sg13cmos5l_decap_8
XFILLER_8_756 VPWR VGND sg13cmos5l_fill_2
X_3491__161 _3491_/RESET_B VPWR VGND sg13cmos5l_tiehi
XFILLER_8_789 VPWR VGND sg13cmos5l_decap_4
X_3413__107 _3413_/D VPWR VGND sg13cmos5l_tielo
XFILLER_4_973 VPWR VGND sg13cmos5l_decap_8
X_2210_ _2210_/Y _3352_/Q _3334_/Q VPWR VGND sg13cmos5l_nor2_1
X_3190_ _3190_/Y _3068_/B _3185_/Y _3204_/B _3205_/A VPWR VGND sg13cmos5l_a22oi_1
XFILLER_15_4 VPWR VGND sg13cmos5l_decap_8
XFILLER_22_1009 VPWR VGND sg13cmos5l_decap_8
X_2141_ _2141_/Y _3345_/Q _3119_/A2 _2019_/B VPWR VGND sg13cmos5l_o21ai_1
X_2072_ _2072_/Y _2068_/Y _2069_/Y _2070_/Y _2071_/Y _2067_/Y VPWR VGND sg13cmos5l_a221oi_1
XFILLER_38_159 VPWR VGND sg13cmos5l_decap_8
XFILLER_47_693 VPWR VGND sg13cmos5l_decap_8
XFILLER_34_321 VPWR VGND sg13cmos5l_fill_2
XFILLER_34_354 VPWR VGND sg13cmos5l_decap_8
XFILLER_34_376 VPWR VGND sg13cmos5l_decap_8
X_2974_ _2974_/Y _2974_/A _2974_/B _2974_/C VPWR VGND sg13cmos5l_nor3_1
XFILLER_22_538 VPWR VGND sg13cmos5l_decap_8
X_1925_ _3276_/D hold518/X input6/X _1932_/S VPWR VGND sg13cmos5l_mux2_1
X_1856_ _2599_/A _3428_/Q VPWR VGND sg13cmos5l_inv_1
Xhold712 hold712/X _3363_/Q VPWR VGND sg13cmos5l_dlygate4sd3_1
Xhold701 _2684_/B _3447_/Q VPWR VGND sg13cmos5l_dlygate4sd3_1
X_3431__229 _3431_/RESET_B VPWR VGND sg13cmos5l_tiehi
Xhold723 hold723/X _2302_/Y VPWR VGND sg13cmos5l_dlygate4sd3_1
X_3526_ _3526_/Q clkload4/A _3526_/D _3526_/RESET_B VPWR VGND sg13cmos5l_dfrbpq_1
Xhold734 hold734/X _3388_/Q VPWR VGND sg13cmos5l_dlygate4sd3_1
XFILLER_39_17 VPWR VGND sg13cmos5l_decap_4
X_3457_ _3457_/Q _3527_/CLK _3457_/D _3457_/RESET_B VPWR VGND sg13cmos5l_dfrbpq_1
X_3388_ _3388_/Q _3442_/CLK _3388_/D _3388_/RESET_B VPWR VGND sg13cmos5l_dfrbpq_1
X_2408_ _2415_/S _2407_/Y _2408_/B VPWR VGND sg13cmos5l_nand2b_1
X_2339_ _2557_/A _2612_/A _2349_/B VPWR VGND sg13cmos5l_nand2_1
XFILLER_38_1027 VPWR VGND sg13cmos5l_fill_2
XFILLER_13_505 VPWR VGND sg13cmos5l_fill_2
XFILLER_25_376 VPWR VGND sg13cmos5l_decap_8
XFILLER_41_836 VPWR VGND sg13cmos5l_decap_8
XFILLER_9_509 VPWR VGND sg13cmos5l_decap_8
XFILLER_5_737 VPWR VGND sg13cmos5l_decap_4
XFILLER_1_921 VPWR VGND sg13cmos5l_decap_8
XFILLER_20_74 VPWR VGND sg13cmos5l_fill_2
XFILLER_0_420 VPWR VGND sg13cmos5l_decap_8
XFILLER_0_431 VPWR VGND sg13cmos5l_fill_2
XFILLER_49_925 VPWR VGND sg13cmos5l_decap_8
XFILLER_48_413 VPWR VGND sg13cmos5l_decap_8
XFILLER_1_998 VPWR VGND sg13cmos5l_decap_8
XFILLER_48_468 VPWR VGND sg13cmos5l_fill_1
XFILLER_48_446 VPWR VGND sg13cmos5l_fill_2
XFILLER_35_129 VPWR VGND sg13cmos5l_decap_8
XFILLER_44_641 VPWR VGND sg13cmos5l_decap_8
XFILLER_16_332 VPWR VGND sg13cmos5l_decap_8
XFILLER_16_343 VPWR VGND sg13cmos5l_fill_2
XFILLER_8_542 VPWR VGND sg13cmos5l_decap_8
X_2690_ _2691_/A _3449_/Q _2692_/A VPWR VGND sg13cmos5l_xor2_1
X_3311_ _3311_/Q clkload8/A _3311_/D _3311_/RESET_B VPWR VGND sg13cmos5l_dfrbpq_1
X_3536__92 _3536_/D VPWR VGND sg13cmos5l_tielo
X_3242_ _3243_/A _1876_/A hold737/X _3225_/A VPWR VGND sg13cmos5l_o21ai_1
XFILLER_39_424 VPWR VGND sg13cmos5l_fill_1
XFILLER_6_1014 VPWR VGND sg13cmos5l_decap_8
X_3173_ _3180_/A _3167_/Y _3170_/Y _3168_/Y VPWR VGND sg13cmos5l_o21ai_1
X_2124_ _2126_/B _2034_/Y _2123_/C _2123_/Y VPWR VGND sg13cmos5l_o21ai_1
XFILLER_39_457 VPWR VGND sg13cmos5l_fill_1
XFILLER_39_446 VPWR VGND sg13cmos5l_fill_1
X_2055_ _2055_/Y _3311_/Q _2049_/X _2054_/Y VPWR VGND sg13cmos5l_o21ai_1
XFILLER_23_847 VPWR VGND sg13cmos5l_decap_4
X_3355__116 _3355_/D VPWR VGND sg13cmos5l_tielo
XFILLER_41_29 VPWR VGND sg13cmos5l_decap_8
X_2957_ _3493_/D _3114_/A _2957_/B VPWR VGND sg13cmos5l_and2_1
X_1908_ _3262_/D hold508/X input9/X _1912_/S VPWR VGND sg13cmos5l_mux2_1
X_2888_ _2890_/B _3453_/Q _3454_/Q _3452_/Q _3451_/Q VPWR VGND sg13cmos5l_nor4_1
X_1839_ _2788_/A _2578_/A VPWR VGND sg13cmos5l_inv_1
Xhold520 _2155_/A _3345_/Q VPWR VGND sg13cmos5l_dlygate4sd3_1
Xhold553 _2025_/B _3315_/Q VPWR VGND sg13cmos5l_dlygate4sd3_1
Xhold531 _3112_/B _3520_/Q VPWR VGND sg13cmos5l_dlygate4sd3_1
XFILLER_2_707 VPWR VGND sg13cmos5l_decap_8
Xhold542 _2601_/B _3398_/Q VPWR VGND sg13cmos5l_dlygate4sd3_1
X_3509_ _3509_/Q clkload5/A _3509_/D _3509_/RESET_B VPWR VGND sg13cmos5l_dfrbpq_1
Xhold564 _3518_/D _3109_/Y VPWR VGND sg13cmos5l_dlygate4sd3_1
Xhold575 hold575/X _3488_/Q VPWR VGND sg13cmos5l_dlygate4sd3_1
Xhold597 _3232_/B _3231_/Y VPWR VGND sg13cmos5l_dlygate4sd3_1
Xhold586 _3250_/A _3541_/Q VPWR VGND sg13cmos5l_dlygate4sd3_1
XFILLER_46_906 VPWR VGND sg13cmos5l_decap_8
XFILLER_45_449 VPWR VGND sg13cmos5l_decap_8
XFILLER_38_490 VPWR VGND sg13cmos5l_fill_1
XFILLER_41_600 VPWR VGND sg13cmos5l_fill_2
XFILLER_13_324 VPWR VGND sg13cmos5l_fill_1
XFILLER_15_41 VPWR VGND sg13cmos5l_decap_8
XFILLER_26_685 VPWR VGND sg13cmos5l_decap_4
XFILLER_41_688 VPWR VGND sg13cmos5l_decap_8
X_3338__336 _3338_/RESET_B VPWR VGND sg13cmos5l_tiehi
XFILLER_31_62 VPWR VGND sg13cmos5l_fill_1
XFILLER_5_534 VPWR VGND sg13cmos5l_decap_4
XFILLER_49_722 VPWR VGND sg13cmos5l_decap_8
XFILLER_0_272 VPWR VGND sg13cmos5l_decap_8
XFILLER_0_250 VPWR VGND sg13cmos5l_decap_4
XFILLER_1_795 VPWR VGND sg13cmos5l_decap_8
XFILLER_49_799 VPWR VGND sg13cmos5l_decap_8
XFILLER_17_630 VPWR VGND sg13cmos5l_fill_2
XFILLER_16_184 VPWR VGND sg13cmos5l_fill_2
X_3536__326 _3536_/RESET_B VPWR VGND sg13cmos5l_tiehi
X_2811_ _2811_/Y _3471_/Q _2820_/B VPWR VGND sg13cmos5l_nand2_1
XFILLER_31_154 VPWR VGND sg13cmos5l_decap_8
X_2742_ _2828_/B _2796_/B VPWR VGND sg13cmos5l_inv_1
XFILLER_9_851 VPWR VGND sg13cmos5l_decap_8
XFILLER_13_891 VPWR VGND sg13cmos5l_decap_8
X_2673_ _3444_/D _2673_/A _2673_/B VPWR VGND sg13cmos5l_nor2_1
XFILLER_28_1004 VPWR VGND sg13cmos5l_decap_8
X_3225_ _3225_/Y _3225_/A _3543_/Q VPWR VGND sg13cmos5l_nand2_1
XFILLER_39_254 VPWR VGND sg13cmos5l_fill_2
X_3156_ _3156_/Y _3485_/Q _3157_/B VPWR VGND sg13cmos5l_xnor2_1
XFILLER_27_416 VPWR VGND sg13cmos5l_decap_8
XFILLER_43_909 VPWR VGND sg13cmos5l_decap_8
X_2107_ _2163_/A hold654/X _2106_/Y _2110_/S VPWR VGND sg13cmos5l_mux2_1
XFILLER_39_298 VPWR VGND sg13cmos5l_fill_1
Xclkbuf_leaf_19_clk clkload4/A clkbuf_leaf_2_clk/A VPWR VGND sg13cmos5l_buf_8
X_3087_ _3088_/B _3536_/Q _3095_/B _3087_/C VPWR VGND sg13cmos5l_nand3b_1
XFILLER_27_427 VPWR VGND sg13cmos5l_fill_2
X_2038_ _3320_/D _2601_/A _2038_/B VPWR VGND sg13cmos5l_and2_1
XFILLER_36_994 VPWR VGND sg13cmos5l_decap_8
XFILLER_23_633 VPWR VGND sg13cmos5l_fill_1
XFILLER_11_817 VPWR VGND sg13cmos5l_decap_8
XFILLER_22_154 VPWR VGND sg13cmos5l_fill_1
XFILLER_2_537 VPWR VGND sg13cmos5l_decap_8
XFILLER_2_526 VPWR VGND sg13cmos5l_decap_8
XFILLER_19_939 VPWR VGND sg13cmos5l_decap_4
XFILLER_46_758 VPWR VGND sg13cmos5l_decap_8
XFILLER_26_51 VPWR VGND sg13cmos5l_decap_4
XFILLER_27_972 VPWR VGND sg13cmos5l_decap_8
XFILLER_42_931 VPWR VGND sg13cmos5l_decap_8
XFILLER_41_485 VPWR VGND sg13cmos5l_decap_4
XFILLER_13_176 VPWR VGND sg13cmos5l_decap_8
XFILLER_6_832 VPWR VGND sg13cmos5l_decap_8
XFILLER_5_331 VPWR VGND sg13cmos5l_decap_8
XFILLER_5_386 VPWR VGND sg13cmos5l_decap_8
XFILLER_49_574 VPWR VGND sg13cmos5l_decap_4
XFILLER_3_1017 VPWR VGND sg13cmos5l_decap_8
X_3010_ _3011_/B _3503_/Q _3015_/B VPWR VGND sg13cmos5l_xor2_1
XFILLER_3_1028 VPWR VGND sg13cmos5l_fill_1
XFILLER_36_246 VPWR VGND sg13cmos5l_decap_8
XFILLER_33_931 VPWR VGND sg13cmos5l_fill_1
XFILLER_20_647 VPWR VGND sg13cmos5l_decap_8
XFILLER_20_658 VPWR VGND sg13cmos5l_fill_1
XFILLER_9_670 VPWR VGND sg13cmos5l_decap_8
X_2725_ _2725_/Y _2521_/A _2715_/X _2521_/B VPWR VGND sg13cmos5l_o21ai_1
Xclkbuf_leaf_8_clk _3378_/CLK clkload1/A VPWR VGND sg13cmos5l_buf_8
X_2656_ _2657_/B _3439_/Q _2662_/B VPWR VGND sg13cmos5l_xor2_1
X_2587_ _2587_/Y _1840_/A _2790_/A _2417_/A _3396_/Q VPWR VGND sg13cmos5l_a22oi_1
X_3328__346 _3328_/RESET_B VPWR VGND sg13cmos5l_tiehi
X_3208_ _3209_/B _3208_/A _3208_/B VPWR VGND sg13cmos5l_xnor2_1
X_3543__127 _3543_/RESET_B VPWR VGND sg13cmos5l_tiehi
XFILLER_28_714 VPWR VGND sg13cmos5l_fill_1
X_3139_ _3207_/B _3529_/Q _3143_/B VPWR VGND sg13cmos5l_nand2_1
XFILLER_43_728 VPWR VGND sg13cmos5l_fill_2
XFILLER_24_975 VPWR VGND sg13cmos5l_decap_8
XFILLER_10_113 VPWR VGND sg13cmos5l_decap_4
XFILLER_6_106 VPWR VGND sg13cmos5l_decap_8
X_3335__339 _3335_/RESET_B VPWR VGND sg13cmos5l_tiehi
XFILLER_3_835 VPWR VGND sg13cmos5l_decap_8
XFILLER_2_312 VPWR VGND sg13cmos5l_decap_8
XFILLER_46_544 VPWR VGND sg13cmos5l_fill_1
XFILLER_37_94 VPWR VGND sg13cmos5l_fill_2
XFILLER_15_931 VPWR VGND sg13cmos5l_decap_8
XFILLER_18_279 VPWR VGND sg13cmos5l_decap_8
XFILLER_14_441 VPWR VGND sg13cmos5l_fill_2
XFILLER_14_463 VPWR VGND sg13cmos5l_decap_4
XFILLER_30_934 VPWR VGND sg13cmos5l_decap_8
X_3490_ _3490_/Q clkload2/A _3490_/D _3490_/RESET_B VPWR VGND sg13cmos5l_dfrbpq_1
X_2510_ _2511_/B _2618_/A _2510_/B VPWR VGND sg13cmos5l_and2_1
XFILLER_6_673 VPWR VGND sg13cmos5l_decap_8
X_2441_ _2441_/Y _3399_/Q _3372_/Q VPWR VGND sg13cmos5l_xnor2_1
XFILLER_45_4 VPWR VGND sg13cmos5l_fill_2
XFILLER_5_194 VPWR VGND sg13cmos5l_fill_1
X_2372_ _2372_/Y _2372_/A _2372_/B _2372_/C VPWR VGND sg13cmos5l_nor3_1
XFILLER_25_1007 VPWR VGND sg13cmos5l_decap_8
X_3427__234 _3427_/RESET_B VPWR VGND sg13cmos5l_tiehi
XFILLER_37_533 VPWR VGND sg13cmos5l_decap_4
XFILLER_25_706 VPWR VGND sg13cmos5l_decap_8
XFILLER_37_588 VPWR VGND sg13cmos5l_decap_8
XFILLER_24_249 VPWR VGND sg13cmos5l_decap_8
XFILLER_21_912 VPWR VGND sg13cmos5l_decap_8
XFILLER_21_934 VPWR VGND sg13cmos5l_decap_8
X_2708_ _2917_/A _2708_/A _2708_/B VPWR VGND sg13cmos5l_and2_1
XFILLER_0_805 VPWR VGND sg13cmos5l_decap_8
X_2639_ _2658_/A _2639_/A _2639_/B VPWR VGND sg13cmos5l_nor2_1
XFILLER_15_249 VPWR VGND sg13cmos5l_decap_8
XFILLER_12_901 VPWR VGND sg13cmos5l_decap_8
XFILLER_23_271 VPWR VGND sg13cmos5l_decap_4
XFILLER_24_794 VPWR VGND sg13cmos5l_decap_8
XFILLER_7_404 VPWR VGND sg13cmos5l_decap_8
XFILLER_12_978 VPWR VGND sg13cmos5l_decap_8
XFILLER_23_85 VPWR VGND sg13cmos5l_decap_8
XFILLER_2_164 VPWR VGND sg13cmos5l_decap_8
XFILLER_2_197 VPWR VGND sg13cmos5l_decap_8
XFILLER_47_864 VPWR VGND sg13cmos5l_decap_8
XFILLER_19_566 VPWR VGND sg13cmos5l_decap_8
XFILLER_46_385 VPWR VGND sg13cmos5l_decap_8
XFILLER_0_78 VPWR VGND sg13cmos5l_decap_8
XFILLER_0_67 VPWR VGND sg13cmos5l_decap_8
X_2990_ _3011_/A _3502_/Q _3000_/B _3004_/A VPWR VGND sg13cmos5l_a21o_1
XFILLER_21_208 VPWR VGND sg13cmos5l_decap_8
X_1941_ _1941_/X input13/X hold537/X _1941_/S VPWR VGND sg13cmos5l_mux2_1
XFILLER_9_32 VPWR VGND sg13cmos5l_fill_2
XFILLER_14_282 VPWR VGND sg13cmos5l_fill_2
XFILLER_15_783 VPWR VGND sg13cmos5l_decap_8
X_1872_ _3552_/D hold423/X hold429/X _1871_/Y VPWR VGND sg13cmos5l_a21oi_1
XFILLER_30_742 VPWR VGND sg13cmos5l_decap_8
XFILLER_31_1022 VPWR VGND sg13cmos5l_decap_8
XFILLER_6_470 VPWR VGND sg13cmos5l_decap_8
X_3542_ _3542_/Q clkload2/A _3542_/D _3542_/RESET_B VPWR VGND sg13cmos5l_dfrbpq_1
X_3473_ _3473_/Q _3485_/CLK _3473_/D _3473_/RESET_B VPWR VGND sg13cmos5l_dfrbpq_1
XFILLER_9_1012 VPWR VGND sg13cmos5l_decap_8
X_2424_ _2424_/Y _3401_/Q _3117_/A2 _2784_/A VPWR VGND sg13cmos5l_o21ai_1
X_2355_ _2377_/B _3363_/Q _2358_/B VPWR VGND sg13cmos5l_nor2_1
XFILLER_36_0 VPWR VGND sg13cmos5l_decap_4
XFILLER_28_19 VPWR VGND sg13cmos5l_decap_8
XFILLER_38_820 VPWR VGND sg13cmos5l_decap_8
X_2286_ _2287_/B _2286_/A _2286_/B VPWR VGND sg13cmos5l_xnor2_1
XFILLER_38_842 VPWR VGND sg13cmos5l_decap_8
XFILLER_37_352 VPWR VGND sg13cmos5l_decap_4
XFILLER_37_363 VPWR VGND sg13cmos5l_decap_8
XFILLER_25_525 VPWR VGND sg13cmos5l_decap_8
X_3325__349 _3325_/RESET_B VPWR VGND sg13cmos5l_tiehi
XFILLER_44_18 VPWR VGND sg13cmos5l_decap_4
XFILLER_12_208 VPWR VGND sg13cmos5l_fill_1
XFILLER_33_580 VPWR VGND sg13cmos5l_fill_1
X_3551__226 _3551_/RESET_B VPWR VGND sg13cmos5l_tiehi
X_3549__133 _3549_/RESET_B VPWR VGND sg13cmos5l_tiehi
XFILLER_0_657 VPWR VGND sg13cmos5l_decap_8
XFILLER_0_679 VPWR VGND sg13cmos5l_decap_8
X_3369__298 _3369_/RESET_B VPWR VGND sg13cmos5l_tiehi
XFILLER_29_831 VPWR VGND sg13cmos5l_decap_8
XFILLER_28_374 VPWR VGND sg13cmos5l_decap_8
XFILLER_44_889 VPWR VGND sg13cmos5l_decap_8
XFILLER_43_377 VPWR VGND sg13cmos5l_fill_2
XFILLER_12_764 VPWR VGND sg13cmos5l_fill_2
XFILLER_8_768 VPWR VGND sg13cmos5l_decap_8
X_3417__244 _3417_/RESET_B VPWR VGND sg13cmos5l_tiehi
XFILLER_4_952 VPWR VGND sg13cmos5l_decap_8
XFILLER_3_462 VPWR VGND sg13cmos5l_decap_8
X_2140_ _2140_/Y _1816_/Y _2140_/A2 _2139_/Y VPWR VGND sg13cmos5l_a21oi_1
X_2071_ _2071_/Y _2043_/A _3289_/Q _2042_/Y VPWR VGND sg13cmos5l_a21oi_1
XFILLER_19_352 VPWR VGND sg13cmos5l_decap_8
X_3424__237 _3424_/RESET_B VPWR VGND sg13cmos5l_tiehi
XFILLER_35_801 VPWR VGND sg13cmos5l_fill_2
XFILLER_34_333 VPWR VGND sg13cmos5l_decap_8
X_2973_ _2973_/Y _2907_/A _2907_/B _2874_/B VPWR VGND sg13cmos5l_o21ai_1
XFILLER_15_591 VPWR VGND sg13cmos5l_fill_1
X_1924_ _1932_/S _3302_/Q _3257_/A input2/X _1924_/D VPWR VGND sg13cmos5l_nor4_1
X_1855_ _1855_/Y _3456_/Q VPWR VGND sg13cmos5l_inv_1
Xhold702 hold702/X _2684_/X VPWR VGND sg13cmos5l_dlygate4sd3_1
Xhold713 hold713/X _2382_/Y VPWR VGND sg13cmos5l_dlygate4sd3_1
Xhold735 _2870_/A _3482_/Q VPWR VGND sg13cmos5l_dlygate4sd3_1
X_3525_ _3525_/Q clkload3/A _3525_/D _3525_/RESET_B VPWR VGND sg13cmos5l_dfrbpq_1
Xhold724 _2286_/A _3376_/Q VPWR VGND sg13cmos5l_dlygate4sd3_1
X_3456_ _3456_/Q clkload4/A _3456_/D _3456_/RESET_B VPWR VGND sg13cmos5l_dfrbpq_1
X_3387_ _3387_/Q _3409_/CLK _3387_/D _3387_/RESET_B VPWR VGND sg13cmos5l_dfrbpq_1
X_2407_ _2407_/Y _3396_/Q _2404_/Y _2417_/A VPWR VGND sg13cmos5l_o21ai_1
X_2338_ _3383_/D _2383_/A _2434_/A VPWR VGND sg13cmos5l_nor2_1
X_2269_ _2269_/Y _3370_/Q _3347_/Q VPWR VGND sg13cmos5l_xnor2_1
XFILLER_37_160 VPWR VGND sg13cmos5l_decap_4
XFILLER_26_801 VPWR VGND sg13cmos5l_decap_8
XFILLER_26_834 VPWR VGND sg13cmos5l_decap_8
XFILLER_26_845 VPWR VGND sg13cmos5l_fill_1
XFILLER_41_815 VPWR VGND sg13cmos5l_decap_8
XFILLER_38_1006 VPWR VGND sg13cmos5l_decap_8
XFILLER_25_355 VPWR VGND sg13cmos5l_decap_8
XFILLER_26_878 VPWR VGND sg13cmos5l_fill_2
XFILLER_40_325 VPWR VGND sg13cmos5l_fill_2
XFILLER_40_358 VPWR VGND sg13cmos5l_decap_8
XFILLER_21_561 VPWR VGND sg13cmos5l_decap_8
XFILLER_5_716 VPWR VGND sg13cmos5l_decap_4
XFILLER_4_237 VPWR VGND sg13cmos5l_fill_1
XFILLER_20_42 VPWR VGND sg13cmos5l_fill_1
XFILLER_1_900 VPWR VGND sg13cmos5l_decap_8
XFILLER_49_904 VPWR VGND sg13cmos5l_decap_8
XFILLER_1_977 VPWR VGND sg13cmos5l_decap_8
XFILLER_29_40 VPWR VGND sg13cmos5l_fill_2
XFILLER_29_683 VPWR VGND sg13cmos5l_decap_8
XFILLER_44_620 VPWR VGND sg13cmos5l_decap_8
X_3308__377 _3308_/RESET_B VPWR VGND sg13cmos5l_tiehi
XFILLER_17_845 VPWR VGND sg13cmos5l_decap_4
XFILLER_43_152 VPWR VGND sg13cmos5l_decap_8
XFILLER_16_377 VPWR VGND sg13cmos5l_decap_8
XFILLER_16_388 VPWR VGND sg13cmos5l_decap_8
XFILLER_8_565 VPWR VGND sg13cmos5l_fill_1
XFILLER_6_22 VPWR VGND sg13cmos5l_fill_2
XFILLER_6_11 VPWR VGND sg13cmos5l_decap_8
XFILLER_6_99 VPWR VGND sg13cmos5l_decap_8
X_3310_ _3310_/Q clkload7/A _3310_/D _3310_/RESET_B VPWR VGND sg13cmos5l_dfrbpq_1
X_3241_ _3255_/A _3241_/A _3241_/B _3241_/C VPWR VGND sg13cmos5l_nor3_1
XFILLER_39_403 VPWR VGND sg13cmos5l_decap_8
X_3172_ _3172_/Y _3487_/Q _3172_/B _3177_/C VPWR VGND sg13cmos5l_nor3_1
X_2123_ _2123_/Y _2265_/A _2123_/B _2123_/C VPWR VGND sg13cmos5l_nand3_1
XFILLER_48_992 VPWR VGND sg13cmos5l_decap_8
XFILLER_47_480 VPWR VGND sg13cmos5l_decap_8
X_2054_ _2054_/Y _2050_/Y _2051_/Y _2052_/Y _2053_/Y hold717/X VPWR VGND sg13cmos5l_a221oi_1
XFILLER_23_815 VPWR VGND sg13cmos5l_decap_8
XFILLER_35_653 VPWR VGND sg13cmos5l_fill_2
XFILLER_35_697 VPWR VGND sg13cmos5l_decap_8
X_2956_ _2956_/Y _2942_/B hold627/X _2971_/B VPWR VGND sg13cmos5l_a21oi_1
XFILLER_31_881 VPWR VGND sg13cmos5l_decap_8
X_2887_ _2893_/A _3453_/Q _3452_/Q _3451_/Q VPWR VGND sg13cmos5l_or3_1
XFILLER_30_391 VPWR VGND sg13cmos5l_fill_2
X_1907_ _3261_/D hold515/X input8/X _1912_/S VPWR VGND sg13cmos5l_mux2_1
X_1838_ _2787_/A _1838_/A VPWR VGND sg13cmos5l_inv_1
Xhold510 hold510/X _3270_/Q VPWR VGND sg13cmos5l_dlygate4sd3_1
Xhold554 _2030_/A _2025_/Y VPWR VGND sg13cmos5l_dlygate4sd3_1
Xhold532 hold532/X _3274_/Q VPWR VGND sg13cmos5l_dlygate4sd3_1
Xhold521 hold521/X _3281_/Q VPWR VGND sg13cmos5l_dlygate4sd3_1
Xhold543 _1800_/A _3519_/Q VPWR VGND sg13cmos5l_dlygate4sd3_1
X_3508_ _3508_/Q clkload4/A _3508_/D _3508_/RESET_B VPWR VGND sg13cmos5l_dfrbpq_1
Xhold576 _3488_/D _2946_/Y VPWR VGND sg13cmos5l_dlygate4sd3_1
Xhold565 _1879_/B _3538_/Q VPWR VGND sg13cmos5l_dlygate4sd3_1
Xhold587 _1860_/A _3424_/Q VPWR VGND sg13cmos5l_dlygate4sd3_1
Xhold598 _1823_/A _3355_/Q VPWR VGND sg13cmos5l_dlygate4sd3_1
X_3439_ _3439_/Q _3442_/CLK _3439_/D _3439_/RESET_B VPWR VGND sg13cmos5l_dfrbpq_1
XFILLER_45_406 VPWR VGND sg13cmos5l_decap_4
XFILLER_45_428 VPWR VGND sg13cmos5l_decap_4
X_3407__254 _3407_/RESET_B VPWR VGND sg13cmos5l_tiehi
XFILLER_41_623 VPWR VGND sg13cmos5l_fill_2
XFILLER_41_612 VPWR VGND sg13cmos5l_decap_8
XFILLER_14_826 VPWR VGND sg13cmos5l_decap_8
XFILLER_25_152 VPWR VGND sg13cmos5l_fill_2
XFILLER_25_163 VPWR VGND sg13cmos5l_fill_1
XFILLER_9_307 VPWR VGND sg13cmos5l_decap_8
XFILLER_14_859 VPWR VGND sg13cmos5l_decap_8
XFILLER_40_155 VPWR VGND sg13cmos5l_decap_4
XFILLER_5_513 VPWR VGND sg13cmos5l_decap_8
X_3414__247 _3414_/RESET_B VPWR VGND sg13cmos5l_tiehi
XFILLER_5_557 VPWR VGND sg13cmos5l_decap_8
XFILLER_1_774 VPWR VGND sg13cmos5l_decap_8
XFILLER_49_778 VPWR VGND sg13cmos5l_decap_8
XFILLER_17_664 VPWR VGND sg13cmos5l_fill_1
XFILLER_45_984 VPWR VGND sg13cmos5l_decap_8
XFILLER_16_163 VPWR VGND sg13cmos5l_decap_8
X_2810_ _2810_/Y _2810_/A VPWR VGND sg13cmos5l_inv_1
XFILLER_31_166 VPWR VGND sg13cmos5l_decap_4
XFILLER_32_678 VPWR VGND sg13cmos5l_fill_1
XFILLER_9_830 VPWR VGND sg13cmos5l_decap_8
X_2741_ _2796_/B _2737_/A _2715_/X _2521_/Y VPWR VGND sg13cmos5l_o21ai_1
X_2672_ _2673_/B _2655_/Y _2659_/Y _2672_/S VPWR VGND sg13cmos5l_mux2_1
X_3512__360 _3512_/RESET_B VPWR VGND sg13cmos5l_tiehi
X_3224_ _3535_/D _3212_/A _3145_/B _3223_/A VPWR VGND sg13cmos5l_a21oi_1
.ends
