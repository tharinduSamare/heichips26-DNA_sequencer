* NGSPICE file created from heichips26_dna_sequencer.ext - technology: ihp-sg13cmos5l

* Black-box entry subcircuit for sg13cmos5l_nor3_1 abstract view
.subckt sg13cmos5l_nor3_1 Y A B C VDD VSS
.ends

* Black-box entry subcircuit for sg13cmos5l_o21ai_1 abstract view
.subckt sg13cmos5l_o21ai_1 Y A1 A2 B1 VDD VSS
.ends

* Black-box entry subcircuit for sg13cmos5l_decap_8 abstract view
.subckt sg13cmos5l_decap_8 VDD VSS
.ends

* Black-box entry subcircuit for sg13cmos5l_and2_1 abstract view
.subckt sg13cmos5l_and2_1 X A B VDD VSS
.ends

* Black-box entry subcircuit for sg13cmos5l_decap_4 abstract view
.subckt sg13cmos5l_decap_4 VDD VSS
.ends

* Black-box entry subcircuit for sg13cmos5l_fill_1 abstract view
.subckt sg13cmos5l_fill_1 VDD VSS
.ends

* Black-box entry subcircuit for sg13cmos5l_fill_2 abstract view
.subckt sg13cmos5l_fill_2 VDD VSS
.ends

* Black-box entry subcircuit for sg13cmos5l_dfrbpq_1 abstract view
.subckt sg13cmos5l_dfrbpq_1 Q CLK D RESET_B VDD VSS
.ends

* Black-box entry subcircuit for sg13cmos5l_nand2_1 abstract view
.subckt sg13cmos5l_nand2_1 Y A B VDD VSS
.ends

* Black-box entry subcircuit for sg13cmos5l_nor2_1 abstract view
.subckt sg13cmos5l_nor2_1 Y A B VDD VSS
.ends

* Black-box entry subcircuit for sg13cmos5l_inv_1 abstract view
.subckt sg13cmos5l_inv_1 Y A VDD VSS
.ends

* Black-box entry subcircuit for sg13cmos5l_a21oi_1 abstract view
.subckt sg13cmos5l_a21oi_1 Y A1 A2 B1 VDD VSS
.ends

* Black-box entry subcircuit for sg13cmos5l_tiehi abstract view
.subckt sg13cmos5l_tiehi L_HI VDD VSS
.ends

* Black-box entry subcircuit for sg13cmos5l_nor2b_1 abstract view
.subckt sg13cmos5l_nor2b_1 Y A B_N VDD VSS
.ends

* Black-box entry subcircuit for sg13cmos5l_nand2b_1 abstract view
.subckt sg13cmos5l_nand2b_1 Y A_N B VDD VSS
.ends

* Black-box entry subcircuit for sg13cmos5l_dlygate4sd3_1 abstract view
.subckt sg13cmos5l_dlygate4sd3_1 X A VDD VSS
.ends

* Black-box entry subcircuit for sg13cmos5l_xnor2_1 abstract view
.subckt sg13cmos5l_xnor2_1 Y A B VDD VSS
.ends

* Black-box entry subcircuit for sg13cmos5l_a22oi_1 abstract view
.subckt sg13cmos5l_a22oi_1 Y A1 A2 B1 B2 VDD VSS
.ends

* Black-box entry subcircuit for sg13cmos5l_tielo abstract view
.subckt sg13cmos5l_tielo L_LO VDD VSS
.ends

* Black-box entry subcircuit for sg13cmos5l_mux2_1 abstract view
.subckt sg13cmos5l_mux2_1 X A0 A1 S VDD VSS
.ends

* Black-box entry subcircuit for sg13cmos5l_a221oi_1 abstract view
.subckt sg13cmos5l_a221oi_1 Y A1 A2 B1 B2 C1 VDD VSS
.ends

* Black-box entry subcircuit for sg13cmos5l_a21o_1 abstract view
.subckt sg13cmos5l_a21o_1 X A1 A2 B1 VDD VSS
.ends

* Black-box entry subcircuit for sg13cmos5l_nor4_1 abstract view
.subckt sg13cmos5l_nor4_1 Y A B C D VDD VSS
.ends

* Black-box entry subcircuit for sg13cmos5l_xor2_1 abstract view
.subckt sg13cmos5l_xor2_1 X A B VDD VSS
.ends

* Black-box entry subcircuit for sg13cmos5l_or3_1 abstract view
.subckt sg13cmos5l_or3_1 X A B C VDD VSS
.ends

* Black-box entry subcircuit for sg13cmos5l_nand3_1 abstract view
.subckt sg13cmos5l_nand3_1 Y A B C VDD VSS
.ends

* Black-box entry subcircuit for sg13cmos5l_nand3b_1 abstract view
.subckt sg13cmos5l_nand3b_1 Y A_N B C VDD VSS
.ends

* Black-box entry subcircuit for sg13cmos5l_and3_1 abstract view
.subckt sg13cmos5l_and3_1 X A B C VDD VSS
.ends

* Black-box entry subcircuit for sg13cmos5l_buf_8 abstract view
.subckt sg13cmos5l_buf_8 X A VDD VSS
.ends

* Black-box entry subcircuit for sg13cmos5l_buf_1 abstract view
.subckt sg13cmos5l_buf_1 X A VDD VSS
.ends

* Black-box entry subcircuit for sg13cmos5l_or2_1 abstract view
.subckt sg13cmos5l_or2_1 X A B VDD VSS
.ends

* Black-box entry subcircuit for sg13cmos5l_mux4_1 abstract view
.subckt sg13cmos5l_mux4_1 X A0 A1 A2 A3 S0 S1 VDD VSS
.ends

* Black-box entry subcircuit for sg13cmos5l_nand4_1 abstract view
.subckt sg13cmos5l_nand4_1 Y A B C D VDD VSS
.ends

* Black-box entry subcircuit for sg13cmos5l_and4_1 abstract view
.subckt sg13cmos5l_and4_1 X A B C D VDD VSS
.ends

* Black-box entry subcircuit for sg13cmos5l_inv_2 abstract view
.subckt sg13cmos5l_inv_2 Y A VDD VSS
.ends

.subckt heichips26_dna_sequencer VGND VPWR clk ena rst_n ui_in[0] ui_in[1] ui_in[2]
+ ui_in[3] ui_in[4] ui_in[5] ui_in[6] ui_in[7] uio_in[0] uio_in[1] uio_in[2] uio_in[3]
+ uio_in[4] uio_in[5] uio_in[6] uio_in[7] uio_oe[0] uio_oe[1] uio_oe[2] uio_oe[3]
+ uio_oe[4] uio_oe[5] uio_oe[6] uio_oe[7] uio_out[0] uio_out[1] uio_out[2] uio_out[3]
+ uio_out[4] uio_out[5] uio_out[6] uio_out[7] uo_out[0] uo_out[1] uo_out[2] uo_out[3]
+ uo_out[4] uo_out[5] uo_out[6] uo_out[7]
X_3155_ _3155_/Y _3625_/Q _3155_/B _3160_/B VPWR VGND sg13cmos5l_nor3_1
X_2106_ _2106_/Y _2049_/A _2053_/Y _2130_/B VPWR VGND sg13cmos5l_o21ai_1
XFILLER_27_428 VPWR VGND sg13cmos5l_decap_8
X_3086_ _3087_/C _3088_/A _3085_/B _3084_/Y VPWR VGND sg13cmos5l_o21ai_1
XFILLER_36_973 VPWR VGND sg13cmos5l_decap_8
X_2037_ _3803_/D _2755_/A _2579_/B VPWR VGND sg13cmos5l_and2_1
XFILLER_35_450 VPWR VGND sg13cmos5l_decap_8
XFILLER_35_494 VPWR VGND sg13cmos5l_decap_4
X_2939_ _3611_/D _2939_/A _2939_/B _2939_/C VPWR VGND sg13cmos5l_nor3_1
XFILLER_7_7 VPWR VGND sg13cmos5l_decap_4
XFILLER_14_601 VPWR VGND sg13cmos5l_fill_1
XFILLER_42_965 VPWR VGND sg13cmos5l_decap_8
XFILLER_14_667 VPWR VGND sg13cmos5l_decap_8
XFILLER_14_689 VPWR VGND sg13cmos5l_decap_8
XFILLER_42_62 VPWR VGND sg13cmos5l_fill_2
XFILLER_9_126 VPWR VGND sg13cmos5l_decap_8
XFILLER_9_137 VPWR VGND sg13cmos5l_fill_1
XFILLER_42_73 VPWR VGND sg13cmos5l_fill_2
XFILLER_10_851 VPWR VGND sg13cmos5l_decap_8
XFILLER_6_855 VPWR VGND sg13cmos5l_decap_8
XFILLER_5_321 VPWR VGND sg13cmos5l_fill_2
XFILLER_5_376 VPWR VGND sg13cmos5l_decap_8
XFILLER_3_67 VPWR VGND sg13cmos5l_fill_2
XFILLER_37_704 VPWR VGND sg13cmos5l_fill_2
XFILLER_3_1018 VPWR VGND sg13cmos5l_decap_8
XFILLER_49_597 VPWR VGND sg13cmos5l_decap_8
XFILLER_37_759 VPWR VGND sg13cmos5l_fill_1
XFILLER_37_737 VPWR VGND sg13cmos5l_decap_8
XFILLER_24_409 VPWR VGND sg13cmos5l_fill_2
XFILLER_45_770 VPWR VGND sg13cmos5l_decap_8
XFILLER_18_995 VPWR VGND sg13cmos5l_decap_8
XFILLER_17_494 VPWR VGND sg13cmos5l_decap_8
XFILLER_33_943 VPWR VGND sg13cmos5l_decap_8
XFILLER_32_497 VPWR VGND sg13cmos5l_decap_8
X_3773_ _3773_/Q clkload5/A _3773_/D _3773_/RESET_B VPWR VGND sg13cmos5l_dfrbpq_1
X_2724_ _2724_/Y _2724_/A _2724_/B VPWR VGND sg13cmos5l_nand2_1
X_2655_ _2655_/Y input9/X _2725_/A VPWR VGND sg13cmos5l_nor2_1
X_2586_ _3798_/D _2586_/A _2586_/B VPWR VGND sg13cmos5l_nor2_1
X_3207_ _3207_/Y _3207_/A VPWR VGND sg13cmos5l_inv_1
X_3138_ _3138_/Y _3139_/B VPWR VGND sg13cmos5l_inv_1
XFILLER_28_737 VPWR VGND sg13cmos5l_decap_8
XFILLER_27_258 VPWR VGND sg13cmos5l_fill_1
X_3069_ _3637_/D _3059_/B _3071_/A _3068_/Y VPWR VGND sg13cmos5l_a21oi_1
XFILLER_36_770 VPWR VGND sg13cmos5l_decap_8
XFILLER_24_954 VPWR VGND sg13cmos5l_decap_8
XFILLER_11_648 VPWR VGND sg13cmos5l_fill_2
XFILLER_10_169 VPWR VGND sg13cmos5l_decap_4
XFILLER_3_836 VPWR VGND sg13cmos5l_decap_8
XFILLER_2_335 VPWR VGND sg13cmos5l_decap_8
XFILLER_2_368 VPWR VGND sg13cmos5l_decap_8
XFILLER_19_704 VPWR VGND sg13cmos5l_decap_8
XFILLER_46_545 VPWR VGND sg13cmos5l_decap_4
XFILLER_37_73 VPWR VGND sg13cmos5l_decap_8
XFILLER_33_206 VPWR VGND sg13cmos5l_decap_4
X_3502__381 _3502_/RESET_B VPWR VGND sg13cmos5l_tiehi
XFILLER_14_420 VPWR VGND sg13cmos5l_fill_2
XFILLER_26_291 VPWR VGND sg13cmos5l_decap_8
XFILLER_33_239 VPWR VGND sg13cmos5l_decap_8
XFILLER_14_442 VPWR VGND sg13cmos5l_decap_8
XFILLER_15_976 VPWR VGND sg13cmos5l_decap_8
XFILLER_30_968 VPWR VGND sg13cmos5l_decap_8
X_2440_ _2442_/B _2274_/Y _2439_/B _2439_/Y VPWR VGND sg13cmos5l_o21ai_1
XFILLER_5_162 VPWR VGND sg13cmos5l_fill_2
XFILLER_38_4 VPWR VGND sg13cmos5l_decap_4
X_2371_ _2386_/B _2388_/B VPWR VGND sg13cmos5l_inv_1
XFILLER_2_891 VPWR VGND sg13cmos5l_decap_8
XFILLER_25_1008 VPWR VGND sg13cmos5l_decap_8
XFILLER_49_372 VPWR VGND sg13cmos5l_decap_8
XFILLER_24_228 VPWR VGND sg13cmos5l_fill_1
XFILLER_33_740 VPWR VGND sg13cmos5l_decap_8
XFILLER_21_924 VPWR VGND sg13cmos5l_decap_8
XFILLER_32_272 VPWR VGND sg13cmos5l_fill_1
X_3756_ _3756_/Q _3783_/CLK _3756_/D _3756_/RESET_B VPWR VGND sg13cmos5l_dfrbpq_1
X_2707_ _2707_/Y _2698_/A _2755_/B _2708_/A VPWR VGND sg13cmos5l_o21ai_1
X_3687_ _3687_/Q _3806_/CLK _3687_/D _3687_/RESET_B VPWR VGND sg13cmos5l_dfrbpq_1
X_2638_ _2650_/C _2638_/A _3559_/Q VPWR VGND sg13cmos5l_nor2b_1
X_2569_ _2569_/Y _2027_/C _2573_/A _2568_/Y VPWR VGND sg13cmos5l_o21ai_1
XFILLER_0_839 VPWR VGND sg13cmos5l_decap_8
XFILLER_43_504 VPWR VGND sg13cmos5l_fill_2
X_3556__319 _3556_/RESET_B VPWR VGND sg13cmos5l_tiehi
XFILLER_24_773 VPWR VGND sg13cmos5l_fill_1
XFILLER_12_935 VPWR VGND sg13cmos5l_decap_4
XFILLER_11_434 VPWR VGND sg13cmos5l_decap_8
XFILLER_12_968 VPWR VGND sg13cmos5l_decap_8
XFILLER_3_611 VPWR VGND sg13cmos5l_decap_8
XFILLER_3_655 VPWR VGND sg13cmos5l_fill_1
X_3669__163 _3669_/RESET_B VPWR VGND sg13cmos5l_tiehi
XFILLER_47_821 VPWR VGND sg13cmos5l_decap_8
XFILLER_19_512 VPWR VGND sg13cmos5l_fill_1
XFILLER_0_35 VPWR VGND sg13cmos5l_decap_8
XFILLER_47_898 VPWR VGND sg13cmos5l_decap_8
XFILLER_46_364 VPWR VGND sg13cmos5l_decap_8
XFILLER_34_526 VPWR VGND sg13cmos5l_fill_2
XFILLER_9_11 VPWR VGND sg13cmos5l_decap_8
XFILLER_15_762 VPWR VGND sg13cmos5l_fill_2
X_1940_ _3155_/B _3006_/A VPWR VGND sg13cmos5l_inv_1
XFILLER_30_765 VPWR VGND sg13cmos5l_decap_8
X_3610_ _3610_/Q clkload9/A _3610_/D _3610_/RESET_B VPWR VGND sg13cmos5l_dfrbpq_1
XFILLER_9_99 VPWR VGND sg13cmos5l_decap_8
XFILLER_30_798 VPWR VGND sg13cmos5l_decap_8
XFILLER_31_1012 VPWR VGND sg13cmos5l_decap_8
X_3541_ _3541_/Q clkload7/A _3541_/D _3541_/RESET_B VPWR VGND sg13cmos5l_dfrbpq_1
X_3472_ _3472_/Y _2150_/B _3469_/A _3463_/B VPWR VGND sg13cmos5l_o21ai_1
X_2423_ _2423_/Y _3750_/Q _3793_/Q VPWR VGND sg13cmos5l_nand2_1
X_2354_ _2360_/S _2345_/Y _2352_/Y _2353_/Y VPWR VGND sg13cmos5l_o21ai_1
XFILLER_38_810 VPWR VGND sg13cmos5l_fill_2
X_2285_ _2287_/B _2286_/A _2284_/Y _2582_/A VPWR VGND sg13cmos5l_a21oi_1
XFILLER_49_191 VPWR VGND sg13cmos5l_decap_8
XFILLER_38_843 VPWR VGND sg13cmos5l_decap_8
XFILLER_37_342 VPWR VGND sg13cmos5l_decap_8
XFILLER_38_876 VPWR VGND sg13cmos5l_decap_4
XFILLER_21_732 VPWR VGND sg13cmos5l_decap_8
XFILLER_33_592 VPWR VGND sg13cmos5l_fill_1
X_3808_ _3808_/Q clkload2/A _3808_/D _3808_/RESET_B VPWR VGND sg13cmos5l_dfrbpq_1
XFILLER_20_297 VPWR VGND sg13cmos5l_decap_8
XFILLER_4_408 VPWR VGND sg13cmos5l_decap_8
X_3739_ _3739_/Q clkload4/A _3739_/D _3739_/RESET_B VPWR VGND sg13cmos5l_dfrbpq_1
X_3707__300 _3707_/RESET_B VPWR VGND sg13cmos5l_tiehi
XFILLER_0_658 VPWR VGND sg13cmos5l_decap_8
XFILLER_0_669 VPWR VGND sg13cmos5l_fill_2
XFILLER_18_20 VPWR VGND sg13cmos5l_fill_1
XFILLER_28_320 VPWR VGND sg13cmos5l_decap_4
XFILLER_44_868 VPWR VGND sg13cmos5l_decap_8
XFILLER_24_581 VPWR VGND sg13cmos5l_decap_8
XFILLER_34_52 VPWR VGND sg13cmos5l_fill_1
XFILLER_12_765 VPWR VGND sg13cmos5l_fill_2
XFILLER_15_1018 VPWR VGND sg13cmos5l_decap_8
XFILLER_8_725 VPWR VGND sg13cmos5l_decap_4
XFILLER_11_275 VPWR VGND sg13cmos5l_decap_8
XFILLER_7_246 VPWR VGND sg13cmos5l_decap_8
XFILLER_4_986 VPWR VGND sg13cmos5l_decap_8
XFILLER_38_106 VPWR VGND sg13cmos5l_decap_8
X_2070_ _3416_/B _2064_/X _2111_/B VPWR VGND sg13cmos5l_nand2b_1
XFILLER_19_353 VPWR VGND sg13cmos5l_decap_4
XFILLER_46_194 VPWR VGND sg13cmos5l_decap_8
XFILLER_19_386 VPWR VGND sg13cmos5l_decap_8
XFILLER_19_397 VPWR VGND sg13cmos5l_decap_8
XFILLER_34_323 VPWR VGND sg13cmos5l_decap_8
X_2972_ _2979_/C _3592_/Q _3593_/Q _2971_/C VPWR VGND sg13cmos5l_o21ai_1
Xhold703 hold703/X _2899_/Y VPWR VGND sg13cmos5l_dlygate4sd3_1
Xhold736 _3140_/A _3621_/Q VPWR VGND sg13cmos5l_dlygate4sd3_1
X_3524_ _3524_/Q clkload8/A _3524_/D _3524_/RESET_B VPWR VGND sg13cmos5l_dfrbpq_1
Xhold725 _3208_/A _3666_/Q VPWR VGND sg13cmos5l_dlygate4sd3_1
Xhold714 hold714/X _3016_/Y VPWR VGND sg13cmos5l_dlygate4sd3_1
Xhold769 _1962_/A _3638_/Q VPWR VGND sg13cmos5l_dlygate4sd3_1
Xhold747 _2545_/A _3788_/Q VPWR VGND sg13cmos5l_dlygate4sd3_1
Xhold758 _1998_/A _3716_/Q VPWR VGND sg13cmos5l_dlygate4sd3_1
X_3455_ _3455_/Y _3721_/Q _3458_/A2 _3460_/A VPWR VGND sg13cmos5l_o21ai_1
X_2406_ _2406_/X _2406_/A _2411_/B VPWR VGND sg13cmos5l_and2_1
X_3386_ _3387_/B _3386_/A _3396_/B VPWR VGND sg13cmos5l_xnor2_1
X_2337_ _2338_/B _2337_/A _2337_/B VPWR VGND sg13cmos5l_nor2_1
X_2268_ _2268_/Y _3750_/Q _2268_/B VPWR VGND sg13cmos5l_nand2b_1
XFILLER_44_109 VPWR VGND sg13cmos5l_fill_1
X_2199_ _2200_/A _2174_/X _2198_/C _2198_/Y VPWR VGND sg13cmos5l_o21ai_1
XFILLER_26_857 VPWR VGND sg13cmos5l_decap_8
XFILLER_40_326 VPWR VGND sg13cmos5l_fill_2
XFILLER_40_315 VPWR VGND sg13cmos5l_decap_8
XFILLER_13_529 VPWR VGND sg13cmos5l_fill_2
XFILLER_25_378 VPWR VGND sg13cmos5l_decap_8
XFILLER_21_573 VPWR VGND sg13cmos5l_fill_1
X_3666__166 _3666_/RESET_B VPWR VGND sg13cmos5l_tiehi
XFILLER_1_934 VPWR VGND sg13cmos5l_decap_8
XFILLER_0_477 VPWR VGND sg13cmos5l_decap_8
XFILLER_0_499 VPWR VGND sg13cmos5l_decap_8
XFILLER_21_1022 VPWR VGND sg13cmos5l_decap_8
XFILLER_28_150 VPWR VGND sg13cmos5l_decap_8
XFILLER_17_857 VPWR VGND sg13cmos5l_decap_8
XFILLER_28_183 VPWR VGND sg13cmos5l_fill_2
XFILLER_45_73 VPWR VGND sg13cmos5l_decap_8
XFILLER_44_676 VPWR VGND sg13cmos5l_decap_8
XFILLER_44_654 VPWR VGND sg13cmos5l_decap_8
XFILLER_43_120 VPWR VGND sg13cmos5l_decap_8
XFILLER_16_356 VPWR VGND sg13cmos5l_decap_8
XFILLER_43_153 VPWR VGND sg13cmos5l_decap_8
XFILLER_32_849 VPWR VGND sg13cmos5l_fill_1
XFILLER_12_540 VPWR VGND sg13cmos5l_decap_8
XFILLER_40_871 VPWR VGND sg13cmos5l_decap_4
XFILLER_6_23 VPWR VGND sg13cmos5l_decap_4
XFILLER_3_293 VPWR VGND sg13cmos5l_decap_4
X_3240_ _3265_/A _3676_/Q _3240_/B VPWR VGND sg13cmos5l_xnor2_1
XFILLER_39_426 VPWR VGND sg13cmos5l_fill_2
XFILLER_6_1027 VPWR VGND sg13cmos5l_fill_2
XFILLER_6_1016 VPWR VGND sg13cmos5l_decap_8
XFILLER_20_4 VPWR VGND sg13cmos5l_decap_8
X_3171_ _3171_/Y hold721/X _3168_/Y _3108_/A VPWR VGND sg13cmos5l_o21ai_1
XFILLER_39_448 VPWR VGND sg13cmos5l_fill_2
X_2122_ _2123_/B _2115_/A _2115_/B _2217_/A VPWR VGND sg13cmos5l_a21oi_1
XFILLER_48_971 VPWR VGND sg13cmos5l_decap_8
X_2053_ _2053_/Y _3465_/A _2053_/B VPWR VGND sg13cmos5l_xnor2_1
XFILLER_35_610 VPWR VGND sg13cmos5l_decap_8
XFILLER_19_194 VPWR VGND sg13cmos5l_decap_8
XFILLER_22_315 VPWR VGND sg13cmos5l_fill_2
XFILLER_16_890 VPWR VGND sg13cmos5l_decap_8
XFILLER_22_359 VPWR VGND sg13cmos5l_fill_1
X_2955_ _2955_/Y _2949_/Y _2950_/Y _2954_/Y _3638_/Q VPWR VGND sg13cmos5l_a22oi_1
X_2886_ _2886_/Y _3000_/B _2891_/B VPWR VGND sg13cmos5l_nand2_1
Xhold500 _2706_/B _2705_/Y VPWR VGND sg13cmos5l_dlygate4sd3_1
Xhold511 _3018_/B _3600_/Q VPWR VGND sg13cmos5l_dlygate4sd3_1
X_3507_ _3507_/Q clkload8/A _3507_/D _3507_/RESET_B VPWR VGND sg13cmos5l_dfrbpq_1
Xhold522 hold522/X _3564_/Q VPWR VGND sg13cmos5l_dlygate4sd3_1
Xhold544 _1957_/A _3752_/Q VPWR VGND sg13cmos5l_dlygate4sd3_1
Xhold533 _3690_/D _3344_/Y VPWR VGND sg13cmos5l_dlygate4sd3_1
Xhold566 hold566/X _3524_/Q VPWR VGND sg13cmos5l_dlygate4sd3_1
Xhold588 hold588/X _3509_/Q VPWR VGND sg13cmos5l_dlygate4sd3_1
Xhold577 hold577/X _3506_/Q VPWR VGND sg13cmos5l_dlygate4sd3_1
Xhold555 hold555/X _3487_/Q VPWR VGND sg13cmos5l_dlygate4sd3_1
XFILLER_44_1022 VPWR VGND sg13cmos5l_decap_8
Xhold599 hold599/X _3532_/Q VPWR VGND sg13cmos5l_dlygate4sd3_1
X_3438_ _3439_/A _3686_/Q _3436_/Y _3437_/Y VPWR VGND sg13cmos5l_o21ai_1
X_3369_ _3389_/A _3694_/Q _3376_/B VPWR VGND sg13cmos5l_nand2_1
XFILLER_38_481 VPWR VGND sg13cmos5l_fill_2
XFILLER_26_665 VPWR VGND sg13cmos5l_decap_8
XFILLER_14_827 VPWR VGND sg13cmos5l_fill_1
XFILLER_15_32 VPWR VGND sg13cmos5l_decap_8
XFILLER_41_646 VPWR VGND sg13cmos5l_fill_2
XFILLER_13_337 VPWR VGND sg13cmos5l_decap_8
XFILLER_13_348 VPWR VGND sg13cmos5l_fill_1
XFILLER_15_65 VPWR VGND sg13cmos5l_decap_8
XFILLER_15_76 VPWR VGND sg13cmos5l_fill_1
XFILLER_49_702 VPWR VGND sg13cmos5l_fill_1
XFILLER_0_241 VPWR VGND sg13cmos5l_decap_8
XFILLER_49_768 VPWR VGND sg13cmos5l_decap_8
X_3640__114 _3640_/D VPWR VGND sg13cmos5l_tielo
XFILLER_0_285 VPWR VGND sg13cmos5l_fill_2
XFILLER_0_274 VPWR VGND sg13cmos5l_decap_8
XFILLER_48_278 VPWR VGND sg13cmos5l_decap_8
XFILLER_48_267 VPWR VGND sg13cmos5l_fill_1
XFILLER_37_919 VPWR VGND sg13cmos5l_decap_8
XFILLER_45_952 VPWR VGND sg13cmos5l_decap_8
XFILLER_29_492 VPWR VGND sg13cmos5l_decap_8
XFILLER_16_164 VPWR VGND sg13cmos5l_fill_2
XFILLER_17_676 VPWR VGND sg13cmos5l_decap_8
XFILLER_32_602 VPWR VGND sg13cmos5l_decap_8
XFILLER_32_646 VPWR VGND sg13cmos5l_fill_1
X_2740_ _2846_/B _2740_/A _2294_/B VPWR VGND sg13cmos5l_nor2b_1
X_2671_ _3536_/D input13/X hold582/X _2671_/S VPWR VGND sg13cmos5l_mux2_1
XFILLER_9_864 VPWR VGND sg13cmos5l_decap_8
XFILLER_4_591 VPWR VGND sg13cmos5l_fill_2
X_3223_ _3223_/Y _3223_/A VPWR VGND sg13cmos5l_inv_1
X_3154_ _3159_/B _3160_/B _3153_/Y _3152_/Y VPWR VGND sg13cmos5l_a21oi_1
XFILLER_28_908 VPWR VGND sg13cmos5l_fill_1
XFILLER_39_289 VPWR VGND sg13cmos5l_decap_8
X_2105_ _2105_/Y _2049_/A _2053_/Y _2100_/X _2103_/Y _2104_/X VPWR VGND sg13cmos5l_a221oi_1
X_3085_ _3087_/B _3088_/A _3085_/B VPWR VGND sg13cmos5l_nand2_1
XFILLER_36_952 VPWR VGND sg13cmos5l_decap_8
X_2036_ _2579_/B hold804/X _2029_/B _2035_/X VPWR VGND sg13cmos5l_a21o_1
XFILLER_35_473 VPWR VGND sg13cmos5l_decap_8
X_2938_ _2939_/C _2938_/A _2912_/C VPWR VGND sg13cmos5l_nor2b_1
XFILLER_22_178 VPWR VGND sg13cmos5l_decap_4
X_2869_ _3588_/D _2939_/A _2869_/B VPWR VGND sg13cmos5l_nor2_1
X_3663__169 _3663_/RESET_B VPWR VGND sg13cmos5l_tiehi
XFILLER_46_716 VPWR VGND sg13cmos5l_decap_8
XFILLER_45_248 VPWR VGND sg13cmos5l_decap_4
XFILLER_27_985 VPWR VGND sg13cmos5l_decap_8
XFILLER_42_944 VPWR VGND sg13cmos5l_decap_8
XFILLER_13_145 VPWR VGND sg13cmos5l_decap_4
X_3750__131 _3750_/D VPWR VGND sg13cmos5l_tielo
XFILLER_42_96 VPWR VGND sg13cmos5l_fill_1
XFILLER_22_690 VPWR VGND sg13cmos5l_fill_2
XFILLER_6_834 VPWR VGND sg13cmos5l_decap_8
XFILLER_5_300 VPWR VGND sg13cmos5l_decap_4
XFILLER_3_46 VPWR VGND sg13cmos5l_decap_8
XFILLER_37_727 VPWR VGND sg13cmos5l_fill_1
X_3599__119 _3599_/D VPWR VGND sg13cmos5l_tielo
XFILLER_17_440 VPWR VGND sg13cmos5l_decap_8
XFILLER_36_237 VPWR VGND sg13cmos5l_fill_2
XFILLER_17_451 VPWR VGND sg13cmos5l_fill_2
XFILLER_17_473 VPWR VGND sg13cmos5l_decap_8
XFILLER_18_974 VPWR VGND sg13cmos5l_decap_8
XFILLER_33_922 VPWR VGND sg13cmos5l_decap_8
XFILLER_33_999 VPWR VGND sg13cmos5l_decap_8
X_3772_ _3772_/Q clkload5/A _3772_/D _3772_/RESET_B VPWR VGND sg13cmos5l_dfrbpq_1
XFILLER_32_476 VPWR VGND sg13cmos5l_decap_8
XFILLER_34_1010 VPWR VGND sg13cmos5l_decap_8
X_2723_ _3559_/D _2723_/A VPWR VGND sg13cmos5l_inv_1
XFILLER_9_672 VPWR VGND sg13cmos5l_decap_8
XFILLER_9_694 VPWR VGND sg13cmos5l_decap_8
XFILLER_8_182 VPWR VGND sg13cmos5l_fill_1
X_2654_ _3522_/D _1990_/Y _2725_/A _2653_/Y VPWR VGND sg13cmos5l_a21oi_1
X_2585_ _2585_/Y _2014_/C _2581_/X _2584_/Y VPWR VGND sg13cmos5l_a21oi_1
X_3206_ _3207_/A _3222_/A _3206_/B VPWR VGND sg13cmos5l_nand2_1
X_3137_ _3139_/B _3121_/Y _3132_/Y _3136_/Y _3131_/Y VPWR VGND sg13cmos5l_a22oi_1
X_3068_ _3068_/Y hold774/X _3071_/A _3030_/B VPWR VGND sg13cmos5l_o21ai_1
XFILLER_36_760 VPWR VGND sg13cmos5l_fill_1
X_2019_ _2284_/A _2015_/B _2019_/B VPWR VGND sg13cmos5l_nand2b_1
XFILLER_24_933 VPWR VGND sg13cmos5l_decap_8
XFILLER_11_616 VPWR VGND sg13cmos5l_decap_4
XFILLER_23_476 VPWR VGND sg13cmos5l_decap_8
XFILLER_12_11 VPWR VGND sg13cmos5l_decap_8
XFILLER_12_55 VPWR VGND sg13cmos5l_fill_2
XFILLER_3_815 VPWR VGND sg13cmos5l_decap_8
XFILLER_2_314 VPWR VGND sg13cmos5l_decap_8
XFILLER_2_347 VPWR VGND sg13cmos5l_decap_8
XFILLER_15_955 VPWR VGND sg13cmos5l_decap_8
XFILLER_26_281 VPWR VGND sg13cmos5l_fill_1
XFILLER_18_1016 VPWR VGND sg13cmos5l_decap_8
XFILLER_18_1027 VPWR VGND sg13cmos5l_fill_2
XFILLER_41_284 VPWR VGND sg13cmos5l_fill_1
XFILLER_30_947 VPWR VGND sg13cmos5l_decap_8
XFILLER_41_295 VPWR VGND sg13cmos5l_decap_4
XFILLER_10_671 VPWR VGND sg13cmos5l_decap_8
XFILLER_6_675 VPWR VGND sg13cmos5l_decap_8
XFILLER_5_152 VPWR VGND sg13cmos5l_decap_4
XFILLER_2_870 VPWR VGND sg13cmos5l_decap_8
X_2370_ _2388_/B _3771_/Q _3770_/Q _3768_/Q _3769_/Q VPWR VGND sg13cmos5l_nor4_1
XFILLER_49_351 VPWR VGND sg13cmos5l_decap_8
XFILLER_37_502 VPWR VGND sg13cmos5l_fill_1
XFILLER_37_579 VPWR VGND sg13cmos5l_decap_8
X_3618__233 _3618_/RESET_B VPWR VGND sg13cmos5l_tiehi
XFILLER_33_796 VPWR VGND sg13cmos5l_decap_8
X_3755_ _3755_/Q _3783_/CLK _3755_/D _3755_/RESET_B VPWR VGND sg13cmos5l_dfrbpq_1
X_2706_ _3553_/D _3801_/D _2706_/B VPWR VGND sg13cmos5l_nor2_1
X_3686_ _3686_/Q _3783_/CLK _3686_/D _3686_/RESET_B VPWR VGND sg13cmos5l_dfrbpq_1
X_2637_ _3511_/D input5/X hold601/X _2637_/S VPWR VGND sg13cmos5l_mux2_1
XFILLER_0_818 VPWR VGND sg13cmos5l_decap_8
X_2568_ _2568_/Y _2027_/C _2277_/A _2567_/Y VPWR VGND sg13cmos5l_o21ai_1
X_2499_ _2500_/C _3741_/Q _3742_/Q VPWR VGND sg13cmos5l_xor2_1
X_3699__316 _3699_/RESET_B VPWR VGND sg13cmos5l_tiehi
XFILLER_15_229 VPWR VGND sg13cmos5l_fill_2
XFILLER_12_903 VPWR VGND sg13cmos5l_decap_4
XFILLER_24_763 VPWR VGND sg13cmos5l_fill_1
XFILLER_12_947 VPWR VGND sg13cmos5l_fill_1
XFILLER_23_262 VPWR VGND sg13cmos5l_decap_8
XFILLER_23_43 VPWR VGND sg13cmos5l_fill_2
XFILLER_7_439 VPWR VGND sg13cmos5l_decap_8
XFILLER_20_980 VPWR VGND sg13cmos5l_decap_8
XFILLER_3_689 VPWR VGND sg13cmos5l_fill_2
XFILLER_2_188 VPWR VGND sg13cmos5l_fill_2
XFILLER_47_800 VPWR VGND sg13cmos5l_decap_8
XFILLER_46_321 VPWR VGND sg13cmos5l_decap_8
XFILLER_0_14 VPWR VGND sg13cmos5l_decap_8
XFILLER_47_877 VPWR VGND sg13cmos5l_decap_8
XFILLER_15_730 VPWR VGND sg13cmos5l_fill_1
XFILLER_30_722 VPWR VGND sg13cmos5l_fill_1
XFILLER_9_78 VPWR VGND sg13cmos5l_decap_8
X_3540_ _3540_/Q clkload7/A _3540_/D _3540_/RESET_B VPWR VGND sg13cmos5l_dfrbpq_1
XFILLER_11_991 VPWR VGND sg13cmos5l_decap_8
XFILLER_7_995 VPWR VGND sg13cmos5l_decap_8
XFILLER_6_483 VPWR VGND sg13cmos5l_decap_8
X_3471_ _3731_/D _3471_/A _3471_/B _3471_/C VPWR VGND sg13cmos5l_nor3_1
X_2422_ _2422_/Y _3749_/Q _1965_/Y _2421_/Y VPWR VGND sg13cmos5l_o21ai_1
X_2353_ _2353_/Y _2332_/A _2329_/Y _2348_/A _2351_/Y VPWR VGND sg13cmos5l_a22oi_1
XFILLER_9_1025 VPWR VGND sg13cmos5l_decap_4
XFILLER_36_2 VPWR VGND sg13cmos5l_fill_1
X_2284_ _2284_/Y _2284_/A _2284_/B VPWR VGND sg13cmos5l_nand2_1
X_3807_ _3807_/Q _3809_/CLK _3807_/D _3807_/RESET_B VPWR VGND sg13cmos5l_dfrbpq_1
X_1999_ _2251_/B _1999_/A VPWR VGND sg13cmos5l_inv_1
X_3738_ _3738_/Q _3766_/CLK _3738_/D _3738_/RESET_B VPWR VGND sg13cmos5l_dfrbpq_1
X_3669_ _3669_/Q _3698_/CLK _3669_/D _3669_/RESET_B VPWR VGND sg13cmos5l_dfrbpq_1
XFILLER_0_626 VPWR VGND sg13cmos5l_decap_8
XFILLER_48_608 VPWR VGND sg13cmos5l_fill_2
XFILLER_47_118 VPWR VGND sg13cmos5l_fill_2
XFILLER_29_833 VPWR VGND sg13cmos5l_decap_4
XFILLER_18_65 VPWR VGND sg13cmos5l_fill_1
XFILLER_18_76 VPWR VGND sg13cmos5l_decap_4
XFILLER_29_877 VPWR VGND sg13cmos5l_decap_8
XFILLER_44_847 VPWR VGND sg13cmos5l_decap_8
XFILLER_43_324 VPWR VGND sg13cmos5l_fill_2
XFILLER_43_313 VPWR VGND sg13cmos5l_decap_8
XFILLER_16_549 VPWR VGND sg13cmos5l_decap_8
XFILLER_12_711 VPWR VGND sg13cmos5l_fill_2
XFILLER_24_560 VPWR VGND sg13cmos5l_decap_8
XFILLER_24_571 VPWR VGND sg13cmos5l_fill_1
XFILLER_12_744 VPWR VGND sg13cmos5l_decap_8
XFILLER_8_737 VPWR VGND sg13cmos5l_fill_1
XFILLER_4_965 VPWR VGND sg13cmos5l_decap_8
X_3608__243 _3608_/RESET_B VPWR VGND sg13cmos5l_tiehi
XFILLER_19_365 VPWR VGND sg13cmos5l_fill_1
XFILLER_46_173 VPWR VGND sg13cmos5l_decap_8
XFILLER_34_302 VPWR VGND sg13cmos5l_decap_8
X_2971_ _2979_/B _3592_/Q _3593_/Q _2971_/C VPWR VGND sg13cmos5l_or3_1
X_3615__236 _3615_/RESET_B VPWR VGND sg13cmos5l_tiehi
XFILLER_30_585 VPWR VGND sg13cmos5l_decap_8
Xhold737 hold737/X _3140_/Y VPWR VGND sg13cmos5l_dlygate4sd3_1
Xhold726 hold726/X _3207_/A VPWR VGND sg13cmos5l_dlygate4sd3_1
Xhold704 _1975_/A _3766_/Q VPWR VGND sg13cmos5l_dlygate4sd3_1
Xhold715 _3624_/D _3017_/Y VPWR VGND sg13cmos5l_dlygate4sd3_1
X_3523_ _3523_/Q clkload7/A _3523_/D _3523_/RESET_B VPWR VGND sg13cmos5l_dfrbpq_1
Xhold748 hold748/X _2549_/B VPWR VGND sg13cmos5l_dlygate4sd3_1
Xhold759 _3450_/B _3449_/X VPWR VGND sg13cmos5l_dlygate4sd3_1
X_3454_ _3454_/Y _1929_/Y _3454_/A2 _3453_/Y VPWR VGND sg13cmos5l_a21oi_1
X_2405_ _3769_/D _2561_/A _2405_/B VPWR VGND sg13cmos5l_nor2_1
X_3385_ _3385_/Y _3385_/A _3385_/B _3385_/C VPWR VGND sg13cmos5l_nand3_1
X_2336_ _2340_/B _2235_/B _2311_/A _2343_/S VPWR VGND sg13cmos5l_mux2_1
XFILLER_29_107 VPWR VGND sg13cmos5l_fill_2
X_2267_ _2267_/Y _2250_/Y _2269_/S hold663/X VPWR VGND sg13cmos5l_a21oi_1
X_3622__229 _3622_/RESET_B VPWR VGND sg13cmos5l_tiehi
X_2198_ _2198_/Y _2198_/A _2198_/B _2198_/C VPWR VGND sg13cmos5l_nand3_1
XFILLER_25_313 VPWR VGND sg13cmos5l_decap_8
XFILLER_38_1019 VPWR VGND sg13cmos5l_decap_8
X_3659__174 _3659_/RESET_B VPWR VGND sg13cmos5l_tiehi
XFILLER_13_519 VPWR VGND sg13cmos5l_fill_1
XFILLER_40_349 VPWR VGND sg13cmos5l_decap_8
XFILLER_21_552 VPWR VGND sg13cmos5l_decap_8
XFILLER_4_217 VPWR VGND sg13cmos5l_decap_4
XFILLER_0_412 VPWR VGND sg13cmos5l_fill_1
XFILLER_1_913 VPWR VGND sg13cmos5l_decap_8
XFILLER_0_445 VPWR VGND sg13cmos5l_decap_8
XFILLER_21_1001 VPWR VGND sg13cmos5l_decap_8
XFILLER_29_674 VPWR VGND sg13cmos5l_decap_8
XFILLER_44_633 VPWR VGND sg13cmos5l_fill_2
XFILLER_16_313 VPWR VGND sg13cmos5l_decap_8
XFILLER_16_324 VPWR VGND sg13cmos5l_fill_2
XFILLER_17_836 VPWR VGND sg13cmos5l_fill_2
XFILLER_45_63 VPWR VGND sg13cmos5l_fill_1
XFILLER_16_335 VPWR VGND sg13cmos5l_decap_8
XFILLER_8_578 VPWR VGND sg13cmos5l_fill_1
XFILLER_4_762 VPWR VGND sg13cmos5l_fill_2
XFILLER_3_283 VPWR VGND sg13cmos5l_fill_2
X_3170_ _3170_/Y _3157_/Y _3168_/Y _3169_/Y VPWR VGND sg13cmos5l_a21oi_1
X_2121_ _2121_/Y _2119_/Y _2120_/Y _2115_/Y VPWR VGND sg13cmos5l_o21ai_1
XFILLER_13_4 VPWR VGND sg13cmos5l_decap_8
XFILLER_48_950 VPWR VGND sg13cmos5l_decap_8
X_2052_ _2056_/A _3702_/Q _2053_/B VPWR VGND sg13cmos5l_xnor2_1
X_3580__276 _3580_/RESET_B VPWR VGND sg13cmos5l_tiehi
XFILLER_47_493 VPWR VGND sg13cmos5l_decap_8
XFILLER_35_644 VPWR VGND sg13cmos5l_decap_8
XFILLER_35_688 VPWR VGND sg13cmos5l_decap_8
XFILLER_35_699 VPWR VGND sg13cmos5l_fill_1
X_2954_ _2954_/Y _3615_/Q _3637_/Q _3614_/Q VPWR VGND sg13cmos5l_nand3b_1
XFILLER_31_850 VPWR VGND sg13cmos5l_fill_2
X_2885_ _2891_/B _2775_/Y _2888_/B _2884_/Y VPWR VGND sg13cmos5l_o21ai_1
Xhold501 hold501/X _3565_/Q VPWR VGND sg13cmos5l_dlygate4sd3_1
X_3506_ _3506_/Q clkload7/A _3506_/D _3506_/RESET_B VPWR VGND sg13cmos5l_dfrbpq_1
Xhold523 _2702_/B _2701_/Y VPWR VGND sg13cmos5l_dlygate4sd3_1
Xhold545 _3781_/D _2459_/Y VPWR VGND sg13cmos5l_dlygate4sd3_1
Xhold534 hold534/X _3807_/Q VPWR VGND sg13cmos5l_dlygate4sd3_1
Xhold512 _1934_/A _3628_/Q VPWR VGND sg13cmos5l_dlygate4sd3_1
Xhold578 hold578/X _3502_/Q VPWR VGND sg13cmos5l_dlygate4sd3_1
Xhold556 hold556/X _3526_/Q VPWR VGND sg13cmos5l_dlygate4sd3_1
Xhold567 hold567/X _3531_/Q VPWR VGND sg13cmos5l_dlygate4sd3_1
XFILLER_44_1001 VPWR VGND sg13cmos5l_decap_8
Xhold589 hold589/X _3541_/Q VPWR VGND sg13cmos5l_dlygate4sd3_1
X_3437_ _3437_/Y _3733_/Q _3437_/B _3437_/C VPWR VGND sg13cmos5l_nand3_1
X_3368_ _3378_/A _3698_/Q _3376_/B VPWR VGND sg13cmos5l_nor2_1
X_2319_ _2319_/Y _3752_/Q _3723_/Q VPWR VGND sg13cmos5l_xnor2_1
XFILLER_46_909 VPWR VGND sg13cmos5l_decap_8
X_3299_ _3391_/A _3298_/Y _3109_/X _3299_/S VPWR VGND sg13cmos5l_mux2_1
XFILLER_39_994 VPWR VGND sg13cmos5l_decap_8
XFILLER_26_611 VPWR VGND sg13cmos5l_fill_1
XFILLER_38_493 VPWR VGND sg13cmos5l_decap_8
XFILLER_26_644 VPWR VGND sg13cmos5l_decap_8
XFILLER_13_316 VPWR VGND sg13cmos5l_decap_8
XFILLER_15_11 VPWR VGND sg13cmos5l_decap_8
XFILLER_25_143 VPWR VGND sg13cmos5l_fill_1
XFILLER_26_699 VPWR VGND sg13cmos5l_fill_2
XFILLER_41_636 VPWR VGND sg13cmos5l_decap_8
XFILLER_40_135 VPWR VGND sg13cmos5l_fill_2
XFILLER_40_102 VPWR VGND sg13cmos5l_decap_8
XFILLER_25_187 VPWR VGND sg13cmos5l_fill_2
XFILLER_5_537 VPWR VGND sg13cmos5l_decap_8
XFILLER_0_220 VPWR VGND sg13cmos5l_decap_8
XFILLER_49_714 VPWR VGND sg13cmos5l_decap_8
XFILLER_1_787 VPWR VGND sg13cmos5l_decap_8
XFILLER_49_747 VPWR VGND sg13cmos5l_decap_8
XFILLER_49_736 VPWR VGND sg13cmos5l_fill_1
X_3605__246 _3605_/RESET_B VPWR VGND sg13cmos5l_tiehi
XFILLER_45_931 VPWR VGND sg13cmos5l_decap_8
XFILLER_17_622 VPWR VGND sg13cmos5l_fill_2
XFILLER_44_474 VPWR VGND sg13cmos5l_decap_8
XFILLER_44_452 VPWR VGND sg13cmos5l_fill_2
XFILLER_44_496 VPWR VGND sg13cmos5l_fill_2
XFILLER_9_843 VPWR VGND sg13cmos5l_decap_8
X_2670_ _3535_/D input12/X hold586/X _2671_/S VPWR VGND sg13cmos5l_mux2_1
X_3612__239 _3612_/RESET_B VPWR VGND sg13cmos5l_tiehi
XFILLER_4_570 VPWR VGND sg13cmos5l_decap_8
XFILLER_28_1018 VPWR VGND sg13cmos5l_decap_8
X_3222_ _3223_/A _3222_/A _3222_/B _3222_/C VPWR VGND sg13cmos5l_or3_1
XFILLER_39_224 VPWR VGND sg13cmos5l_decap_4
X_3153_ _3153_/Y _3349_/A _3352_/A VPWR VGND sg13cmos5l_nor2_1
XFILLER_39_257 VPWR VGND sg13cmos5l_decap_8
X_2104_ _2104_/X _2104_/A _2104_/B _3249_/A VPWR VGND sg13cmos5l_and3_1
XFILLER_39_279 VPWR VGND sg13cmos5l_fill_1
X_3084_ _3084_/Y _3641_/Q _3642_/Q VPWR VGND sg13cmos5l_xnor2_1
XFILLER_36_931 VPWR VGND sg13cmos5l_decap_8
X_2035_ _2035_/X _2564_/A _2745_/A VPWR VGND sg13cmos5l_and2_1
X_3617__117 _3617_/D VPWR VGND sg13cmos5l_tielo
XFILLER_22_157 VPWR VGND sg13cmos5l_decap_8
X_2937_ _2939_/B _2937_/A _2938_/A VPWR VGND sg13cmos5l_nor2b_1
XFILLER_30_190 VPWR VGND sg13cmos5l_decap_8
X_2868_ _2913_/A hold732/X _2981_/A _2871_/A VPWR VGND sg13cmos5l_mux2_1
X_2799_ _2800_/A _2797_/Y _2798_/Y _2790_/A VPWR VGND sg13cmos5l_o21ai_1
XFILLER_2_507 VPWR VGND sg13cmos5l_decap_4
XFILLER_39_791 VPWR VGND sg13cmos5l_decap_4
XFILLER_27_964 VPWR VGND sg13cmos5l_decap_8
XFILLER_42_923 VPWR VGND sg13cmos5l_decap_8
XFILLER_26_474 VPWR VGND sg13cmos5l_decap_8
XFILLER_14_636 VPWR VGND sg13cmos5l_fill_2
XFILLER_26_76 VPWR VGND sg13cmos5l_fill_2
XFILLER_41_444 VPWR VGND sg13cmos5l_decap_8
XFILLER_9_106 VPWR VGND sg13cmos5l_decap_8
X_3750__143 _3750_/RESET_B VPWR VGND sg13cmos5l_tiehi
XFILLER_6_813 VPWR VGND sg13cmos5l_decap_8
XFILLER_10_897 VPWR VGND sg13cmos5l_decap_4
XFILLER_3_69 VPWR VGND sg13cmos5l_fill_1
XFILLER_49_555 VPWR VGND sg13cmos5l_decap_8
XFILLER_18_920 VPWR VGND sg13cmos5l_decap_8
XFILLER_36_205 VPWR VGND sg13cmos5l_fill_1
XFILLER_18_953 VPWR VGND sg13cmos5l_decap_8
XFILLER_32_400 VPWR VGND sg13cmos5l_fill_1
XFILLER_33_978 VPWR VGND sg13cmos5l_decap_8
X_3771_ _3771_/Q clkload5/A _3771_/D _3771_/RESET_B VPWR VGND sg13cmos5l_dfrbpq_1
X_2722_ _2723_/A hold717/X _2607_/X _2724_/B VPWR VGND sg13cmos5l_o21ai_1
XFILLER_8_161 VPWR VGND sg13cmos5l_decap_8
X_2653_ _2653_/Y input8/X _2725_/A VPWR VGND sg13cmos5l_nor2_1
X_2584_ _2584_/Y _2592_/B _2583_/Y _2592_/A VPWR VGND sg13cmos5l_a21oi_1
XFILLER_41_1026 VPWR VGND sg13cmos5l_fill_2
X_3205_ _3206_/B _3208_/A _3216_/B VPWR VGND sg13cmos5l_nor2_1
X_3662__170 _3662_/RESET_B VPWR VGND sg13cmos5l_tiehi
X_3136_ _3136_/Y _3638_/Q _3136_/B _3189_/A VPWR VGND sg13cmos5l_nor3_1
X_3067_ _3071_/A _3067_/A _3073_/B _3073_/C VPWR VGND sg13cmos5l_or3_1
XFILLER_27_249 VPWR VGND sg13cmos5l_decap_8
X_2018_ _3809_/D _2018_/A VPWR VGND sg13cmos5l_inv_1
XFILLER_24_989 VPWR VGND sg13cmos5l_decap_8
XFILLER_10_105 VPWR VGND sg13cmos5l_decap_8
XFILLER_6_109 VPWR VGND sg13cmos5l_fill_2
XFILLER_12_89 VPWR VGND sg13cmos5l_fill_2
XFILLER_18_249 VPWR VGND sg13cmos5l_decap_8
XFILLER_15_912 VPWR VGND sg13cmos5l_fill_2
XFILLER_14_400 VPWR VGND sg13cmos5l_decap_8
XFILLER_14_422 VPWR VGND sg13cmos5l_fill_1
XFILLER_15_934 VPWR VGND sg13cmos5l_decap_8
XFILLER_42_786 VPWR VGND sg13cmos5l_decap_8
XFILLER_30_926 VPWR VGND sg13cmos5l_decap_8
XFILLER_6_621 VPWR VGND sg13cmos5l_decap_8
XFILLER_37_558 VPWR VGND sg13cmos5l_decap_8
XFILLER_37_536 VPWR VGND sg13cmos5l_decap_8
XFILLER_18_772 VPWR VGND sg13cmos5l_decap_8
XFILLER_33_720 VPWR VGND sg13cmos5l_fill_1
XFILLER_33_753 VPWR VGND sg13cmos5l_decap_8
XFILLER_20_425 VPWR VGND sg13cmos5l_fill_2
XFILLER_21_959 VPWR VGND sg13cmos5l_decap_8
X_3754_ _3754_/Q _3783_/CLK _3754_/D _3754_/RESET_B VPWR VGND sg13cmos5l_dfrbpq_1
XFILLER_20_469 VPWR VGND sg13cmos5l_decap_8
X_2705_ _2705_/Y _3553_/Q _2692_/A _2693_/B hold499/X VPWR VGND sg13cmos5l_a22oi_1
XFILLER_9_481 VPWR VGND sg13cmos5l_decap_4
X_3685_ _3685_/Q _3728_/CLK _3685_/D _3685_/RESET_B VPWR VGND sg13cmos5l_dfrbpq_1
X_2636_ _2636_/X input13/X hold609/X _2636_/S VPWR VGND sg13cmos5l_mux2_1
X_2567_ _2567_/Y _2567_/A _2567_/B VPWR VGND sg13cmos5l_nor2_1
X_3781__434 _3781_/RESET_B VPWR VGND sg13cmos5l_tiehi
X_2498_ _2501_/A _2465_/A _2498_/B _2507_/A VPWR VGND sg13cmos5l_nand3b_1
X_3119_ _3120_/B _3621_/Q _3126_/B VPWR VGND sg13cmos5l_nand2b_1
XFILLER_43_539 VPWR VGND sg13cmos5l_decap_8
XFILLER_36_591 VPWR VGND sg13cmos5l_fill_2
XFILLER_8_919 VPWR VGND sg13cmos5l_decap_8
XFILLER_23_22 VPWR VGND sg13cmos5l_decap_8
XFILLER_11_469 VPWR VGND sg13cmos5l_decap_8
XFILLER_3_668 VPWR VGND sg13cmos5l_decap_8
XFILLER_2_134 VPWR VGND sg13cmos5l_decap_4
XFILLER_24_1010 VPWR VGND sg13cmos5l_decap_8
XFILLER_46_300 VPWR VGND sg13cmos5l_decap_4
XFILLER_47_856 VPWR VGND sg13cmos5l_decap_8
XFILLER_19_558 VPWR VGND sg13cmos5l_decap_8
XFILLER_34_539 VPWR VGND sg13cmos5l_fill_2
XFILLER_27_591 VPWR VGND sg13cmos5l_decap_8
XFILLER_14_274 VPWR VGND sg13cmos5l_decap_8
XFILLER_9_57 VPWR VGND sg13cmos5l_decap_8
XFILLER_30_745 VPWR VGND sg13cmos5l_fill_2
XFILLER_11_970 VPWR VGND sg13cmos5l_decap_8
XFILLER_7_974 VPWR VGND sg13cmos5l_decap_8
X_3470_ _3471_/C _3470_/A _3469_/A VPWR VGND sg13cmos5l_nor2b_1
XFILLER_43_4 VPWR VGND sg13cmos5l_decap_4
X_2421_ _2421_/Y _2421_/A _3791_/Q VPWR VGND sg13cmos5l_nand2_1
XFILLER_9_1004 VPWR VGND sg13cmos5l_decap_8
X_2352_ _2352_/Y _2348_/A _2351_/Y _2346_/Y VPWR VGND sg13cmos5l_o21ai_1
X_2283_ _2740_/A hold534/X _2279_/Y _2282_/Y VPWR VGND sg13cmos5l_a21oi_1
XFILLER_38_812 VPWR VGND sg13cmos5l_fill_1
XFILLER_37_322 VPWR VGND sg13cmos5l_decap_8
XFILLER_40_509 VPWR VGND sg13cmos5l_decap_8
XFILLER_33_550 VPWR VGND sg13cmos5l_decap_8
X_3555__321 _3555_/RESET_B VPWR VGND sg13cmos5l_tiehi
XFILLER_20_255 VPWR VGND sg13cmos5l_decap_4
X_3806_ _3806_/Q _3806_/CLK _3806_/D _3806_/RESET_B VPWR VGND sg13cmos5l_dfrbpq_1
XFILLER_21_778 VPWR VGND sg13cmos5l_decap_8
X_3737_ _3737_/Q _3766_/CLK _3737_/D _3737_/RESET_B VPWR VGND sg13cmos5l_dfrbpq_1
X_1998_ _2256_/B _1998_/A VPWR VGND sg13cmos5l_inv_1
XFILLER_20_288 VPWR VGND sg13cmos5l_decap_4
X_3668_ _3668_/Q _3698_/CLK _3668_/D _3668_/RESET_B VPWR VGND sg13cmos5l_dfrbpq_1
XFILLER_47_1010 VPWR VGND sg13cmos5l_decap_8
X_3599_ _3599_/Q _3665_/CLK _3599_/D _3599_/RESET_B VPWR VGND sg13cmos5l_dfrbpq_1
X_2619_ _2627_/S _2663_/A _2628_/C VPWR VGND sg13cmos5l_nand2_1
XFILLER_18_11 VPWR VGND sg13cmos5l_decap_8
XFILLER_44_826 VPWR VGND sg13cmos5l_decap_8
XFILLER_43_369 VPWR VGND sg13cmos5l_decap_8
XFILLER_34_43 VPWR VGND sg13cmos5l_decap_8
XFILLER_8_705 VPWR VGND sg13cmos5l_fill_2
XFILLER_11_244 VPWR VGND sg13cmos5l_decap_8
XFILLER_12_767 VPWR VGND sg13cmos5l_fill_1
XFILLER_4_944 VPWR VGND sg13cmos5l_decap_8
XFILLER_3_454 VPWR VGND sg13cmos5l_decap_4
XFILLER_1_0 VPWR VGND sg13cmos5l_decap_8
XFILLER_3_498 VPWR VGND sg13cmos5l_decap_8
XFILLER_19_322 VPWR VGND sg13cmos5l_decap_4
XFILLER_47_642 VPWR VGND sg13cmos5l_fill_2
XFILLER_46_141 VPWR VGND sg13cmos5l_decap_8
XFILLER_35_826 VPWR VGND sg13cmos5l_decap_4
XFILLER_34_347 VPWR VGND sg13cmos5l_decap_8
X_2970_ _3616_/D _3072_/A _2970_/B VPWR VGND sg13cmos5l_nor2_1
XFILLER_22_509 VPWR VGND sg13cmos5l_fill_2
XFILLER_43_892 VPWR VGND sg13cmos5l_decap_8
XFILLER_7_760 VPWR VGND sg13cmos5l_decap_8
XFILLER_7_771 VPWR VGND sg13cmos5l_fill_2
Xhold727 _2464_/A _3763_/Q VPWR VGND sg13cmos5l_dlygate4sd3_1
Xhold716 _1985_/A _3702_/Q VPWR VGND sg13cmos5l_dlygate4sd3_1
Xhold705 _2026_/A _3805_/Q VPWR VGND sg13cmos5l_dlygate4sd3_1
X_3522_ _3522_/Q clkload6/A _3522_/D _3522_/RESET_B VPWR VGND sg13cmos5l_dfrbpq_1
Xhold738 _3143_/B _3141_/Y VPWR VGND sg13cmos5l_dlygate4sd3_1
Xhold749 _2337_/A _3758_/Q VPWR VGND sg13cmos5l_dlygate4sd3_1
X_3453_ _3453_/Y _3720_/Q _3454_/A2 _3460_/A VPWR VGND sg13cmos5l_o21ai_1
X_2404_ _2404_/Y _2399_/S _2401_/Y _2402_/Y VPWR VGND sg13cmos5l_a21oi_1
X_3384_ _3384_/X _3385_/B _3385_/C VPWR VGND sg13cmos5l_and2_1
XFILLER_34_0 VPWR VGND sg13cmos5l_decap_8
X_2335_ _2340_/A _2342_/B _2335_/B VPWR VGND sg13cmos5l_nor2_1
X_2266_ _2266_/Y hold662/X _2269_/S _2304_/B VPWR VGND sg13cmos5l_o21ai_1
XFILLER_38_642 VPWR VGND sg13cmos5l_fill_1
X_2197_ _3737_/D _2307_/B _2311_/A VPWR VGND sg13cmos5l_nor2_1
XFILLER_37_174 VPWR VGND sg13cmos5l_decap_8
XFILLER_37_163 VPWR VGND sg13cmos5l_fill_2
XFILLER_37_185 VPWR VGND sg13cmos5l_fill_1
XFILLER_41_829 VPWR VGND sg13cmos5l_decap_8
XFILLER_21_597 VPWR VGND sg13cmos5l_fill_2
XFILLER_5_708 VPWR VGND sg13cmos5l_fill_2
XFILLER_0_424 VPWR VGND sg13cmos5l_decap_8
XFILLER_1_969 VPWR VGND sg13cmos5l_decap_8
XFILLER_49_929 VPWR VGND sg13cmos5l_decap_8
XFILLER_29_642 VPWR VGND sg13cmos5l_decap_8
XFILLER_29_653 VPWR VGND sg13cmos5l_decap_8
XFILLER_44_612 VPWR VGND sg13cmos5l_decap_8
XFILLER_17_815 VPWR VGND sg13cmos5l_decap_8
XFILLER_28_185 VPWR VGND sg13cmos5l_fill_1
XFILLER_31_306 VPWR VGND sg13cmos5l_decap_8
XFILLER_25_892 VPWR VGND sg13cmos5l_decap_8
XFILLER_8_546 VPWR VGND sg13cmos5l_decap_4
XFILLER_6_58 VPWR VGND sg13cmos5l_decap_8
XFILLER_4_752 VPWR VGND sg13cmos5l_fill_1
XFILLER_3_273 VPWR VGND sg13cmos5l_fill_1
XFILLER_39_428 VPWR VGND sg13cmos5l_fill_1
X_2120_ _2120_/Y _3731_/Q _2116_/Y _2305_/A VPWR VGND sg13cmos5l_a21oi_1
X_2051_ _2055_/B _3701_/Q _3463_/A _3702_/Q VPWR VGND sg13cmos5l_nor3_1
X_3621__230 _3621_/RESET_B VPWR VGND sg13cmos5l_tiehi
XFILLER_47_472 VPWR VGND sg13cmos5l_decap_8
XFILLER_34_133 VPWR VGND sg13cmos5l_decap_4
XFILLER_23_829 VPWR VGND sg13cmos5l_decap_8
X_2953_ _2953_/X _2956_/A _2956_/C _2956_/B VPWR VGND sg13cmos5l_a21o_1
XFILLER_15_380 VPWR VGND sg13cmos5l_decap_4
XFILLER_31_862 VPWR VGND sg13cmos5l_fill_1
XFILLER_31_873 VPWR VGND sg13cmos5l_fill_1
X_2884_ _2884_/Y _3031_/A _3029_/A _2888_/B VPWR VGND sg13cmos5l_nand3_1
Xhold502 _2704_/B _2703_/Y VPWR VGND sg13cmos5l_dlygate4sd3_1
Xhold524 _2754_/A _3570_/Q VPWR VGND sg13cmos5l_dlygate4sd3_1
Xhold535 _2742_/A _2740_/A VPWR VGND sg13cmos5l_dlygate4sd3_1
Xhold513 _2843_/A _3580_/Q VPWR VGND sg13cmos5l_dlygate4sd3_1
X_3505_ _3505_/Q clkload6/A _3505_/D _3505_/RESET_B VPWR VGND sg13cmos5l_dfrbpq_1
Xhold568 hold568/X _3544_/Q VPWR VGND sg13cmos5l_dlygate4sd3_1
Xhold546 hold546/X _3533_/Q VPWR VGND sg13cmos5l_dlygate4sd3_1
Xhold557 hold557/X _3490_/Q VPWR VGND sg13cmos5l_dlygate4sd3_1
Xhold579 _1937_/A _3602_/Q VPWR VGND sg13cmos5l_dlygate4sd3_1
X_3436_ _3436_/Y _3684_/Q _3436_/B VPWR VGND sg13cmos5l_nand2_1
X_3367_ _3396_/B _3365_/Y _3366_/Y _3364_/Y VPWR VGND sg13cmos5l_a21oi_1
X_2318_ _2333_/B _3754_/Q _3725_/Q VPWR VGND sg13cmos5l_nand2_1
XFILLER_39_973 VPWR VGND sg13cmos5l_decap_8
X_3778__439 _3778_/RESET_B VPWR VGND sg13cmos5l_tiehi
X_3298_ _3298_/Y _3298_/A _3298_/B VPWR VGND sg13cmos5l_nor2_1
XFILLER_38_483 VPWR VGND sg13cmos5l_fill_1
XFILLER_38_472 VPWR VGND sg13cmos5l_fill_1
X_2249_ _2249_/Y _2257_/B _3763_/Q VPWR VGND sg13cmos5l_nor2b_1
XFILLER_25_122 VPWR VGND sg13cmos5l_fill_2
XFILLER_41_615 VPWR VGND sg13cmos5l_fill_1
XFILLER_26_678 VPWR VGND sg13cmos5l_fill_2
XFILLER_22_840 VPWR VGND sg13cmos5l_decap_4
XFILLER_21_372 VPWR VGND sg13cmos5l_decap_8
XFILLER_22_884 VPWR VGND sg13cmos5l_decap_8
XFILLER_5_516 VPWR VGND sg13cmos5l_fill_2
XFILLER_31_77 VPWR VGND sg13cmos5l_fill_1
XFILLER_1_766 VPWR VGND sg13cmos5l_decap_8
XFILLER_0_298 VPWR VGND sg13cmos5l_decap_8
XFILLER_45_910 VPWR VGND sg13cmos5l_decap_8
XFILLER_29_461 VPWR VGND sg13cmos5l_fill_2
XFILLER_44_431 VPWR VGND sg13cmos5l_decap_8
XFILLER_45_987 VPWR VGND sg13cmos5l_decap_8
XFILLER_32_637 VPWR VGND sg13cmos5l_decap_8
XFILLER_13_840 VPWR VGND sg13cmos5l_fill_2
XFILLER_13_862 VPWR VGND sg13cmos5l_decap_8
XFILLER_31_136 VPWR VGND sg13cmos5l_decap_8
XFILLER_31_147 VPWR VGND sg13cmos5l_fill_1
XFILLER_8_310 VPWR VGND sg13cmos5l_decap_8
XFILLER_9_833 VPWR VGND sg13cmos5l_decap_4
XFILLER_8_387 VPWR VGND sg13cmos5l_decap_8
XFILLER_8_376 VPWR VGND sg13cmos5l_decap_8
XFILLER_9_899 VPWR VGND sg13cmos5l_decap_8
XFILLER_8_398 VPWR VGND sg13cmos5l_decap_8
X_3221_ _3221_/X _3221_/A _3221_/B _3221_/C VPWR VGND sg13cmos5l_and3_1
XFILLER_39_203 VPWR VGND sg13cmos5l_decap_8
X_3152_ _3152_/Y _3625_/Q _3152_/B _3160_/B VPWR VGND sg13cmos5l_nor3_1
X_2103_ _2103_/Y _3700_/Q _2094_/Y _2101_/Y _2102_/Y VPWR VGND sg13cmos5l_a22oi_1
X_3083_ _3085_/B _3667_/Q _3641_/Q VPWR VGND sg13cmos5l_nand2_1
X_2034_ _2745_/A _2698_/A _2024_/B VPWR VGND sg13cmos5l_nor2b_1
XFILLER_36_987 VPWR VGND sg13cmos5l_decap_8
X_2936_ _3610_/D _2936_/A _2936_/B VPWR VGND sg13cmos5l_nor2_1
XFILLER_10_309 VPWR VGND sg13cmos5l_decap_8
XFILLER_31_670 VPWR VGND sg13cmos5l_fill_2
X_2867_ _2981_/A _3028_/A _2982_/A VPWR VGND sg13cmos5l_nand2_1
XFILLER_11_1012 VPWR VGND sg13cmos5l_decap_8
X_2798_ _2798_/Y _2826_/A1 _3497_/Q _2826_/B1 VPWR VGND sg13cmos5l_o21ai_1
X_3419_ _3711_/D _3466_/B _3419_/B VPWR VGND sg13cmos5l_nor2_1
XFILLER_45_206 VPWR VGND sg13cmos5l_decap_4
XFILLER_27_943 VPWR VGND sg13cmos5l_decap_8
XFILLER_42_902 VPWR VGND sg13cmos5l_decap_8
XFILLER_14_615 VPWR VGND sg13cmos5l_decap_8
XFILLER_42_979 VPWR VGND sg13cmos5l_decap_8
XFILLER_42_32 VPWR VGND sg13cmos5l_fill_2
XFILLER_41_478 VPWR VGND sg13cmos5l_decap_8
XFILLER_22_692 VPWR VGND sg13cmos5l_fill_1
XFILLER_10_865 VPWR VGND sg13cmos5l_decap_8
XFILLER_21_191 VPWR VGND sg13cmos5l_fill_1
X_3611__240 _3611_/RESET_B VPWR VGND sg13cmos5l_tiehi
XFILLER_6_869 VPWR VGND sg13cmos5l_decap_8
XFILLER_5_335 VPWR VGND sg13cmos5l_fill_1
XFILLER_49_512 VPWR VGND sg13cmos5l_decap_8
XFILLER_49_534 VPWR VGND sg13cmos5l_decap_8
X_3722__224 _3722_/RESET_B VPWR VGND sg13cmos5l_tiehi
XFILLER_37_718 VPWR VGND sg13cmos5l_decap_8
XFILLER_45_740 VPWR VGND sg13cmos5l_decap_8
XFILLER_45_784 VPWR VGND sg13cmos5l_decap_8
XFILLER_32_445 VPWR VGND sg13cmos5l_fill_2
XFILLER_32_456 VPWR VGND sg13cmos5l_decap_8
XFILLER_33_957 VPWR VGND sg13cmos5l_decap_8
X_3770_ _3770_/Q clkload4/A _3770_/D _3770_/RESET_B VPWR VGND sg13cmos5l_dfrbpq_1
X_2721_ _2724_/B hold717/X _2607_/X _3477_/A VPWR VGND sg13cmos5l_a21oi_1
X_2652_ _3521_/D input7/X hold565/X _2725_/A VPWR VGND sg13cmos5l_mux2_1
X_2583_ _2583_/Y _2014_/C _3806_/Q VPWR VGND sg13cmos5l_nand2b_1
XFILLER_5_880 VPWR VGND sg13cmos5l_decap_8
X_3204_ _3222_/A _3221_/B _3221_/C _3221_/A VPWR VGND sg13cmos5l_a21oi_1
XFILLER_41_1005 VPWR VGND sg13cmos5l_decap_8
X_3135_ _3646_/D _3143_/A _3135_/B VPWR VGND sg13cmos5l_nor2_1
X_3066_ _3073_/C _3051_/A _3051_/B _3059_/X _3064_/Y _3065_/Y VPWR VGND sg13cmos5l_a221oi_1
XFILLER_27_228 VPWR VGND sg13cmos5l_decap_8
XFILLER_42_209 VPWR VGND sg13cmos5l_decap_8
X_2017_ _2018_/A _3805_/D _3802_/D VPWR VGND sg13cmos5l_nor2_1
XFILLER_36_784 VPWR VGND sg13cmos5l_decap_8
XFILLER_23_412 VPWR VGND sg13cmos5l_fill_1
XFILLER_35_261 VPWR VGND sg13cmos5l_fill_2
XFILLER_35_283 VPWR VGND sg13cmos5l_fill_1
XFILLER_23_456 VPWR VGND sg13cmos5l_fill_1
XFILLER_24_968 VPWR VGND sg13cmos5l_decap_8
X_2919_ _2923_/B _2919_/A _2919_/B _2928_/A VPWR VGND sg13cmos5l_and3_1
XFILLER_12_68 VPWR VGND sg13cmos5l_decap_8
X_3565__301 _3565_/RESET_B VPWR VGND sg13cmos5l_tiehi
XFILLER_46_515 VPWR VGND sg13cmos5l_decap_8
XFILLER_37_32 VPWR VGND sg13cmos5l_decap_4
XFILLER_19_718 VPWR VGND sg13cmos5l_decap_4
XFILLER_19_729 VPWR VGND sg13cmos5l_decap_8
XFILLER_46_559 VPWR VGND sg13cmos5l_decap_8
XFILLER_2_1010 VPWR VGND sg13cmos5l_decap_8
XFILLER_30_905 VPWR VGND sg13cmos5l_decap_8
XFILLER_10_651 VPWR VGND sg13cmos5l_decap_4
XFILLER_6_633 VPWR VGND sg13cmos5l_decap_8
XFILLER_6_688 VPWR VGND sg13cmos5l_decap_8
XFILLER_5_198 VPWR VGND sg13cmos5l_decap_4
XFILLER_5_176 VPWR VGND sg13cmos5l_decap_8
XFILLER_49_320 VPWR VGND sg13cmos5l_decap_8
XFILLER_49_386 VPWR VGND sg13cmos5l_fill_1
XFILLER_37_526 VPWR VGND sg13cmos5l_decap_4
XFILLER_21_905 VPWR VGND sg13cmos5l_fill_2
XFILLER_21_938 VPWR VGND sg13cmos5l_decap_8
XFILLER_32_297 VPWR VGND sg13cmos5l_fill_2
X_3753_ _3753_/Q _3783_/CLK _3753_/D _3753_/RESET_B VPWR VGND sg13cmos5l_dfrbpq_1
X_2704_ _3552_/D _3801_/D _2704_/B VPWR VGND sg13cmos5l_nor2_1
X_3684_ _3684_/Q _3728_/CLK _3684_/D _3684_/RESET_B VPWR VGND sg13cmos5l_dfrbpq_1
X_2635_ _3509_/D input12/X hold588/X _2637_/S VPWR VGND sg13cmos5l_mux2_1
X_2566_ _2573_/A _2567_/B VPWR VGND sg13cmos5l_inv_1
X_2497_ _2521_/A _3763_/Q _2493_/X _2496_/Y VPWR VGND sg13cmos5l_a21o_1
X_3118_ _3126_/B _3620_/Q _3618_/Q _3619_/Q VPWR VGND sg13cmos5l_or3_1
XFILLER_43_518 VPWR VGND sg13cmos5l_decap_8
XFILLER_36_570 VPWR VGND sg13cmos5l_decap_8
X_3049_ _3051_/A _3073_/A VPWR VGND sg13cmos5l_inv_1
XFILLER_24_754 VPWR VGND sg13cmos5l_decap_8
XFILLER_11_404 VPWR VGND sg13cmos5l_decap_8
XFILLER_23_242 VPWR VGND sg13cmos5l_fill_2
XFILLER_23_45 VPWR VGND sg13cmos5l_fill_1
XFILLER_23_286 VPWR VGND sg13cmos5l_decap_8
XFILLER_23_297 VPWR VGND sg13cmos5l_fill_1
XFILLER_11_459 VPWR VGND sg13cmos5l_fill_1
XFILLER_3_625 VPWR VGND sg13cmos5l_decap_8
XFILLER_3_4 VPWR VGND sg13cmos5l_fill_1
XFILLER_2_157 VPWR VGND sg13cmos5l_decap_8
XFILLER_47_835 VPWR VGND sg13cmos5l_decap_8
XFILLER_46_334 VPWR VGND sg13cmos5l_decap_8
XFILLER_0_49 VPWR VGND sg13cmos5l_decap_8
XFILLER_46_378 VPWR VGND sg13cmos5l_fill_1
X_3676__137 _3676_/RESET_B VPWR VGND sg13cmos5l_tiehi
XFILLER_27_570 VPWR VGND sg13cmos5l_fill_2
XFILLER_14_231 VPWR VGND sg13cmos5l_fill_2
XFILLER_15_743 VPWR VGND sg13cmos5l_decap_8
XFILLER_9_25 VPWR VGND sg13cmos5l_decap_8
XFILLER_42_584 VPWR VGND sg13cmos5l_decap_8
XFILLER_7_953 VPWR VGND sg13cmos5l_decap_8
XFILLER_10_470 VPWR VGND sg13cmos5l_decap_4
XFILLER_31_1026 VPWR VGND sg13cmos5l_fill_2
XFILLER_6_463 VPWR VGND sg13cmos5l_fill_1
X_2420_ _2420_/Y _3748_/Q _1966_/Y _1967_/Y _3747_/Q _2419_/Y VPWR VGND sg13cmos5l_a221oi_1
X_2351_ _2351_/Y _2332_/A _2332_/B _2350_/Y VPWR VGND sg13cmos5l_o21ai_1
X_2282_ _2282_/Y _2282_/A _2282_/B VPWR VGND sg13cmos5l_nand2_1
XFILLER_49_161 VPWR VGND sg13cmos5l_fill_2
XFILLER_38_824 VPWR VGND sg13cmos5l_decap_4
XFILLER_37_356 VPWR VGND sg13cmos5l_decap_4
XFILLER_37_389 VPWR VGND sg13cmos5l_decap_4
XFILLER_21_702 VPWR VGND sg13cmos5l_decap_8
XFILLER_20_223 VPWR VGND sg13cmos5l_decap_8
XFILLER_21_746 VPWR VGND sg13cmos5l_decap_8
X_1997_ _2261_/A _3718_/Q VPWR VGND sg13cmos5l_inv_1
XFILLER_20_234 VPWR VGND sg13cmos5l_decap_8
XFILLER_21_757 VPWR VGND sg13cmos5l_decap_8
X_3805_ _3805_/Q _3809_/CLK _3805_/D _3805_/RESET_B VPWR VGND sg13cmos5l_dfrbpq_1
X_3736_ _3736_/Q _3766_/CLK _3736_/D _3736_/RESET_B VPWR VGND sg13cmos5l_dfrbpq_1
X_3667_ _3667_/Q _3698_/CLK _3667_/D _3667_/RESET_B VPWR VGND sg13cmos5l_dfrbpq_1
X_3598_ _3598_/Q _3665_/CLK _3598_/D _3598_/RESET_B VPWR VGND sg13cmos5l_dfrbpq_1
X_2618_ _2628_/C _3559_/Q _3560_/Q VPWR VGND sg13cmos5l_nor2b_1
X_2549_ _2560_/C _2549_/A _2549_/B VPWR VGND sg13cmos5l_nand2_1
XFILLER_44_805 VPWR VGND sg13cmos5l_decap_8
XFILLER_18_45 VPWR VGND sg13cmos5l_fill_2
XFILLER_43_326 VPWR VGND sg13cmos5l_fill_1
XFILLER_28_389 VPWR VGND sg13cmos5l_fill_1
XFILLER_12_713 VPWR VGND sg13cmos5l_fill_1
XFILLER_11_201 VPWR VGND sg13cmos5l_fill_2
XFILLER_11_223 VPWR VGND sg13cmos5l_decap_8
XFILLER_24_595 VPWR VGND sg13cmos5l_decap_8
XFILLER_7_227 VPWR VGND sg13cmos5l_decap_8
XFILLER_4_923 VPWR VGND sg13cmos5l_decap_8
X_3747__149 _3747_/RESET_B VPWR VGND sg13cmos5l_tiehi
XFILLER_3_477 VPWR VGND sg13cmos5l_decap_8
XFILLER_47_621 VPWR VGND sg13cmos5l_decap_8
XFILLER_47_676 VPWR VGND sg13cmos5l_decap_8
XFILLER_15_540 VPWR VGND sg13cmos5l_decap_8
XFILLER_15_562 VPWR VGND sg13cmos5l_fill_1
X_3521_ _3521_/Q clkload6/A _3521_/D _3521_/RESET_B VPWR VGND sg13cmos5l_dfrbpq_1
Xhold706 _3462_/A _3699_/Q VPWR VGND sg13cmos5l_dlygate4sd3_1
Xhold717 hold717/X _3559_/Q VPWR VGND sg13cmos5l_dlygate4sd3_1
Xhold728 _3006_/A _3622_/Q VPWR VGND sg13cmos5l_dlygate4sd3_1
Xhold739 _2925_/A _3607_/Q VPWR VGND sg13cmos5l_dlygate4sd3_1
X_3452_ _3719_/D _3452_/A _3452_/B VPWR VGND sg13cmos5l_and2_1
X_2403_ _2403_/X _2399_/S _2401_/Y _2402_/Y VPWR VGND sg13cmos5l_a21o_1
X_3383_ _3385_/C _3391_/B _3391_/C _3264_/B VPWR VGND sg13cmos5l_a21o_1
X_2334_ _2335_/B _2341_/A _2334_/B VPWR VGND sg13cmos5l_xnor2_1
XFILLER_27_0 VPWR VGND sg13cmos5l_decap_4
XFILLER_38_621 VPWR VGND sg13cmos5l_decap_8
X_2265_ _2269_/S _2271_/A _2265_/B _2265_/C VPWR VGND sg13cmos5l_or3_1
XFILLER_38_654 VPWR VGND sg13cmos5l_decap_4
X_2196_ _2311_/A _2178_/X _2195_/Y _2198_/C VPWR VGND sg13cmos5l_mux2_1
XFILLER_38_676 VPWR VGND sg13cmos5l_decap_8
XFILLER_21_510 VPWR VGND sg13cmos5l_decap_8
XFILLER_21_521 VPWR VGND sg13cmos5l_decap_8
X_3719_ _3719_/Q _3806_/CLK _3719_/D _3719_/RESET_B VPWR VGND sg13cmos5l_dfrbpq_1
XFILLER_0_403 VPWR VGND sg13cmos5l_decap_8
XFILLER_49_908 VPWR VGND sg13cmos5l_decap_8
XFILLER_1_948 VPWR VGND sg13cmos5l_decap_8
XFILLER_29_11 VPWR VGND sg13cmos5l_fill_2
XFILLER_29_621 VPWR VGND sg13cmos5l_decap_8
XFILLER_17_838 VPWR VGND sg13cmos5l_fill_1
XFILLER_28_164 VPWR VGND sg13cmos5l_fill_2
XFILLER_45_32 VPWR VGND sg13cmos5l_fill_2
XFILLER_44_635 VPWR VGND sg13cmos5l_fill_1
XFILLER_44_668 VPWR VGND sg13cmos5l_decap_4
XFILLER_43_167 VPWR VGND sg13cmos5l_decap_8
XFILLER_24_381 VPWR VGND sg13cmos5l_decap_4
X_3497__386 _3497_/RESET_B VPWR VGND sg13cmos5l_tiehi
X_3718__273 _3718_/RESET_B VPWR VGND sg13cmos5l_tiehi
XFILLER_6_37 VPWR VGND sg13cmos5l_decap_8
XFILLER_3_285 VPWR VGND sg13cmos5l_fill_1
X_2050_ _2053_/B _3701_/Q _3463_/A VPWR VGND sg13cmos5l_nor2_1
XFILLER_48_985 VPWR VGND sg13cmos5l_decap_8
XFILLER_35_624 VPWR VGND sg13cmos5l_decap_8
XFILLER_34_112 VPWR VGND sg13cmos5l_decap_8
XFILLER_37_1010 VPWR VGND sg13cmos5l_decap_8
XFILLER_34_167 VPWR VGND sg13cmos5l_decap_4
XFILLER_35_668 VPWR VGND sg13cmos5l_fill_2
X_2952_ _2956_/C _3614_/Q _3615_/Q hold816/X VPWR VGND sg13cmos5l_o21ai_1
XFILLER_22_329 VPWR VGND sg13cmos5l_decap_8
XFILLER_31_852 VPWR VGND sg13cmos5l_fill_1
X_2883_ _2888_/B _2863_/Y _2881_/Y _2882_/Y _3613_/Q VPWR VGND sg13cmos5l_a22oi_1
X_3732__248 _3732_/RESET_B VPWR VGND sg13cmos5l_tiehi
XFILLER_31_896 VPWR VGND sg13cmos5l_fill_1
X_3504_ _3504_/Q clkload7/A _3504_/D _3504_/RESET_B VPWR VGND sg13cmos5l_dfrbpq_1
Xhold525 _1950_/A _3562_/Q VPWR VGND sg13cmos5l_dlygate4sd3_1
Xhold503 _2711_/B _3554_/Q VPWR VGND sg13cmos5l_dlygate4sd3_1
Xhold536 hold536/X _2835_/A VPWR VGND sg13cmos5l_dlygate4sd3_1
Xhold514 _3602_/D _2905_/Y VPWR VGND sg13cmos5l_dlygate4sd3_1
Xhold569 _3544_/D _2680_/X VPWR VGND sg13cmos5l_dlygate4sd3_1
Xhold547 hold547/X _3542_/Q VPWR VGND sg13cmos5l_dlygate4sd3_1
X_3435_ _3435_/Y _3714_/Q _3430_/Y _3434_/Y _3715_/Q VPWR VGND sg13cmos5l_a22oi_1
Xhold558 hold558/X _3488_/Q VPWR VGND sg13cmos5l_dlygate4sd3_1
X_3704__306 _3704_/RESET_B VPWR VGND sg13cmos5l_tiehi
X_3366_ _3366_/Y _3689_/Q _3661_/Q VPWR VGND sg13cmos5l_xnor2_1
X_2317_ _2317_/X _2230_/B _2194_/B _2343_/S VPWR VGND sg13cmos5l_mux2_1
X_3297_ _3678_/D _3355_/C _3355_/D _3410_/A VPWR VGND sg13cmos5l_a21oi_1
XFILLER_39_952 VPWR VGND sg13cmos5l_decap_8
X_2248_ _2256_/C _2257_/B _2261_/A _2247_/B VPWR VGND sg13cmos5l_o21ai_1
X_2179_ _2179_/Y _3737_/Q _3736_/Q VPWR VGND sg13cmos5l_xnor2_1
XFILLER_25_112 VPWR VGND sg13cmos5l_fill_2
XFILLER_26_624 VPWR VGND sg13cmos5l_decap_4
XFILLER_15_46 VPWR VGND sg13cmos5l_decap_8
XFILLER_25_189 VPWR VGND sg13cmos5l_fill_1
XFILLER_22_863 VPWR VGND sg13cmos5l_decap_8
XFILLER_21_351 VPWR VGND sg13cmos5l_decap_8
XFILLER_5_528 VPWR VGND sg13cmos5l_fill_2
XFILLER_5_506 VPWR VGND sg13cmos5l_fill_1
XFILLER_1_723 VPWR VGND sg13cmos5l_fill_2
XFILLER_0_255 VPWR VGND sg13cmos5l_fill_1
XFILLER_29_451 VPWR VGND sg13cmos5l_fill_1
XFILLER_44_410 VPWR VGND sg13cmos5l_fill_2
XFILLER_45_966 VPWR VGND sg13cmos5l_decap_8
XFILLER_44_454 VPWR VGND sg13cmos5l_fill_1
XFILLER_44_498 VPWR VGND sg13cmos5l_fill_1
XFILLER_31_115 VPWR VGND sg13cmos5l_decap_8
XFILLER_32_616 VPWR VGND sg13cmos5l_decap_8
XFILLER_12_362 VPWR VGND sg13cmos5l_decap_8
XFILLER_8_344 VPWR VGND sg13cmos5l_fill_1
XFILLER_8_333 VPWR VGND sg13cmos5l_decap_8
XFILLER_9_878 VPWR VGND sg13cmos5l_decap_8
X_3649__186 _3649_/RESET_B VPWR VGND sg13cmos5l_tiehi
X_3220_ _3220_/Y _3220_/A VPWR VGND sg13cmos5l_inv_1
X_3151_ _3160_/B _3671_/Q _3150_/Y _3149_/Y VPWR VGND sg13cmos5l_o21ai_1
X_2102_ _2102_/Y _3463_/A _3678_/Q VPWR VGND sg13cmos5l_nand2b_1
XFILLER_48_782 VPWR VGND sg13cmos5l_decap_8
X_3082_ _3087_/A _3092_/B _3081_/B _3109_/A VPWR VGND sg13cmos5l_a21o_1
XFILLER_36_911 VPWR VGND sg13cmos5l_fill_1
XFILLER_36_900 VPWR VGND sg13cmos5l_decap_8
X_2033_ _3806_/D _2033_/A VPWR VGND sg13cmos5l_inv_1
XFILLER_36_966 VPWR VGND sg13cmos5l_decap_8
XFILLER_35_443 VPWR VGND sg13cmos5l_decap_8
XFILLER_35_487 VPWR VGND sg13cmos5l_decap_8
XFILLER_35_498 VPWR VGND sg13cmos5l_fill_1
X_3656__179 _3656_/RESET_B VPWR VGND sg13cmos5l_tiehi
X_2935_ _2936_/B _2913_/Y _2938_/A _2911_/B VPWR VGND sg13cmos5l_o21ai_1
X_2866_ _2871_/A _2862_/Y _2865_/Y _2852_/Y VPWR VGND sg13cmos5l_o21ai_1
X_2797_ _2797_/Y _3480_/Q _2826_/A1 VPWR VGND sg13cmos5l_nor2b_1
X_3418_ _3710_/D _3463_/B _3418_/B VPWR VGND sg13cmos5l_and2_1
X_3680__442 _3680_/RESET_B VPWR VGND sg13cmos5l_tiehi
X_3349_ _3695_/D _3349_/A _3410_/A VPWR VGND sg13cmos5l_nor2_1
X_3487__396 _3487_/RESET_B VPWR VGND sg13cmos5l_tiehi
XFILLER_39_760 VPWR VGND sg13cmos5l_decap_8
XFILLER_27_922 VPWR VGND sg13cmos5l_decap_8
XFILLER_13_104 VPWR VGND sg13cmos5l_fill_2
XFILLER_27_999 VPWR VGND sg13cmos5l_decap_8
XFILLER_42_958 VPWR VGND sg13cmos5l_decap_8
XFILLER_9_119 VPWR VGND sg13cmos5l_decap_8
XFILLER_42_55 VPWR VGND sg13cmos5l_decap_8
XFILLER_21_170 VPWR VGND sg13cmos5l_decap_8
X_3494__389 _3494_/RESET_B VPWR VGND sg13cmos5l_tiehi
XFILLER_6_848 VPWR VGND sg13cmos5l_decap_8
XFILLER_27_1020 VPWR VGND sg13cmos5l_decap_8
XFILLER_1_597 VPWR VGND sg13cmos5l_fill_2
XFILLER_18_911 VPWR VGND sg13cmos5l_decap_4
XFILLER_45_763 VPWR VGND sg13cmos5l_decap_8
XFILLER_44_240 VPWR VGND sg13cmos5l_decap_4
XFILLER_18_988 VPWR VGND sg13cmos5l_decap_8
XFILLER_44_273 VPWR VGND sg13cmos5l_fill_2
XFILLER_17_487 VPWR VGND sg13cmos5l_decap_8
XFILLER_33_936 VPWR VGND sg13cmos5l_decap_8
XFILLER_9_620 VPWR VGND sg13cmos5l_decap_8
XFILLER_20_619 VPWR VGND sg13cmos5l_fill_2
XFILLER_34_1024 VPWR VGND sg13cmos5l_decap_4
XFILLER_41_991 VPWR VGND sg13cmos5l_decap_8
X_2720_ _2720_/Y _2596_/A _2718_/Y _2719_/Y VPWR VGND sg13cmos5l_a21oi_1
X_2651_ _3520_/D input6/X hold598/X _2725_/A VPWR VGND sg13cmos5l_mux2_1
X_3686__106 _3686_/D VPWR VGND sg13cmos5l_tielo
X_2582_ _2592_/B _2582_/A _2582_/B VPWR VGND sg13cmos5l_nand2_1
X_3203_ _3221_/C _3203_/A _3203_/B _3203_/C VPWR VGND sg13cmos5l_nand3_1
XFILLER_41_1028 VPWR VGND sg13cmos5l_fill_1
X_3134_ _3135_/B _1981_/Y _3132_/Y _3133_/Y _3131_/Y VPWR VGND sg13cmos5l_a22oi_1
X_3065_ _3065_/Y _3065_/A _3070_/A VPWR VGND sg13cmos5l_nor2_1
X_2016_ _3802_/D _2755_/A _2579_/A VPWR VGND sg13cmos5l_and2_1
XFILLER_24_947 VPWR VGND sg13cmos5l_decap_8
X_2918_ _2923_/A _2918_/A _2925_/B VPWR VGND sg13cmos5l_nor2_1
XFILLER_31_490 VPWR VGND sg13cmos5l_fill_2
X_2849_ _2911_/B _3075_/A _3018_/B VPWR VGND sg13cmos5l_nor2_1
XFILLER_3_829 VPWR VGND sg13cmos5l_decap_8
XFILLER_2_328 VPWR VGND sg13cmos5l_decap_8
XFILLER_46_549 VPWR VGND sg13cmos5l_fill_2
XFILLER_46_538 VPWR VGND sg13cmos5l_decap_8
XFILLER_37_66 VPWR VGND sg13cmos5l_decap_8
XFILLER_42_711 VPWR VGND sg13cmos5l_fill_2
XFILLER_15_925 VPWR VGND sg13cmos5l_decap_4
XFILLER_26_251 VPWR VGND sg13cmos5l_fill_2
XFILLER_27_785 VPWR VGND sg13cmos5l_fill_2
XFILLER_41_221 VPWR VGND sg13cmos5l_fill_1
XFILLER_14_435 VPWR VGND sg13cmos5l_decap_8
XFILLER_15_969 VPWR VGND sg13cmos5l_decap_8
X_3639__196 _3639_/RESET_B VPWR VGND sg13cmos5l_tiehi
XFILLER_23_991 VPWR VGND sg13cmos5l_decap_8
Xclkbuf_leaf_21_clk clkload4/A clkbuf_leaf_3_clk/A VPWR VGND sg13cmos5l_buf_8
XFILLER_10_630 VPWR VGND sg13cmos5l_decap_8
XFILLER_10_685 VPWR VGND sg13cmos5l_decap_4
XFILLER_10_696 VPWR VGND sg13cmos5l_decap_8
XFILLER_2_884 VPWR VGND sg13cmos5l_decap_8
X_3646__189 _3646_/RESET_B VPWR VGND sg13cmos5l_tiehi
XFILLER_49_365 VPWR VGND sg13cmos5l_decap_8
XFILLER_49_398 VPWR VGND sg13cmos5l_decap_8
XFILLER_33_733 VPWR VGND sg13cmos5l_decap_8
XFILLER_20_405 VPWR VGND sg13cmos5l_decap_8
XFILLER_14_980 VPWR VGND sg13cmos5l_decap_8
XFILLER_20_427 VPWR VGND sg13cmos5l_fill_1
Xclkbuf_leaf_12_clk _3666_/CLK clkload0/A VPWR VGND sg13cmos5l_buf_8
X_3752_ _3752_/Q _3783_/CLK _3752_/D _3752_/RESET_B VPWR VGND sg13cmos5l_dfrbpq_1
X_2703_ _2703_/Y _2692_/A _3552_/Q _2693_/B hold501/X VPWR VGND sg13cmos5l_a22oi_1
X_3683_ _3683_/Q _3728_/CLK _3683_/D _3683_/RESET_B VPWR VGND sg13cmos5l_dfrbpq_1
X_2634_ _3508_/D input11/X hold604/X _2637_/S VPWR VGND sg13cmos5l_mux2_1
X_2565_ _2567_/B _2035_/X _2564_/Y _2030_/Y VPWR VGND sg13cmos5l_o21ai_1
X_2496_ _2496_/Y _3741_/Q _2507_/A _2507_/B VPWR VGND sg13cmos5l_nor3_1
X_3484__399 _3484_/RESET_B VPWR VGND sg13cmos5l_tiehi
X_3740__133 _3740_/D VPWR VGND sg13cmos5l_tielo
X_3117_ _3644_/D _3143_/A _3117_/B VPWR VGND sg13cmos5l_nor2_1
X_3048_ _3073_/A _3042_/Y _3048_/B VPWR VGND sg13cmos5l_nand2b_1
XFILLER_36_593 VPWR VGND sg13cmos5l_fill_1
XFILLER_12_939 VPWR VGND sg13cmos5l_fill_1
XFILLER_23_276 VPWR VGND sg13cmos5l_decap_4
XFILLER_20_994 VPWR VGND sg13cmos5l_decap_8
XFILLER_3_604 VPWR VGND sg13cmos5l_decap_8
XFILLER_3_648 VPWR VGND sg13cmos5l_decap_8
XFILLER_47_814 VPWR VGND sg13cmos5l_decap_8
XFILLER_19_527 VPWR VGND sg13cmos5l_decap_4
XFILLER_0_28 VPWR VGND sg13cmos5l_decap_8
XFILLER_15_700 VPWR VGND sg13cmos5l_fill_2
XFILLER_42_530 VPWR VGND sg13cmos5l_decap_8
XFILLER_14_210 VPWR VGND sg13cmos5l_decap_8
X_3576__283 _3576_/RESET_B VPWR VGND sg13cmos5l_tiehi
Xfanout80 _3460_/A _3186_/A VPWR VGND sg13cmos5l_buf_1
XFILLER_30_758 VPWR VGND sg13cmos5l_decap_8
XFILLER_31_1005 VPWR VGND sg13cmos5l_decap_8
XFILLER_7_932 VPWR VGND sg13cmos5l_decap_8
XFILLER_6_420 VPWR VGND sg13cmos5l_decap_8
X_2350_ _2350_/Y _2350_/A _2350_/B VPWR VGND sg13cmos5l_xnor2_1
XFILLER_2_670 VPWR VGND sg13cmos5l_decap_8
X_2281_ _2282_/B _3802_/Q _3801_/Q _2286_/B VPWR VGND sg13cmos5l_nor3_1
XFILLER_49_140 VPWR VGND sg13cmos5l_decap_8
XFILLER_38_803 VPWR VGND sg13cmos5l_decap_8
Xclkbuf_leaf_1_clk clkload2/A clkbuf_leaf_3_clk/A VPWR VGND sg13cmos5l_buf_8
XFILLER_29_4 VPWR VGND sg13cmos5l_decap_8
XFILLER_49_184 VPWR VGND sg13cmos5l_decap_8
XFILLER_38_836 VPWR VGND sg13cmos5l_decap_8
XFILLER_38_869 VPWR VGND sg13cmos5l_decap_8
XFILLER_21_725 VPWR VGND sg13cmos5l_fill_2
X_1996_ _3004_/B _1996_/A VPWR VGND sg13cmos5l_inv_1
X_3804_ _3804_/Q _3809_/CLK _3804_/D _3804_/RESET_B VPWR VGND sg13cmos5l_dfrbpq_1
X_3735_ _3735_/Q _3766_/CLK _3735_/D _3735_/RESET_B VPWR VGND sg13cmos5l_dfrbpq_1
XFILLER_9_280 VPWR VGND sg13cmos5l_fill_1
XFILLER_9_291 VPWR VGND sg13cmos5l_decap_8
X_3666_ _3666_/Q _3666_/CLK _3666_/D _3666_/RESET_B VPWR VGND sg13cmos5l_dfrbpq_1
X_3597_ _3597_/Q _3665_/CLK _3597_/D _3597_/RESET_B VPWR VGND sg13cmos5l_dfrbpq_1
X_2617_ _3494_/D input5/X hold573/X _2617_/S VPWR VGND sg13cmos5l_mux2_1
X_2548_ _2560_/B _2537_/Y _2543_/Y _2547_/Y VPWR VGND sg13cmos5l_o21ai_1
XFILLER_0_607 VPWR VGND sg13cmos5l_fill_1
X_2479_ _2545_/C _3787_/Q _2545_/B _2540_/A VPWR VGND sg13cmos5l_o21ai_1
XFILLER_28_324 VPWR VGND sg13cmos5l_fill_1
XFILLER_29_869 VPWR VGND sg13cmos5l_fill_2
XFILLER_24_541 VPWR VGND sg13cmos5l_fill_1
XFILLER_8_718 VPWR VGND sg13cmos5l_decap_8
XFILLER_12_758 VPWR VGND sg13cmos5l_decap_8
X_3636__199 _3636_/RESET_B VPWR VGND sg13cmos5l_tiehi
Xclkload0 clkload0/X clkload0/A VPWR VGND sg13cmos5l_buf_8
XFILLER_4_902 VPWR VGND sg13cmos5l_decap_8
XFILLER_3_401 VPWR VGND sg13cmos5l_decap_8
XFILLER_4_979 VPWR VGND sg13cmos5l_decap_8
XFILLER_47_600 VPWR VGND sg13cmos5l_fill_2
XFILLER_19_346 VPWR VGND sg13cmos5l_decap_8
XFILLER_19_357 VPWR VGND sg13cmos5l_fill_2
XFILLER_19_379 VPWR VGND sg13cmos5l_decap_8
XFILLER_34_316 VPWR VGND sg13cmos5l_decap_8
XFILLER_46_187 VPWR VGND sg13cmos5l_decap_8
XFILLER_30_599 VPWR VGND sg13cmos5l_decap_8
X_3520_ _3520_/Q clkload6/A _3520_/D _3520_/RESET_B VPWR VGND sg13cmos5l_dfrbpq_1
Xhold718 _1995_/A _3597_/Q VPWR VGND sg13cmos5l_dlygate4sd3_1
XFILLER_6_250 VPWR VGND sg13cmos5l_decap_8
Xhold707 _2286_/A _3808_/Q VPWR VGND sg13cmos5l_dlygate4sd3_1
X_3451_ _3451_/Y hold679/X _3441_/Y _3471_/A VPWR VGND sg13cmos5l_a21oi_1
Xhold729 _3013_/B _3012_/X VPWR VGND sg13cmos5l_dlygate4sd3_1
X_2402_ _2402_/Y _2379_/A _2379_/B _2390_/Y _2394_/Y _2396_/A VPWR VGND sg13cmos5l_a221oi_1
X_3382_ _3385_/B _3382_/A _3391_/B _3391_/C VPWR VGND sg13cmos5l_nand3_1
XFILLER_3_990 VPWR VGND sg13cmos5l_decap_8
X_2333_ _2334_/B _2333_/A _2333_/B VPWR VGND sg13cmos5l_xor2_1
X_2264_ _2265_/C _2274_/B _2264_/B VPWR VGND sg13cmos5l_nor2_1
X_2195_ _2195_/Y _2195_/A _2198_/B VPWR VGND sg13cmos5l_nand2_1
XFILLER_37_143 VPWR VGND sg13cmos5l_fill_2
XFILLER_26_817 VPWR VGND sg13cmos5l_fill_2
XFILLER_26_828 VPWR VGND sg13cmos5l_fill_1
XFILLER_25_327 VPWR VGND sg13cmos5l_decap_4
XFILLER_40_308 VPWR VGND sg13cmos5l_decap_8
XFILLER_33_382 VPWR VGND sg13cmos5l_decap_8
XFILLER_34_883 VPWR VGND sg13cmos5l_decap_4
XFILLER_14_1022 VPWR VGND sg13cmos5l_decap_8
XFILLER_21_566 VPWR VGND sg13cmos5l_decap_8
X_1979_ _3349_/A _3088_/A VPWR VGND sg13cmos5l_inv_1
X_3718_ _3718_/Q clkload3/A _3718_/D _3718_/RESET_B VPWR VGND sg13cmos5l_dfrbpq_1
X_3649_ _3649_/Q _3698_/CLK _3649_/D _3649_/RESET_B VPWR VGND sg13cmos5l_dfrbpq_1
XFILLER_1_927 VPWR VGND sg13cmos5l_decap_8
XFILLER_48_408 VPWR VGND sg13cmos5l_decap_4
XFILLER_0_459 VPWR VGND sg13cmos5l_fill_2
XFILLER_29_67 VPWR VGND sg13cmos5l_decap_4
XFILLER_21_1015 VPWR VGND sg13cmos5l_decap_8
XFILLER_28_143 VPWR VGND sg13cmos5l_fill_2
XFILLER_29_688 VPWR VGND sg13cmos5l_fill_2
XFILLER_45_55 VPWR VGND sg13cmos5l_decap_4
XFILLER_44_647 VPWR VGND sg13cmos5l_decap_8
XFILLER_43_113 VPWR VGND sg13cmos5l_decap_8
XFILLER_16_349 VPWR VGND sg13cmos5l_decap_8
XFILLER_43_146 VPWR VGND sg13cmos5l_decap_8
XFILLER_12_511 VPWR VGND sg13cmos5l_fill_2
XFILLER_40_864 VPWR VGND sg13cmos5l_decap_8
XFILLER_12_533 VPWR VGND sg13cmos5l_decap_8
XFILLER_8_526 VPWR VGND sg13cmos5l_fill_2
XFILLER_6_16 VPWR VGND sg13cmos5l_decap_8
XFILLER_6_27 VPWR VGND sg13cmos5l_fill_1
XFILLER_6_1009 VPWR VGND sg13cmos5l_decap_8
XFILLER_3_297 VPWR VGND sg13cmos5l_fill_1
XFILLER_0_993 VPWR VGND sg13cmos5l_decap_8
XFILLER_48_964 VPWR VGND sg13cmos5l_decap_8
XFILLER_35_603 VPWR VGND sg13cmos5l_decap_8
XFILLER_19_187 VPWR VGND sg13cmos5l_decap_8
XFILLER_23_809 VPWR VGND sg13cmos5l_fill_2
X_2951_ _2956_/B _3638_/Q _3639_/Q VPWR VGND sg13cmos5l_xnor2_1
XFILLER_16_883 VPWR VGND sg13cmos5l_fill_2
X_2882_ _2882_/Y _3577_/Q _3612_/Q VPWR VGND sg13cmos5l_nand2_1
Xhold515 _2846_/A _3581_/Q VPWR VGND sg13cmos5l_dlygate4sd3_1
Xhold526 _3549_/D _2697_/Y VPWR VGND sg13cmos5l_dlygate4sd3_1
Xhold504 _1935_/A _3627_/Q VPWR VGND sg13cmos5l_dlygate4sd3_1
X_3503_ _3503_/Q clkload6/A _3503_/D _3503_/RESET_B VPWR VGND sg13cmos5l_dfrbpq_1
Xhold559 hold559/X _3519_/Q VPWR VGND sg13cmos5l_dlygate4sd3_1
Xhold548 hold548/X _3507_/Q VPWR VGND sg13cmos5l_dlygate4sd3_1
X_3434_ _3434_/Y _3434_/A VPWR VGND sg13cmos5l_inv_1
Xhold537 _1928_/A _3720_/Q VPWR VGND sg13cmos5l_dlygate4sd3_1
XFILLER_44_1015 VPWR VGND sg13cmos5l_decap_8
X_3365_ _3365_/Y _3688_/Q _3660_/Q VPWR VGND sg13cmos5l_xnor2_1
X_2316_ _2343_/S _2313_/Y _2315_/Y _2309_/Y VPWR VGND sg13cmos5l_o21ai_1
X_3296_ _3382_/A _3355_/C _3355_/D VPWR VGND sg13cmos5l_nand2_1
XFILLER_39_931 VPWR VGND sg13cmos5l_decap_8
XFILLER_38_430 VPWR VGND sg13cmos5l_decap_4
X_2247_ _2247_/X _3714_/Q _2247_/B VPWR VGND sg13cmos5l_and2_1
X_2178_ _2178_/X _2178_/A _2178_/B VPWR VGND sg13cmos5l_xor2_1
XFILLER_25_102 VPWR VGND sg13cmos5l_fill_2
XFILLER_26_658 VPWR VGND sg13cmos5l_decap_8
XFILLER_40_116 VPWR VGND sg13cmos5l_decap_4
XFILLER_15_25 VPWR VGND sg13cmos5l_decap_8
XFILLER_31_35 VPWR VGND sg13cmos5l_decap_4
XFILLER_0_234 VPWR VGND sg13cmos5l_decap_8
XFILLER_0_267 VPWR VGND sg13cmos5l_decap_8
XFILLER_5_1020 VPWR VGND sg13cmos5l_decap_8
XFILLER_45_945 VPWR VGND sg13cmos5l_decap_8
XFILLER_29_485 VPWR VGND sg13cmos5l_decap_8
XFILLER_44_488 VPWR VGND sg13cmos5l_decap_4
XFILLER_40_672 VPWR VGND sg13cmos5l_decap_8
XFILLER_9_813 VPWR VGND sg13cmos5l_fill_2
XFILLER_40_694 VPWR VGND sg13cmos5l_decap_8
XFILLER_9_857 VPWR VGND sg13cmos5l_decap_8
XFILLER_4_584 VPWR VGND sg13cmos5l_decap_8
X_3803__206 _3803_/RESET_B VPWR VGND sg13cmos5l_tiehi
X_3150_ _3150_/Y _3625_/Q _3670_/Q VPWR VGND sg13cmos5l_nor2_1
X_3081_ _3111_/A _3092_/B _3081_/B VPWR VGND sg13cmos5l_and2_1
XFILLER_0_790 VPWR VGND sg13cmos5l_decap_8
X_2101_ _2101_/Y _3699_/Q _3677_/Q VPWR VGND sg13cmos5l_nor2_1
XFILLER_48_761 VPWR VGND sg13cmos5l_decap_8
XFILLER_11_4 VPWR VGND sg13cmos5l_fill_1
X_2032_ _2033_/A _2284_/A _2031_/Y _2586_/A VPWR VGND sg13cmos5l_a21o_1
XFILLER_47_271 VPWR VGND sg13cmos5l_decap_8
XFILLER_36_945 VPWR VGND sg13cmos5l_decap_8
X_3777__441 _3777_/RESET_B VPWR VGND sg13cmos5l_tiehi
XFILLER_35_400 VPWR VGND sg13cmos5l_decap_4
XFILLER_35_422 VPWR VGND sg13cmos5l_decap_8
XFILLER_35_466 VPWR VGND sg13cmos5l_decap_8
XFILLER_16_680 VPWR VGND sg13cmos5l_decap_8
X_2934_ _2936_/A _2934_/A _2938_/A VPWR VGND sg13cmos5l_nor2b_1
X_2865_ _2865_/Y _2979_/A _2857_/A _2982_/A VPWR VGND sg13cmos5l_o21ai_1
X_2796_ _2796_/Y _2826_/A1 _3531_/Q _2795_/Y VPWR VGND sg13cmos5l_o21ai_1
X_3417_ _3709_/D _3471_/A _3417_/B VPWR VGND sg13cmos5l_nor2_1
X_3348_ _3694_/D _3348_/A _3352_/B VPWR VGND sg13cmos5l_and2_1
XFILLER_46_709 VPWR VGND sg13cmos5l_decap_8
X_3279_ _3284_/B _3648_/Q _3649_/Q _3646_/Q _3647_/Q VPWR VGND sg13cmos5l_nor4_1
XFILLER_27_978 VPWR VGND sg13cmos5l_decap_8
XFILLER_42_937 VPWR VGND sg13cmos5l_decap_8
XFILLER_26_488 VPWR VGND sg13cmos5l_decap_4
XFILLER_13_138 VPWR VGND sg13cmos5l_decap_8
XFILLER_42_89 VPWR VGND sg13cmos5l_decap_8
XFILLER_6_827 VPWR VGND sg13cmos5l_decap_8
XFILLER_5_304 VPWR VGND sg13cmos5l_fill_2
XFILLER_5_348 VPWR VGND sg13cmos5l_fill_1
XFILLER_3_39 VPWR VGND sg13cmos5l_decap_8
XFILLER_1_565 VPWR VGND sg13cmos5l_decap_4
XFILLER_49_569 VPWR VGND sg13cmos5l_decap_4
XFILLER_17_400 VPWR VGND sg13cmos5l_decap_8
XFILLER_18_934 VPWR VGND sg13cmos5l_fill_1
XFILLER_18_967 VPWR VGND sg13cmos5l_decap_8
XFILLER_17_466 VPWR VGND sg13cmos5l_decap_8
XFILLER_33_915 VPWR VGND sg13cmos5l_decap_8
XFILLER_41_970 VPWR VGND sg13cmos5l_decap_8
XFILLER_32_469 VPWR VGND sg13cmos5l_decap_8
XFILLER_34_1003 VPWR VGND sg13cmos5l_decap_8
XFILLER_13_694 VPWR VGND sg13cmos5l_fill_2
X_3655__180 _3655_/RESET_B VPWR VGND sg13cmos5l_tiehi
XFILLER_8_131 VPWR VGND sg13cmos5l_decap_8
XFILLER_9_687 VPWR VGND sg13cmos5l_decap_8
XFILLER_12_193 VPWR VGND sg13cmos5l_decap_4
X_2650_ _2650_/Y _2672_/A _2708_/A _2650_/C VPWR VGND sg13cmos5l_nand3_1
XFILLER_8_175 VPWR VGND sg13cmos5l_decap_8
X_2581_ _2581_/X _2592_/A _2582_/B VPWR VGND sg13cmos5l_or2_1
X_3202_ _3221_/B _3216_/A _3216_/B VPWR VGND sg13cmos5l_nand2_1
X_3133_ _3133_/Y _3187_/A _3136_/B _3133_/C VPWR VGND sg13cmos5l_nor3_1
X_3064_ _3064_/Y _3065_/A _3070_/A VPWR VGND sg13cmos5l_nand2_1
X_2015_ _2579_/A _2019_/B _2015_/B VPWR VGND sg13cmos5l_and2_1
XFILLER_24_926 VPWR VGND sg13cmos5l_decap_8
XFILLER_35_263 VPWR VGND sg13cmos5l_fill_1
XFILLER_11_609 VPWR VGND sg13cmos5l_decap_8
XFILLER_23_469 VPWR VGND sg13cmos5l_decap_8
XFILLER_32_981 VPWR VGND sg13cmos5l_decap_8
X_2917_ _2925_/B _2915_/Y _2916_/Y _2927_/A VPWR VGND sg13cmos5l_a21oi_1
X_3493__390 _3493_/RESET_B VPWR VGND sg13cmos5l_tiehi
X_2848_ _3586_/D _2772_/B _2846_/Y _2772_/A VPWR VGND sg13cmos5l_a21oi_1
XFILLER_12_48 VPWR VGND sg13cmos5l_decap_8
XFILLER_3_808 VPWR VGND sg13cmos5l_decap_8
X_2779_ _3578_/D _3075_/A _2779_/B VPWR VGND sg13cmos5l_nor2_1
XFILLER_46_506 VPWR VGND sg13cmos5l_fill_2
XFILLER_15_904 VPWR VGND sg13cmos5l_decap_4
XFILLER_27_764 VPWR VGND sg13cmos5l_fill_1
XFILLER_27_775 VPWR VGND sg13cmos5l_decap_4
XFILLER_42_745 VPWR VGND sg13cmos5l_fill_1
XFILLER_15_948 VPWR VGND sg13cmos5l_decap_8
XFILLER_18_1009 VPWR VGND sg13cmos5l_decap_8
XFILLER_42_767 VPWR VGND sg13cmos5l_fill_2
XFILLER_23_970 VPWR VGND sg13cmos5l_decap_8
XFILLER_22_480 VPWR VGND sg13cmos5l_fill_2
X_3687__416 _3687_/RESET_B VPWR VGND sg13cmos5l_tiehi
XFILLER_6_668 VPWR VGND sg13cmos5l_decap_8
XFILLER_5_145 VPWR VGND sg13cmos5l_decap_8
XFILLER_2_863 VPWR VGND sg13cmos5l_decap_8
XFILLER_49_344 VPWR VGND sg13cmos5l_decap_8
XFILLER_37_517 VPWR VGND sg13cmos5l_fill_1
XFILLER_18_731 VPWR VGND sg13cmos5l_decap_8
XFILLER_45_572 VPWR VGND sg13cmos5l_decap_8
XFILLER_17_263 VPWR VGND sg13cmos5l_fill_1
XFILLER_33_767 VPWR VGND sg13cmos5l_fill_2
XFILLER_33_789 VPWR VGND sg13cmos5l_decap_8
X_3751_ _3751_/Q _3806_/CLK _3751_/D _3751_/RESET_B VPWR VGND sg13cmos5l_dfrbpq_1
X_2702_ _3551_/D _3801_/D _2702_/B VPWR VGND sg13cmos5l_nor2_1
XFILLER_13_491 VPWR VGND sg13cmos5l_fill_1
X_3682_ _3682_/Q _3728_/CLK _3682_/D _3682_/RESET_B VPWR VGND sg13cmos5l_dfrbpq_1
X_2633_ _3507_/D input10/X hold548/X _2637_/S VPWR VGND sg13cmos5l_mux2_1
X_2564_ _2564_/Y _2564_/A _2567_/A VPWR VGND sg13cmos5l_nor2_1
X_2495_ _2507_/B _2511_/A _2511_/C VPWR VGND sg13cmos5l_and2_1
XFILLER_4_71 VPWR VGND sg13cmos5l_decap_4
X_3116_ _3116_/Y _3117_/B VPWR VGND sg13cmos5l_inv_1
X_3047_ _3048_/B _3042_/A _3042_/B _3046_/A VPWR VGND sg13cmos5l_a21oi_1
XFILLER_12_907 VPWR VGND sg13cmos5l_fill_1
XFILLER_23_244 VPWR VGND sg13cmos5l_fill_1
XFILLER_23_36 VPWR VGND sg13cmos5l_fill_2
XFILLER_20_973 VPWR VGND sg13cmos5l_decap_8
XFILLER_24_1024 VPWR VGND sg13cmos5l_decap_4
XFILLER_46_314 VPWR VGND sg13cmos5l_decap_8
X_3645__190 _3645_/RESET_B VPWR VGND sg13cmos5l_tiehi
XFILLER_15_712 VPWR VGND sg13cmos5l_decap_8
XFILLER_27_550 VPWR VGND sg13cmos5l_decap_8
XFILLER_27_572 VPWR VGND sg13cmos5l_fill_1
XFILLER_14_288 VPWR VGND sg13cmos5l_decap_4
XFILLER_30_726 VPWR VGND sg13cmos5l_decap_4
Xfanout70 _2586_/A _3075_/A VPWR VGND sg13cmos5l_buf_1
Xfanout81 _3347_/A _3186_/A VPWR VGND sg13cmos5l_buf_1
XFILLER_7_911 VPWR VGND sg13cmos5l_decap_8
XFILLER_11_984 VPWR VGND sg13cmos5l_decap_8
X_3652__183 _3652_/RESET_B VPWR VGND sg13cmos5l_tiehi
XFILLER_31_1028 VPWR VGND sg13cmos5l_fill_1
XFILLER_7_988 VPWR VGND sg13cmos5l_decap_8
XFILLER_6_476 VPWR VGND sg13cmos5l_decap_8
XFILLER_9_1018 VPWR VGND sg13cmos5l_decap_8
X_2280_ _2282_/A _3805_/Q _2022_/Y _2278_/Y VPWR VGND sg13cmos5l_o21ai_1
XFILLER_49_130 VPWR VGND sg13cmos5l_fill_1
XFILLER_37_303 VPWR VGND sg13cmos5l_fill_2
XFILLER_46_881 VPWR VGND sg13cmos5l_decap_8
X_3803_ _3803_/Q clkload2/A _3803_/D _3803_/RESET_B VPWR VGND sg13cmos5l_dfrbpq_1
X_1995_ _3000_/B _1995_/A VPWR VGND sg13cmos5l_inv_1
X_3734_ _3734_/Q _3783_/CLK _3734_/D _3734_/RESET_B VPWR VGND sg13cmos5l_dfrbpq_1
X_3665_ _3665_/Q _3665_/CLK _3665_/D _3665_/RESET_B VPWR VGND sg13cmos5l_dfrbpq_1
X_2616_ _2616_/X input13/X hold570/X _2616_/S VPWR VGND sg13cmos5l_mux2_1
X_3490__393 _3490_/RESET_B VPWR VGND sg13cmos5l_tiehi
X_3596_ _3596_/Q _3665_/CLK _3596_/D _3596_/RESET_B VPWR VGND sg13cmos5l_dfrbpq_1
XFILLER_47_1024 VPWR VGND sg13cmos5l_decap_4
X_2547_ _2547_/Y _2418_/B _2546_/Y _2544_/Y VPWR VGND sg13cmos5l_a21oi_1
XFILLER_0_619 VPWR VGND sg13cmos5l_decap_8
X_2478_ _2540_/A _3786_/Q _2482_/B _2531_/A VPWR VGND sg13cmos5l_a21o_1
XFILLER_18_58 VPWR VGND sg13cmos5l_decap_8
XFILLER_37_870 VPWR VGND sg13cmos5l_decap_4
XFILLER_18_69 VPWR VGND sg13cmos5l_decap_8
XFILLER_43_339 VPWR VGND sg13cmos5l_decap_4
XFILLER_12_704 VPWR VGND sg13cmos5l_decap_8
XFILLER_24_553 VPWR VGND sg13cmos5l_decap_8
XFILLER_11_203 VPWR VGND sg13cmos5l_fill_1
XFILLER_12_737 VPWR VGND sg13cmos5l_decap_8
XFILLER_11_258 VPWR VGND sg13cmos5l_decap_4
Xclkload1 clkload1/Y clkload1/A VPWR VGND sg13cmos5l_inv_1
XFILLER_4_958 VPWR VGND sg13cmos5l_decap_8
XFILLER_19_303 VPWR VGND sg13cmos5l_fill_1
XFILLER_46_166 VPWR VGND sg13cmos5l_decap_8
XFILLER_28_892 VPWR VGND sg13cmos5l_decap_8
XFILLER_15_597 VPWR VGND sg13cmos5l_decap_8
XFILLER_30_501 VPWR VGND sg13cmos5l_decap_8
XFILLER_30_523 VPWR VGND sg13cmos5l_decap_4
Xhold719 _3597_/D _2898_/Y VPWR VGND sg13cmos5l_dlygate4sd3_1
Xhold708 _2742_/B _2292_/A VPWR VGND sg13cmos5l_dlygate4sd3_1
XFILLER_6_295 VPWR VGND sg13cmos5l_decap_4
X_3450_ _3716_/D _3471_/A _3450_/B VPWR VGND sg13cmos5l_nor2_1
X_2401_ _2401_/Y _2401_/A _2401_/B VPWR VGND sg13cmos5l_nor2_1
X_3381_ _3385_/A _3398_/A _3381_/B VPWR VGND sg13cmos5l_nor2_1
X_2332_ _2342_/B _2332_/A _2332_/B VPWR VGND sg13cmos5l_nor2_1
X_2263_ _2265_/B _3748_/Q _2259_/Y _2264_/B _3749_/Q _2260_/Y VPWR VGND sg13cmos5l_a221oi_1
X_2194_ _3736_/D _2307_/B _2194_/B VPWR VGND sg13cmos5l_nor2_1
XFILLER_1_72 VPWR VGND sg13cmos5l_decap_8
XFILLER_25_306 VPWR VGND sg13cmos5l_fill_2
XFILLER_34_851 VPWR VGND sg13cmos5l_decap_8
XFILLER_34_862 VPWR VGND sg13cmos5l_fill_2
XFILLER_33_372 VPWR VGND sg13cmos5l_decap_4
XFILLER_14_1001 VPWR VGND sg13cmos5l_decap_8
X_1978_ _2767_/C _3574_/Q VPWR VGND sg13cmos5l_inv_1
X_3717_ _3717_/Q clkload3/A _3717_/D _3717_/RESET_B VPWR VGND sg13cmos5l_dfrbpq_1
X_3648_ _3648_/Q _3666_/CLK _3648_/D _3648_/RESET_B VPWR VGND sg13cmos5l_dfrbpq_1
XFILLER_20_48 VPWR VGND sg13cmos5l_decap_8
XFILLER_1_906 VPWR VGND sg13cmos5l_decap_8
X_3579_ _3579_/Q _3809_/CLK _3579_/D _3579_/RESET_B VPWR VGND sg13cmos5l_dfrbpq_1
X_3746__151 _3746_/RESET_B VPWR VGND sg13cmos5l_tiehi
XFILLER_0_438 VPWR VGND sg13cmos5l_fill_2
XFILLER_29_24 VPWR VGND sg13cmos5l_decap_4
XFILLER_28_100 VPWR VGND sg13cmos5l_fill_1
XFILLER_28_122 VPWR VGND sg13cmos5l_decap_8
X_3642__193 _3642_/RESET_B VPWR VGND sg13cmos5l_tiehi
XFILLER_16_306 VPWR VGND sg13cmos5l_decap_8
XFILLER_17_829 VPWR VGND sg13cmos5l_decap_8
XFILLER_28_166 VPWR VGND sg13cmos5l_fill_1
XFILLER_29_667 VPWR VGND sg13cmos5l_decap_8
XFILLER_44_626 VPWR VGND sg13cmos5l_decap_8
XFILLER_25_862 VPWR VGND sg13cmos5l_decap_8
XFILLER_25_873 VPWR VGND sg13cmos5l_fill_1
XFILLER_8_505 VPWR VGND sg13cmos5l_decap_4
X_3573__287 _3573_/RESET_B VPWR VGND sg13cmos5l_tiehi
XFILLER_4_700 VPWR VGND sg13cmos5l_decap_8
XFILLER_4_733 VPWR VGND sg13cmos5l_decap_8
XFILLER_3_243 VPWR VGND sg13cmos5l_fill_2
XFILLER_10_81 VPWR VGND sg13cmos5l_fill_2
XFILLER_0_972 VPWR VGND sg13cmos5l_decap_8
XFILLER_48_943 VPWR VGND sg13cmos5l_decap_8
XFILLER_19_100 VPWR VGND sg13cmos5l_fill_2
XFILLER_47_486 VPWR VGND sg13cmos5l_decap_8
XFILLER_16_851 VPWR VGND sg13cmos5l_fill_2
XFILLER_34_147 VPWR VGND sg13cmos5l_decap_4
X_2950_ _2950_/Y _3614_/Q _3637_/Q VPWR VGND sg13cmos5l_nand2_1
XFILLER_16_873 VPWR VGND sg13cmos5l_fill_2
XFILLER_31_821 VPWR VGND sg13cmos5l_fill_2
X_2881_ _2881_/Y _3577_/Q _3031_/A _3029_/A _1944_/Y _2880_/Y VPWR VGND sg13cmos5l_a221oi_1
XFILLER_30_320 VPWR VGND sg13cmos5l_fill_2
XFILLER_31_843 VPWR VGND sg13cmos5l_fill_2
X_3552__327 _3552_/RESET_B VPWR VGND sg13cmos5l_tiehi
X_3502_ _3502_/Q _3574_/CLK _3502_/D _3502_/RESET_B VPWR VGND sg13cmos5l_dfrbpq_1
XFILLER_7_571 VPWR VGND sg13cmos5l_decap_8
Xhold505 _3657_/D _3179_/Y VPWR VGND sg13cmos5l_dlygate4sd3_1
Xhold527 _3027_/B _3606_/Q VPWR VGND sg13cmos5l_dlygate4sd3_1
Xhold516 _3603_/D _2907_/Y VPWR VGND sg13cmos5l_dlygate4sd3_1
X_3433_ _3434_/A _3686_/Q _3431_/Y _3432_/Y VPWR VGND sg13cmos5l_o21ai_1
Xhold538 _3752_/D _2296_/Y VPWR VGND sg13cmos5l_dlygate4sd3_1
Xhold549 hold549/X _3486_/Q VPWR VGND sg13cmos5l_dlygate4sd3_1
X_3364_ _3364_/Y _3690_/Q _3662_/Q VPWR VGND sg13cmos5l_nand2_1
XFILLER_39_910 VPWR VGND sg13cmos5l_decap_8
X_2315_ _2315_/Y _2200_/A _2238_/B _2314_/Y VPWR VGND sg13cmos5l_o21ai_1
X_3295_ _3355_/D _3288_/A _3288_/B _3294_/X VPWR VGND sg13cmos5l_o21ai_1
X_2246_ _2247_/B _2242_/Y _2244_/Y _2245_/Y VPWR VGND sg13cmos5l_o21ai_1
XFILLER_39_987 VPWR VGND sg13cmos5l_decap_8
X_2177_ _2177_/Y _3737_/Q _3736_/Q _3763_/Q VPWR VGND sg13cmos5l_nand3b_1
XFILLER_26_637 VPWR VGND sg13cmos5l_decap_8
XFILLER_41_629 VPWR VGND sg13cmos5l_decap_8
XFILLER_13_309 VPWR VGND sg13cmos5l_decap_8
XFILLER_40_128 VPWR VGND sg13cmos5l_decap_8
XFILLER_34_692 VPWR VGND sg13cmos5l_fill_2
XFILLER_21_386 VPWR VGND sg13cmos5l_fill_2
XFILLER_22_898 VPWR VGND sg13cmos5l_decap_8
Xoutput14 uo_out[0] _3548_/Q VPWR VGND sg13cmos5l_buf_1
XFILLER_49_707 VPWR VGND sg13cmos5l_decap_8
XFILLER_0_213 VPWR VGND sg13cmos5l_decap_8
XFILLER_49_729 VPWR VGND sg13cmos5l_decap_8
XFILLER_45_924 VPWR VGND sg13cmos5l_decap_8
XFILLER_44_412 VPWR VGND sg13cmos5l_fill_1
XFILLER_44_401 VPWR VGND sg13cmos5l_fill_2
XFILLER_16_103 VPWR VGND sg13cmos5l_decap_8
XFILLER_17_615 VPWR VGND sg13cmos5l_decap_8
XFILLER_29_475 VPWR VGND sg13cmos5l_decap_4
XFILLER_44_445 VPWR VGND sg13cmos5l_decap_8
XFILLER_44_467 VPWR VGND sg13cmos5l_decap_8
XFILLER_8_324 VPWR VGND sg13cmos5l_fill_2
XFILLER_12_397 VPWR VGND sg13cmos5l_fill_2
XFILLER_4_563 VPWR VGND sg13cmos5l_decap_8
X_3080_ _3081_/B _3641_/Q _3642_/Q _3643_/Q VPWR VGND sg13cmos5l_o21ai_1
XFILLER_39_228 VPWR VGND sg13cmos5l_fill_2
XFILLER_39_217 VPWR VGND sg13cmos5l_decap_8
X_2100_ _2100_/X _2104_/A _2104_/B _3249_/A VPWR VGND sg13cmos5l_a21o_1
X_2031_ _2031_/Y _2564_/A _2286_/B _2582_/A VPWR VGND sg13cmos5l_o21ai_1
XFILLER_36_924 VPWR VGND sg13cmos5l_decap_8
X_2933_ _2938_/A _2921_/A _2921_/B _2932_/Y VPWR VGND sg13cmos5l_a21o_1
X_3736__161 _3736_/RESET_B VPWR VGND sg13cmos5l_tiehi
X_2864_ _2982_/A _3613_/Q _2864_/B VPWR VGND sg13cmos5l_xnor2_1
XFILLER_31_695 VPWR VGND sg13cmos5l_fill_2
XFILLER_30_183 VPWR VGND sg13cmos5l_decap_8
X_2795_ _2795_/Y _2826_/A1 _1989_/Y _2826_/B1 VPWR VGND sg13cmos5l_a21oi_1
XFILLER_8_891 VPWR VGND sg13cmos5l_decap_8
XFILLER_7_71 VPWR VGND sg13cmos5l_decap_8
XFILLER_11_1026 VPWR VGND sg13cmos5l_fill_2
X_3416_ _3707_/D _3463_/B _3416_/B VPWR VGND sg13cmos5l_and2_1
X_3743__154 _3743_/RESET_B VPWR VGND sg13cmos5l_tiehi
X_3347_ _3693_/D _3347_/A _3347_/B VPWR VGND sg13cmos5l_and2_1
X_3278_ _3278_/X _3109_/A _3298_/A _3277_/Y VPWR VGND sg13cmos5l_a21o_1
XFILLER_39_784 VPWR VGND sg13cmos5l_decap_8
X_2229_ _2230_/B _2229_/A _2229_/B VPWR VGND sg13cmos5l_nor2_1
XFILLER_26_445 VPWR VGND sg13cmos5l_decap_8
XFILLER_27_957 VPWR VGND sg13cmos5l_decap_8
XFILLER_42_916 VPWR VGND sg13cmos5l_decap_8
XFILLER_13_106 VPWR VGND sg13cmos5l_fill_1
XFILLER_14_629 VPWR VGND sg13cmos5l_decap_8
XFILLER_41_437 VPWR VGND sg13cmos5l_decap_8
XFILLER_22_651 VPWR VGND sg13cmos5l_decap_8
XFILLER_21_161 VPWR VGND sg13cmos5l_decap_4
XFILLER_6_806 VPWR VGND sg13cmos5l_decap_8
XFILLER_1_533 VPWR VGND sg13cmos5l_decap_4
XFILLER_49_548 VPWR VGND sg13cmos5l_decap_8
XFILLER_18_946 VPWR VGND sg13cmos5l_decap_8
XFILLER_29_272 VPWR VGND sg13cmos5l_decap_8
XFILLER_29_294 VPWR VGND sg13cmos5l_fill_1
XFILLER_45_798 VPWR VGND sg13cmos5l_decap_8
XFILLER_16_80 VPWR VGND sg13cmos5l_fill_1
XFILLER_8_154 VPWR VGND sg13cmos5l_decap_8
X_2580_ _2582_/B _3806_/Q _3801_/Q _2277_/A VPWR VGND sg13cmos5l_o21ai_1
XFILLER_5_894 VPWR VGND sg13cmos5l_decap_8
XFILLER_4_371 VPWR VGND sg13cmos5l_decap_8
X_3201_ _3221_/A _3665_/Q _3216_/B VPWR VGND sg13cmos5l_xnor2_1
X_3132_ _3132_/Y _3120_/A _3130_/Y _3120_/B VPWR VGND sg13cmos5l_a21oi_1
XFILLER_41_1019 VPWR VGND sg13cmos5l_decap_8
X_3063_ _3070_/A _3055_/A _2966_/B _3063_/S VPWR VGND sg13cmos5l_mux2_1
XFILLER_36_743 VPWR VGND sg13cmos5l_decap_4
X_2014_ _2015_/B _2014_/A _2587_/A _2014_/C VPWR VGND sg13cmos5l_nor3_1
XFILLER_36_798 VPWR VGND sg13cmos5l_decap_8
XFILLER_24_916 VPWR VGND sg13cmos5l_decap_4
XFILLER_17_990 VPWR VGND sg13cmos5l_decap_8
XFILLER_35_297 VPWR VGND sg13cmos5l_decap_8
XFILLER_32_960 VPWR VGND sg13cmos5l_decap_8
X_2916_ _2916_/Y _3602_/Q _3583_/Q VPWR VGND sg13cmos5l_xnor2_1
X_2847_ _3585_/D _2768_/Y _2769_/Y _2772_/B _2845_/X _2772_/A VPWR VGND sg13cmos5l_a221oi_1
X_2778_ _3576_/D _2761_/Y hold689/X _2772_/A VPWR VGND sg13cmos5l_a21oi_1
XFILLER_2_308 VPWR VGND sg13cmos5l_fill_2
XFILLER_2_1024 VPWR VGND sg13cmos5l_decap_4
XFILLER_26_253 VPWR VGND sg13cmos5l_fill_1
XFILLER_41_212 VPWR VGND sg13cmos5l_fill_1
XFILLER_30_919 VPWR VGND sg13cmos5l_decap_8
XFILLER_6_614 VPWR VGND sg13cmos5l_decap_8
XFILLER_6_647 VPWR VGND sg13cmos5l_fill_2
XFILLER_2_842 VPWR VGND sg13cmos5l_decap_8
XFILLER_18_710 VPWR VGND sg13cmos5l_decap_8
XFILLER_18_765 VPWR VGND sg13cmos5l_decap_8
XFILLER_33_713 VPWR VGND sg13cmos5l_decap_8
XFILLER_33_779 VPWR VGND sg13cmos5l_decap_4
X_3750_ _3750_/Q clkload1/A _3750_/D _3750_/RESET_B VPWR VGND sg13cmos5l_dfrbpq_1
XFILLER_32_267 VPWR VGND sg13cmos5l_fill_1
X_2701_ _2701_/Y _2692_/A _3551_/Q _2693_/B hold522/X VPWR VGND sg13cmos5l_a22oi_1
X_3681_ _3681_/Q _3712_/CLK _3681_/D _3681_/RESET_B VPWR VGND sg13cmos5l_dfrbpq_1
XFILLER_9_474 VPWR VGND sg13cmos5l_decap_8
XFILLER_9_485 VPWR VGND sg13cmos5l_fill_1
X_2632_ _3506_/D input9/X hold577/X _2637_/S VPWR VGND sg13cmos5l_mux2_1
XFILLER_9_496 VPWR VGND sg13cmos5l_decap_8
X_2563_ _2567_/A _3803_/Q _3801_/Q VPWR VGND sg13cmos5l_nor2_1
X_2494_ _2511_/C _3743_/Q _3741_/Q _3742_/Q VPWR VGND sg13cmos5l_nor3_1
X_3115_ _3117_/B _3093_/Y _3101_/B _3114_/X VPWR VGND sg13cmos5l_a21oi_1
X_3740__157 _3740_/RESET_B VPWR VGND sg13cmos5l_tiehi
X_3046_ _3059_/A _3046_/A _3046_/B VPWR VGND sg13cmos5l_nor2_1
X_3601__253 _3601_/RESET_B VPWR VGND sg13cmos5l_tiehi
XFILLER_36_584 VPWR VGND sg13cmos5l_decap_8
XFILLER_11_418 VPWR VGND sg13cmos5l_decap_4
XFILLER_23_15 VPWR VGND sg13cmos5l_decap_8
XFILLER_20_952 VPWR VGND sg13cmos5l_decap_8
XFILLER_2_138 VPWR VGND sg13cmos5l_fill_2
XFILLER_48_34 VPWR VGND sg13cmos5l_decap_8
XFILLER_24_1003 VPWR VGND sg13cmos5l_decap_8
XFILLER_46_304 VPWR VGND sg13cmos5l_fill_1
XFILLER_47_849 VPWR VGND sg13cmos5l_decap_8
XFILLER_15_702 VPWR VGND sg13cmos5l_fill_1
XFILLER_27_584 VPWR VGND sg13cmos5l_decap_8
XFILLER_15_757 VPWR VGND sg13cmos5l_fill_1
XFILLER_42_598 VPWR VGND sg13cmos5l_decap_8
XFILLER_9_39 VPWR VGND sg13cmos5l_fill_2
XFILLER_14_267 VPWR VGND sg13cmos5l_decap_8
XFILLER_11_930 VPWR VGND sg13cmos5l_fill_2
XFILLER_23_790 VPWR VGND sg13cmos5l_fill_1
Xfanout71 _3075_/A _3236_/A VPWR VGND sg13cmos5l_buf_1
Xfanout60 _2810_/B1 _2832_/S1 VPWR VGND sg13cmos5l_buf_1
Xfanout82 _3186_/A _3461_/A VPWR VGND sg13cmos5l_buf_1
XFILLER_11_963 VPWR VGND sg13cmos5l_decap_8
XFILLER_7_967 VPWR VGND sg13cmos5l_decap_8
XFILLER_13_70 VPWR VGND sg13cmos5l_decap_8
XFILLER_13_81 VPWR VGND sg13cmos5l_fill_1
XFILLER_13_92 VPWR VGND sg13cmos5l_decap_8
XFILLER_1_193 VPWR VGND sg13cmos5l_fill_2
XFILLER_1_182 VPWR VGND sg13cmos5l_decap_8
XFILLER_37_315 VPWR VGND sg13cmos5l_decap_8
XFILLER_46_860 VPWR VGND sg13cmos5l_decap_8
X_3479__404 _3479_/RESET_B VPWR VGND sg13cmos5l_tiehi
XFILLER_21_716 VPWR VGND sg13cmos5l_decap_4
XFILLER_21_727 VPWR VGND sg13cmos5l_fill_1
X_3802_ _3802_/Q _3806_/CLK _3802_/D _3802_/RESET_B VPWR VGND sg13cmos5l_dfrbpq_1
XFILLER_33_565 VPWR VGND sg13cmos5l_decap_4
X_1994_ _2899_/A _3599_/Q VPWR VGND sg13cmos5l_inv_1
XFILLER_20_248 VPWR VGND sg13cmos5l_decap_4
X_3733_ _3733_/Q _3766_/CLK _3733_/D _3733_/RESET_B VPWR VGND sg13cmos5l_dfrbpq_1
XFILLER_20_259 VPWR VGND sg13cmos5l_fill_2
X_3631__213 _3631_/RESET_B VPWR VGND sg13cmos5l_tiehi
X_3664_ _3664_/Q _3664_/CLK _3664_/D _3664_/RESET_B VPWR VGND sg13cmos5l_dfrbpq_1
X_2615_ _3492_/D input12/X hold595/X _2617_/S VPWR VGND sg13cmos5l_mux2_1
XFILLER_47_1003 VPWR VGND sg13cmos5l_decap_8
X_3595_ _3595_/Q _3665_/CLK _3595_/D _3595_/RESET_B VPWR VGND sg13cmos5l_dfrbpq_1
X_3711__292 _3711_/RESET_B VPWR VGND sg13cmos5l_tiehi
X_2546_ _2546_/Y _2549_/B VPWR VGND sg13cmos5l_inv_1
X_2477_ _2531_/A _2530_/A _2530_/B _2530_/C VPWR VGND sg13cmos5l_a21oi_1
X_3562__307 _3562_/RESET_B VPWR VGND sg13cmos5l_tiehi
XFILLER_28_304 VPWR VGND sg13cmos5l_decap_8
XFILLER_44_819 VPWR VGND sg13cmos5l_decap_8
X_3029_ _3634_/D _3029_/A _3030_/B VPWR VGND sg13cmos5l_and2_1
XFILLER_34_36 VPWR VGND sg13cmos5l_decap_8
XFILLER_11_237 VPWR VGND sg13cmos5l_fill_2
Xclkload2 clkload2/X clkload2/A VPWR VGND sg13cmos5l_buf_8
XFILLER_4_937 VPWR VGND sg13cmos5l_decap_8
XFILLER_3_458 VPWR VGND sg13cmos5l_fill_2
XFILLER_47_602 VPWR VGND sg13cmos5l_fill_1
XFILLER_47_635 VPWR VGND sg13cmos5l_decap_8
XFILLER_19_326 VPWR VGND sg13cmos5l_fill_2
XFILLER_19_337 VPWR VGND sg13cmos5l_decap_4
XFILLER_46_134 VPWR VGND sg13cmos5l_decap_8
XFILLER_35_819 VPWR VGND sg13cmos5l_decap_8
XFILLER_43_885 VPWR VGND sg13cmos5l_decap_8
XFILLER_42_395 VPWR VGND sg13cmos5l_fill_1
XFILLER_30_535 VPWR VGND sg13cmos5l_fill_1
XFILLER_11_782 VPWR VGND sg13cmos5l_decap_8
XFILLER_7_753 VPWR VGND sg13cmos5l_decap_8
XFILLER_10_281 VPWR VGND sg13cmos5l_fill_1
XFILLER_10_292 VPWR VGND sg13cmos5l_decap_4
Xhold709 _2779_/B _2745_/B VPWR VGND sg13cmos5l_dlygate4sd3_1
X_2400_ _3768_/D _2561_/A _2400_/B VPWR VGND sg13cmos5l_nor2_1
X_3380_ _3380_/Y _3380_/A _3380_/B VPWR VGND sg13cmos5l_xnor2_1
X_2331_ _2332_/B _2322_/A _2337_/B _2329_/A _2330_/Y VPWR VGND sg13cmos5l_a22oi_1
X_2262_ _2264_/B _3766_/Q _2468_/A _2261_/A _2261_/B VPWR VGND sg13cmos5l_a22oi_1
XFILLER_38_635 VPWR VGND sg13cmos5l_decap_8
X_2193_ _2194_/B _2178_/B _2192_/Y _2198_/C VPWR VGND sg13cmos5l_mux2_1
XFILLER_37_156 VPWR VGND sg13cmos5l_fill_2
XFILLER_37_145 VPWR VGND sg13cmos5l_fill_1
XFILLER_1_51 VPWR VGND sg13cmos5l_decap_8
XFILLER_19_882 VPWR VGND sg13cmos5l_fill_1
XFILLER_34_830 VPWR VGND sg13cmos5l_decap_8
XFILLER_33_340 VPWR VGND sg13cmos5l_fill_1
XFILLER_33_351 VPWR VGND sg13cmos5l_decap_8
XFILLER_21_535 VPWR VGND sg13cmos5l_fill_2
XFILLER_21_546 VPWR VGND sg13cmos5l_fill_2
X_3716_ _3716_/Q _3783_/CLK _3716_/D _3716_/RESET_B VPWR VGND sg13cmos5l_dfrbpq_1
X_1977_ _2691_/B input2/X VPWR VGND sg13cmos5l_inv_1
X_3647_ _3647_/Q _3698_/CLK _3647_/D _3647_/RESET_B VPWR VGND sg13cmos5l_dfrbpq_1
X_3578_ _3578_/Q _3806_/CLK _3578_/D _3578_/RESET_B VPWR VGND sg13cmos5l_dfrbpq_1
XFILLER_0_417 VPWR VGND sg13cmos5l_decap_8
X_2529_ _2529_/Y _2553_/A _2529_/B _2529_/C VPWR VGND sg13cmos5l_nor3_1
XFILLER_28_112 VPWR VGND sg13cmos5l_decap_4
XFILLER_29_635 VPWR VGND sg13cmos5l_decap_8
XFILLER_17_808 VPWR VGND sg13cmos5l_decap_8
XFILLER_37_690 VPWR VGND sg13cmos5l_decap_8
XFILLER_24_351 VPWR VGND sg13cmos5l_decap_8
XFILLER_25_885 VPWR VGND sg13cmos5l_decap_8
XFILLER_24_395 VPWR VGND sg13cmos5l_decap_8
XFILLER_8_528 VPWR VGND sg13cmos5l_fill_1
XFILLER_12_568 VPWR VGND sg13cmos5l_decap_4
XFILLER_8_539 VPWR VGND sg13cmos5l_decap_8
XFILLER_4_745 VPWR VGND sg13cmos5l_decap_8
XFILLER_3_222 VPWR VGND sg13cmos5l_decap_8
XFILLER_3_266 VPWR VGND sg13cmos5l_decap_8
XFILLER_48_922 VPWR VGND sg13cmos5l_decap_8
XFILLER_0_951 VPWR VGND sg13cmos5l_decap_8
XFILLER_19_112 VPWR VGND sg13cmos5l_decap_8
XFILLER_19_123 VPWR VGND sg13cmos5l_fill_1
XFILLER_48_999 VPWR VGND sg13cmos5l_decap_8
X_3695__324 _3695_/RESET_B VPWR VGND sg13cmos5l_tiehi
XFILLER_35_638 VPWR VGND sg13cmos5l_fill_2
XFILLER_16_830 VPWR VGND sg13cmos5l_decap_8
XFILLER_34_126 VPWR VGND sg13cmos5l_decap_8
XFILLER_37_1024 VPWR VGND sg13cmos5l_decap_4
XFILLER_42_181 VPWR VGND sg13cmos5l_decap_8
X_2880_ _2880_/Y _3575_/Q _2880_/B VPWR VGND sg13cmos5l_nor2_1
XFILLER_31_833 VPWR VGND sg13cmos5l_fill_1
XFILLER_30_332 VPWR VGND sg13cmos5l_decap_8
XFILLER_7_550 VPWR VGND sg13cmos5l_decap_8
X_3501_ _3501_/Q _3574_/CLK _3501_/D _3501_/RESET_B VPWR VGND sg13cmos5l_dfrbpq_1
Xhold506 _2689_/B _3557_/Q VPWR VGND sg13cmos5l_dlygate4sd3_1
Xhold517 _1938_/A _3601_/Q VPWR VGND sg13cmos5l_dlygate4sd3_1
X_3432_ _3432_/Y _3732_/Q _3437_/B _3437_/C VPWR VGND sg13cmos5l_nand3_1
Xhold528 _1956_/A _3753_/Q VPWR VGND sg13cmos5l_dlygate4sd3_1
Xhold539 _1926_/A _3721_/Q VPWR VGND sg13cmos5l_dlygate4sd3_1
X_3363_ _3363_/X _3388_/A _3388_/B VPWR VGND sg13cmos5l_or2_1
Xheichips26_dna_sequencer_100 uo_out[6] VPWR VGND sg13cmos5l_tielo
X_2314_ _2314_/Y _2347_/B _2347_/A VPWR VGND sg13cmos5l_nand2b_1
X_3294_ _3294_/X _3294_/A _3294_/B VPWR VGND sg13cmos5l_and2_1
X_2245_ _2245_/Y _2257_/B _2261_/A _3717_/Q _2467_/A VPWR VGND sg13cmos5l_a22oi_1
XFILLER_39_966 VPWR VGND sg13cmos5l_decap_8
X_2176_ _2176_/Y _3763_/Q _3736_/Q VPWR VGND sg13cmos5l_nand2_1
XFILLER_25_104 VPWR VGND sg13cmos5l_fill_1
XFILLER_19_690 VPWR VGND sg13cmos5l_decap_4
XFILLER_41_608 VPWR VGND sg13cmos5l_decap_8
XFILLER_21_321 VPWR VGND sg13cmos5l_decap_8
XFILLER_22_833 VPWR VGND sg13cmos5l_decap_8
XFILLER_22_877 VPWR VGND sg13cmos5l_decap_8
XFILLER_33_192 VPWR VGND sg13cmos5l_fill_1
XFILLER_21_365 VPWR VGND sg13cmos5l_decap_8
Xoutput15 uo_out[1] _3549_/Q VPWR VGND sg13cmos5l_buf_1
XFILLER_1_759 VPWR VGND sg13cmos5l_decap_8
XFILLER_45_903 VPWR VGND sg13cmos5l_decap_8
XFILLER_44_424 VPWR VGND sg13cmos5l_decap_8
XFILLER_16_126 VPWR VGND sg13cmos5l_fill_2
XFILLER_13_833 VPWR VGND sg13cmos5l_decap_8
XFILLER_24_181 VPWR VGND sg13cmos5l_decap_8
XFILLER_31_129 VPWR VGND sg13cmos5l_decap_8
XFILLER_40_652 VPWR VGND sg13cmos5l_fill_2
XFILLER_8_303 VPWR VGND sg13cmos5l_decap_8
XFILLER_9_815 VPWR VGND sg13cmos5l_fill_1
XFILLER_12_332 VPWR VGND sg13cmos5l_decap_8
XFILLER_13_855 VPWR VGND sg13cmos5l_decap_8
XFILLER_9_837 VPWR VGND sg13cmos5l_fill_2
XFILLER_12_376 VPWR VGND sg13cmos5l_fill_2
XFILLER_13_899 VPWR VGND sg13cmos5l_fill_2
X_3649__112 _3649_/D VPWR VGND sg13cmos5l_tielo
XFILLER_4_553 VPWR VGND sg13cmos5l_decap_4
X_2030_ _2030_/Y _3803_/Q _2284_/B VPWR VGND sg13cmos5l_nand2_1
XFILLER_48_796 VPWR VGND sg13cmos5l_decap_8
XFILLER_35_457 VPWR VGND sg13cmos5l_fill_1
XFILLER_44_980 VPWR VGND sg13cmos5l_decap_8
X_2932_ _2932_/Y _2913_/Y _2930_/Y _2931_/Y VPWR VGND sg13cmos5l_a21oi_1
X_2863_ _2863_/Y _3031_/A _3030_/A VPWR VGND sg13cmos5l_nand2_1
XFILLER_30_162 VPWR VGND sg13cmos5l_decap_8
XFILLER_11_1005 VPWR VGND sg13cmos5l_decap_8
X_2794_ _2794_/X _3529_/Q _3512_/Q _3495_/Q _3478_/Q _2826_/A1 _2826_/B1 VPWR VGND
+ sg13cmos5l_mux4_1
XFILLER_8_870 VPWR VGND sg13cmos5l_decap_8
XFILLER_7_83 VPWR VGND sg13cmos5l_decap_4
X_3415_ _3706_/D _3463_/B _3415_/B VPWR VGND sg13cmos5l_and2_1
X_3628__218 _3628_/RESET_B VPWR VGND sg13cmos5l_tiehi
X_3346_ _3692_/D _3347_/A _3346_/B VPWR VGND sg13cmos5l_and2_1
XFILLER_39_741 VPWR VGND sg13cmos5l_fill_2
X_3277_ _3277_/Y _3668_/Q _3294_/A _3275_/Y _3276_/Y VPWR VGND sg13cmos5l_a22oi_1
XFILLER_38_273 VPWR VGND sg13cmos5l_fill_1
XFILLER_38_262 VPWR VGND sg13cmos5l_fill_2
X_2228_ _2229_/B _3731_/Q _2228_/B _2232_/C VPWR VGND sg13cmos5l_and3_1
XFILLER_27_936 VPWR VGND sg13cmos5l_decap_8
XFILLER_38_284 VPWR VGND sg13cmos5l_fill_2
X_2159_ _2159_/Y _2150_/A _2150_/B _2161_/A _2161_/B VPWR VGND sg13cmos5l_a22oi_1
XFILLER_41_405 VPWR VGND sg13cmos5l_fill_2
XFILLER_14_608 VPWR VGND sg13cmos5l_decap_8
XFILLER_41_416 VPWR VGND sg13cmos5l_fill_1
XFILLER_10_803 VPWR VGND sg13cmos5l_fill_1
XFILLER_22_641 VPWR VGND sg13cmos5l_fill_1
XFILLER_10_825 VPWR VGND sg13cmos5l_decap_8
XFILLER_10_858 VPWR VGND sg13cmos5l_decap_8
XFILLER_1_512 VPWR VGND sg13cmos5l_fill_2
XFILLER_49_505 VPWR VGND sg13cmos5l_decap_8
XFILLER_49_527 VPWR VGND sg13cmos5l_decap_8
XFILLER_17_413 VPWR VGND sg13cmos5l_decap_4
XFILLER_45_733 VPWR VGND sg13cmos5l_decap_8
XFILLER_29_284 VPWR VGND sg13cmos5l_fill_1
XFILLER_45_777 VPWR VGND sg13cmos5l_decap_8
XFILLER_9_634 VPWR VGND sg13cmos5l_decap_8
XFILLER_32_80 VPWR VGND sg13cmos5l_decap_4
XFILLER_5_873 VPWR VGND sg13cmos5l_decap_8
XFILLER_4_350 VPWR VGND sg13cmos5l_decap_8
X_3200_ _3216_/B _3198_/Y _3199_/Y _3197_/Y VPWR VGND sg13cmos5l_a21oi_1
X_3131_ _3131_/Y _3131_/A _3130_/Y VPWR VGND sg13cmos5l_nor2b_1
X_3062_ _3065_/A _3046_/A _3062_/B VPWR VGND sg13cmos5l_nand2b_1
X_2013_ _2593_/A _2587_/A _3798_/Q VPWR VGND sg13cmos5l_nor2_1
XFILLER_35_210 VPWR VGND sg13cmos5l_fill_1
XFILLER_36_777 VPWR VGND sg13cmos5l_decap_8
XFILLER_35_276 VPWR VGND sg13cmos5l_decap_8
Xclkbuf_leaf_15_clk _3728_/CLK clkbuf_leaf_2_clk/A VPWR VGND sg13cmos5l_buf_8
XFILLER_23_449 VPWR VGND sg13cmos5l_decap_8
X_2915_ _2915_/Y _3601_/Q _3582_/Q VPWR VGND sg13cmos5l_xnor2_1
X_2846_ _2846_/Y _2846_/A _2846_/B _2846_/C _2846_/D VPWR VGND sg13cmos5l_nand4_1
X_2777_ _3575_/D _2774_/Y _2776_/Y _2772_/A VPWR VGND sg13cmos5l_a21oi_1
X_3329_ _3329_/Y _3317_/B _3327_/X _3328_/Y VPWR VGND sg13cmos5l_a21oi_1
XFILLER_46_508 VPWR VGND sg13cmos5l_fill_1
XFILLER_37_36 VPWR VGND sg13cmos5l_fill_2
XFILLER_2_1003 VPWR VGND sg13cmos5l_decap_8
XFILLER_27_700 VPWR VGND sg13cmos5l_decap_8
XFILLER_39_593 VPWR VGND sg13cmos5l_decap_8
XFILLER_26_210 VPWR VGND sg13cmos5l_decap_8
XFILLER_26_298 VPWR VGND sg13cmos5l_decap_4
XFILLER_27_799 VPWR VGND sg13cmos5l_decap_8
XFILLER_14_449 VPWR VGND sg13cmos5l_fill_1
XFILLER_10_644 VPWR VGND sg13cmos5l_decap_8
XFILLER_6_604 VPWR VGND sg13cmos5l_decap_4
XFILLER_5_169 VPWR VGND sg13cmos5l_decap_8
XFILLER_2_821 VPWR VGND sg13cmos5l_decap_8
XFILLER_49_313 VPWR VGND sg13cmos5l_decap_8
XFILLER_2_898 VPWR VGND sg13cmos5l_decap_8
XFILLER_49_379 VPWR VGND sg13cmos5l_fill_2
XFILLER_17_276 VPWR VGND sg13cmos5l_fill_2
XFILLER_33_747 VPWR VGND sg13cmos5l_fill_1
XFILLER_14_994 VPWR VGND sg13cmos5l_decap_8
XFILLER_41_791 VPWR VGND sg13cmos5l_decap_8
X_2700_ _2700_/Y _2698_/Y hold654/X _3801_/D VPWR VGND sg13cmos5l_a21oi_1
X_3680_ _3680_/Q _3712_/CLK _3680_/D _3680_/RESET_B VPWR VGND sg13cmos5l_dfrbpq_1
X_2631_ _3505_/D input8/X hold580/X _2637_/S VPWR VGND sg13cmos5l_mux2_1
X_2562_ _3793_/D _2418_/B hold748/X _2561_/A VPWR VGND sg13cmos5l_a21oi_1
XFILLER_4_191 VPWR VGND sg13cmos5l_decap_8
X_2493_ _2493_/X _2498_/B _2507_/A VPWR VGND sg13cmos5l_and2_1
Xclkbuf_leaf_4_clk clkload6/A clkbuf_leaf_9_clk/A VPWR VGND sg13cmos5l_buf_8
XFILLER_28_508 VPWR VGND sg13cmos5l_fill_1
X_3114_ _3114_/X _3114_/A _3287_/A VPWR VGND sg13cmos5l_and2_1
XFILLER_49_880 VPWR VGND sg13cmos5l_decap_8
X_3045_ _3046_/B _3045_/A _3052_/C VPWR VGND sg13cmos5l_xnor2_1
XFILLER_23_213 VPWR VGND sg13cmos5l_fill_2
XFILLER_24_747 VPWR VGND sg13cmos5l_decap_8
XFILLER_24_769 VPWR VGND sg13cmos5l_decap_4
XFILLER_17_1011 VPWR VGND sg13cmos5l_decap_8
XFILLER_20_931 VPWR VGND sg13cmos5l_decap_8
X_2829_ _2829_/Y _2824_/Y _2828_/Y _3569_/Q VPWR VGND sg13cmos5l_a21oi_1
XFILLER_3_618 VPWR VGND sg13cmos5l_decap_8
XFILLER_2_106 VPWR VGND sg13cmos5l_fill_1
X_3569__293 _3569_/RESET_B VPWR VGND sg13cmos5l_tiehi
XFILLER_47_828 VPWR VGND sg13cmos5l_decap_8
XFILLER_48_68 VPWR VGND sg13cmos5l_decap_8
X_3797__413 _3797_/RESET_B VPWR VGND sg13cmos5l_tiehi
X_3676__108 _3676_/D VPWR VGND sg13cmos5l_tielo
XFILLER_15_736 VPWR VGND sg13cmos5l_decap_8
XFILLER_9_18 VPWR VGND sg13cmos5l_decap_8
XFILLER_14_224 VPWR VGND sg13cmos5l_decap_8
XFILLER_30_706 VPWR VGND sg13cmos5l_fill_2
Xfanout50 _2428_/B _3790_/Q VPWR VGND sg13cmos5l_buf_1
Xfanout72 _2597_/C _2457_/A VPWR VGND sg13cmos5l_buf_1
Xfanout83 _3461_/A _2838_/B1 VPWR VGND sg13cmos5l_buf_1
Xfanout61 _2826_/B1 _2832_/S1 VPWR VGND sg13cmos5l_buf_1
XFILLER_31_1019 VPWR VGND sg13cmos5l_decap_8
XFILLER_7_946 VPWR VGND sg13cmos5l_decap_8
XFILLER_6_456 VPWR VGND sg13cmos5l_decap_8
XFILLER_2_684 VPWR VGND sg13cmos5l_fill_2
XFILLER_49_154 VPWR VGND sg13cmos5l_decap_8
XFILLER_38_817 VPWR VGND sg13cmos5l_decap_8
XFILLER_49_198 VPWR VGND sg13cmos5l_decap_8
XFILLER_37_349 VPWR VGND sg13cmos5l_decap_8
XFILLER_45_382 VPWR VGND sg13cmos5l_fill_2
X_3801_ _3801_/Q clkload2/A _3801_/D _3801_/RESET_B VPWR VGND sg13cmos5l_dfrbpq_1
XFILLER_33_577 VPWR VGND sg13cmos5l_decap_8
XFILLER_33_588 VPWR VGND sg13cmos5l_decap_4
XFILLER_21_739 VPWR VGND sg13cmos5l_decap_8
X_1993_ _1993_/Y _1993_/A VPWR VGND sg13cmos5l_inv_1
X_3732_ _3732_/Q _3766_/CLK _3732_/D _3732_/RESET_B VPWR VGND sg13cmos5l_dfrbpq_1
XFILLER_13_290 VPWR VGND sg13cmos5l_decap_8
X_3663_ _3663_/Q _3722_/CLK _3663_/D _3663_/RESET_B VPWR VGND sg13cmos5l_dfrbpq_1
X_2614_ _3491_/D input11/X hold551/X _2617_/S VPWR VGND sg13cmos5l_mux2_1
X_3594_ _3594_/Q _3665_/CLK _3594_/D _3594_/RESET_B VPWR VGND sg13cmos5l_dfrbpq_1
X_2545_ _2549_/B _2545_/A _2545_/B _2545_/C VPWR VGND sg13cmos5l_or3_1
X_2476_ _2530_/C _3786_/Q _2545_/B VPWR VGND sg13cmos5l_xnor2_1
XFILLER_18_38 VPWR VGND sg13cmos5l_decap_8
X_3028_ _3633_/D _3028_/A _3030_/B VPWR VGND sg13cmos5l_and2_1
XFILLER_36_382 VPWR VGND sg13cmos5l_decap_4
XFILLER_24_588 VPWR VGND sg13cmos5l_decap_8
XFILLER_11_216 VPWR VGND sg13cmos5l_decap_8
Xclkload3 clkload3/X clkload3/A VPWR VGND sg13cmos5l_buf_8
XFILLER_4_916 VPWR VGND sg13cmos5l_decap_8
XFILLER_3_415 VPWR VGND sg13cmos5l_fill_2
XFILLER_3_448 VPWR VGND sg13cmos5l_fill_2
XFILLER_47_614 VPWR VGND sg13cmos5l_decap_8
XFILLER_28_850 VPWR VGND sg13cmos5l_decap_8
XFILLER_42_330 VPWR VGND sg13cmos5l_decap_8
XFILLER_15_533 VPWR VGND sg13cmos5l_decap_8
XFILLER_15_555 VPWR VGND sg13cmos5l_decap_8
XFILLER_7_732 VPWR VGND sg13cmos5l_decap_8
XFILLER_6_275 VPWR VGND sg13cmos5l_decap_4
XFILLER_6_264 VPWR VGND sg13cmos5l_decap_4
X_2330_ _2330_/Y _3761_/Q _2337_/B VPWR VGND sg13cmos5l_nand2_1
X_2261_ _2261_/Y _2261_/A _2261_/B VPWR VGND sg13cmos5l_nand2_1
XFILLER_38_614 VPWR VGND sg13cmos5l_decap_8
XFILLER_27_4 VPWR VGND sg13cmos5l_fill_2
XFILLER_38_647 VPWR VGND sg13cmos5l_decap_8
XFILLER_37_124 VPWR VGND sg13cmos5l_fill_2
X_2192_ _2192_/Y _2464_/A _2198_/B VPWR VGND sg13cmos5l_nand2_1
XFILLER_38_669 VPWR VGND sg13cmos5l_decap_8
XFILLER_38_658 VPWR VGND sg13cmos5l_fill_2
XFILLER_25_308 VPWR VGND sg13cmos5l_fill_1
XFILLER_33_330 VPWR VGND sg13cmos5l_fill_2
XFILLER_21_503 VPWR VGND sg13cmos5l_decap_8
XFILLER_33_396 VPWR VGND sg13cmos5l_fill_2
X_1976_ _2468_/A _2257_/B VPWR VGND sg13cmos5l_inv_1
X_3715_ _3715_/Q _3783_/CLK _3715_/D _3715_/RESET_B VPWR VGND sg13cmos5l_dfrbpq_1
X_3646_ _3646_/Q _3666_/CLK _3646_/D _3646_/RESET_B VPWR VGND sg13cmos5l_dfrbpq_1
X_3577_ _3577_/Q _3629_/CLK _3577_/D _3577_/RESET_B VPWR VGND sg13cmos5l_dfrbpq_1
X_2528_ _2528_/Y _2529_/B _2529_/C _2553_/A VPWR VGND sg13cmos5l_o21ai_1
X_2459_ _2459_/Y _1957_/Y _3020_/A2 _2458_/Y VPWR VGND sg13cmos5l_a21oi_1
XFILLER_29_614 VPWR VGND sg13cmos5l_decap_8
XFILLER_28_157 VPWR VGND sg13cmos5l_decap_8
XFILLER_43_127 VPWR VGND sg13cmos5l_fill_2
XFILLER_25_842 VPWR VGND sg13cmos5l_fill_2
XFILLER_24_374 VPWR VGND sg13cmos5l_decap_8
XFILLER_24_385 VPWR VGND sg13cmos5l_fill_1
XFILLER_10_72 VPWR VGND sg13cmos5l_fill_1
XFILLER_0_930 VPWR VGND sg13cmos5l_decap_8
X_3725__215 _3725_/RESET_B VPWR VGND sg13cmos5l_tiehi
XFILLER_48_901 VPWR VGND sg13cmos5l_decap_8
XFILLER_19_102 VPWR VGND sg13cmos5l_fill_1
XFILLER_48_978 VPWR VGND sg13cmos5l_decap_8
XFILLER_47_444 VPWR VGND sg13cmos5l_decap_4
XFILLER_19_92 VPWR VGND sg13cmos5l_fill_2
XFILLER_35_617 VPWR VGND sg13cmos5l_decap_8
XFILLER_16_853 VPWR VGND sg13cmos5l_fill_1
XFILLER_37_1003 VPWR VGND sg13cmos5l_decap_8
XFILLER_43_694 VPWR VGND sg13cmos5l_decap_8
XFILLER_16_897 VPWR VGND sg13cmos5l_decap_4
XFILLER_31_845 VPWR VGND sg13cmos5l_fill_1
X_3500_ _3500_/Q clkload8/A _3500_/D _3500_/RESET_B VPWR VGND sg13cmos5l_dfrbpq_1
Xhold518 _2596_/A _3556_/Q VPWR VGND sg13cmos5l_dlygate4sd3_1
Xhold507 _2689_/A _3558_/Q VPWR VGND sg13cmos5l_dlygate4sd3_1
X_3431_ _3431_/Y _3683_/Q _3436_/B VPWR VGND sg13cmos5l_nand2_1
Xhold529 _3782_/D _2461_/Y VPWR VGND sg13cmos5l_dlygate4sd3_1
X_3362_ _3388_/B _3391_/B _3391_/C _3258_/Y VPWR VGND sg13cmos5l_a21oi_1
X_2313_ _2313_/Y _2200_/A _2238_/B _2310_/Y _2311_/Y _2312_/Y VPWR VGND sg13cmos5l_a221oi_1
Xheichips26_dna_sequencer_101 uo_out[7] VPWR VGND sg13cmos5l_tielo
X_3293_ _3355_/C _3288_/A _3293_/B VPWR VGND sg13cmos5l_nand2b_1
XFILLER_39_945 VPWR VGND sg13cmos5l_decap_8
XFILLER_38_400 VPWR VGND sg13cmos5l_fill_2
X_2244_ _2244_/Y _2466_/A _3716_/Q _2243_/Y VPWR VGND sg13cmos5l_o21ai_1
X_2175_ _2175_/X _2185_/B _2181_/C _2198_/A VPWR VGND sg13cmos5l_a21o_1
XFILLER_15_39 VPWR VGND sg13cmos5l_decap_8
XFILLER_22_801 VPWR VGND sg13cmos5l_decap_4
XFILLER_22_856 VPWR VGND sg13cmos5l_decap_8
XFILLER_33_182 VPWR VGND sg13cmos5l_fill_2
XFILLER_21_388 VPWR VGND sg13cmos5l_fill_1
X_1959_ _1959_/Y _3747_/Q VPWR VGND sg13cmos5l_inv_1
X_3629_ _3629_/Q _3629_/CLK _3629_/D _3629_/RESET_B VPWR VGND sg13cmos5l_dfrbpq_1
Xoutput16 uo_out[2] _3550_/Q VPWR VGND sg13cmos5l_buf_1
XFILLER_0_248 VPWR VGND sg13cmos5l_decap_8
XFILLER_44_403 VPWR VGND sg13cmos5l_fill_1
XFILLER_45_959 VPWR VGND sg13cmos5l_decap_8
XFILLER_29_499 VPWR VGND sg13cmos5l_decap_4
XFILLER_32_609 VPWR VGND sg13cmos5l_decap_8
XFILLER_12_311 VPWR VGND sg13cmos5l_decap_8
XFILLER_13_812 VPWR VGND sg13cmos5l_decap_8
XFILLER_24_160 VPWR VGND sg13cmos5l_decap_8
XFILLER_40_631 VPWR VGND sg13cmos5l_decap_8
XFILLER_9_805 VPWR VGND sg13cmos5l_fill_2
XFILLER_40_686 VPWR VGND sg13cmos5l_decap_4
XFILLER_12_399 VPWR VGND sg13cmos5l_fill_1
XFILLER_4_532 VPWR VGND sg13cmos5l_decap_8
X_3482__401 _3482_/RESET_B VPWR VGND sg13cmos5l_tiehi
XFILLER_48_775 VPWR VGND sg13cmos5l_decap_8
XFILLER_36_959 VPWR VGND sg13cmos5l_decap_8
XFILLER_35_436 VPWR VGND sg13cmos5l_decap_8
X_2931_ _2931_/Y _2912_/C _2929_/Y _2921_/X VPWR VGND sg13cmos5l_o21ai_1
XFILLER_16_694 VPWR VGND sg13cmos5l_fill_1
Xclkbuf_0_clk clkbuf_0_clk/X clk VPWR VGND sg13cmos5l_buf_8
XFILLER_31_642 VPWR VGND sg13cmos5l_fill_1
X_2862_ _2862_/Y _2979_/A _2857_/A _2861_/Y VPWR VGND sg13cmos5l_a21oi_1
XFILLER_30_141 VPWR VGND sg13cmos5l_decap_8
X_2793_ _2793_/X _3570_/Q _2793_/B VPWR VGND sg13cmos5l_and2_1
XFILLER_11_1028 VPWR VGND sg13cmos5l_fill_1
XFILLER_7_95 VPWR VGND sg13cmos5l_fill_1
X_3414_ _3705_/D _2137_/B _2137_/C _3466_/B VPWR VGND sg13cmos5l_a21oi_1
X_3345_ _3691_/D _3460_/A _3345_/B VPWR VGND sg13cmos5l_and2_1
X_3708__298 _3708_/RESET_B VPWR VGND sg13cmos5l_tiehi
X_3276_ _3276_/Y _3088_/A _3647_/Q VPWR VGND sg13cmos5l_nand2b_1
XFILLER_39_753 VPWR VGND sg13cmos5l_decap_8
X_2227_ _2229_/A _2232_/B _2232_/C _2226_/Y VPWR VGND sg13cmos5l_a21oi_1
X_2158_ _2161_/B _2140_/Y _3415_/B _2158_/S VPWR VGND sg13cmos5l_mux2_1
X_2089_ _2090_/B _2089_/A _2089_/B VPWR VGND sg13cmos5l_xnor2_1
XFILLER_21_196 VPWR VGND sg13cmos5l_decap_8
XFILLER_27_1013 VPWR VGND sg13cmos5l_decap_8
XFILLER_45_712 VPWR VGND sg13cmos5l_decap_8
XFILLER_18_915 VPWR VGND sg13cmos5l_fill_1
XFILLER_45_756 VPWR VGND sg13cmos5l_decap_8
XFILLER_44_244 VPWR VGND sg13cmos5l_fill_2
XFILLER_17_447 VPWR VGND sg13cmos5l_decap_4
XFILLER_33_929 VPWR VGND sg13cmos5l_decap_8
XFILLER_9_602 VPWR VGND sg13cmos5l_decap_8
XFILLER_13_631 VPWR VGND sg13cmos5l_fill_1
XFILLER_25_491 VPWR VGND sg13cmos5l_decap_4
XFILLER_41_984 VPWR VGND sg13cmos5l_decap_8
XFILLER_40_461 VPWR VGND sg13cmos5l_decap_8
XFILLER_12_130 VPWR VGND sg13cmos5l_decap_4
XFILLER_12_152 VPWR VGND sg13cmos5l_decap_8
XFILLER_34_1017 VPWR VGND sg13cmos5l_decap_8
XFILLER_34_1028 VPWR VGND sg13cmos5l_fill_1
XFILLER_9_679 VPWR VGND sg13cmos5l_decap_4
X_3809__407 _3809_/RESET_B VPWR VGND sg13cmos5l_tiehi
XFILLER_5_852 VPWR VGND sg13cmos5l_decap_8
X_3130_ _3130_/Y _3125_/Y _3128_/Y _3129_/Y VPWR VGND sg13cmos5l_o21ai_1
XFILLER_48_572 VPWR VGND sg13cmos5l_fill_2
X_3061_ _3061_/X _3061_/A _3061_/B VPWR VGND sg13cmos5l_xor2_1
X_2012_ _3805_/D _2291_/A _2755_/A VPWR VGND sg13cmos5l_and2_1
XFILLER_35_222 VPWR VGND sg13cmos5l_fill_2
XFILLER_31_461 VPWR VGND sg13cmos5l_fill_2
XFILLER_32_995 VPWR VGND sg13cmos5l_decap_8
X_3634__201 _3634_/RESET_B VPWR VGND sg13cmos5l_tiehi
X_2914_ _2927_/A _3603_/Q _2919_/B VPWR VGND sg13cmos5l_nand2_1
XFILLER_12_18 VPWR VGND sg13cmos5l_decap_8
X_2845_ _2845_/X _2846_/A _2846_/B _2846_/C _2846_/D VPWR VGND sg13cmos5l_and4_1
X_2776_ _2776_/Y _2876_/A hold689/X _2762_/Y VPWR VGND sg13cmos5l_o21ai_1
X_3328_ _3328_/Y hold696/X _3327_/X _3352_/B VPWR VGND sg13cmos5l_o21ai_1
X_3259_ _3672_/D _3410_/A _3259_/B VPWR VGND sg13cmos5l_nor2_1
XFILLER_37_59 VPWR VGND sg13cmos5l_decap_8
XFILLER_15_918 VPWR VGND sg13cmos5l_decap_8
XFILLER_14_428 VPWR VGND sg13cmos5l_decap_8
XFILLER_15_929 VPWR VGND sg13cmos5l_fill_1
XFILLER_22_450 VPWR VGND sg13cmos5l_fill_2
XFILLER_23_984 VPWR VGND sg13cmos5l_decap_8
XFILLER_10_678 VPWR VGND sg13cmos5l_decap_8
XFILLER_6_649 VPWR VGND sg13cmos5l_fill_1
XFILLER_10_689 VPWR VGND sg13cmos5l_fill_2
XFILLER_2_800 VPWR VGND sg13cmos5l_decap_8
X_3767__454 _3767_/RESET_B VPWR VGND sg13cmos5l_tiehi
XFILLER_1_310 VPWR VGND sg13cmos5l_fill_1
Xhold690 _3351_/A _3670_/Q VPWR VGND sg13cmos5l_dlygate4sd3_1
XFILLER_2_877 VPWR VGND sg13cmos5l_decap_8
XFILLER_49_358 VPWR VGND sg13cmos5l_decap_8
XFILLER_40_1021 VPWR VGND sg13cmos5l_decap_8
XFILLER_17_200 VPWR VGND sg13cmos5l_fill_1
XFILLER_18_745 VPWR VGND sg13cmos5l_decap_4
XFILLER_45_553 VPWR VGND sg13cmos5l_decap_8
XFILLER_17_233 VPWR VGND sg13cmos5l_decap_8
XFILLER_33_704 VPWR VGND sg13cmos5l_fill_2
XFILLER_45_586 VPWR VGND sg13cmos5l_decap_4
X_3774__447 _3774_/RESET_B VPWR VGND sg13cmos5l_tiehi
XFILLER_32_203 VPWR VGND sg13cmos5l_decap_4
XFILLER_33_726 VPWR VGND sg13cmos5l_decap_8
XFILLER_14_973 VPWR VGND sg13cmos5l_decap_8
XFILLER_9_432 VPWR VGND sg13cmos5l_decap_4
X_2630_ _3504_/D input7/X hold596/X _2637_/S VPWR VGND sg13cmos5l_mux2_1
X_2561_ _3792_/D _2561_/A _2561_/B _2561_/C VPWR VGND sg13cmos5l_nor3_1
X_2492_ _2507_/A _2490_/Y _2491_/Y _3745_/Q VPWR VGND sg13cmos5l_a21o_1
XFILLER_5_660 VPWR VGND sg13cmos5l_decap_8
XFILLER_4_170 VPWR VGND sg13cmos5l_decap_8
X_3113_ _3643_/D _3192_/A _3192_/B _3143_/A VPWR VGND sg13cmos5l_a21oi_1
X_3044_ _3046_/A _3042_/Y _3043_/Y _3036_/Y VPWR VGND sg13cmos5l_o21ai_1
XFILLER_36_553 VPWR VGND sg13cmos5l_decap_4
XFILLER_23_269 VPWR VGND sg13cmos5l_decap_8
X_2828_ _2828_/Y _2828_/A VPWR VGND sg13cmos5l_inv_1
XFILLER_20_987 VPWR VGND sg13cmos5l_decap_8
X_2759_ _2759_/Y _2759_/A _2767_/B VPWR VGND sg13cmos5l_nor2b_1
XFILLER_47_807 VPWR VGND sg13cmos5l_decap_8
XFILLER_46_328 VPWR VGND sg13cmos5l_fill_2
XFILLER_15_726 VPWR VGND sg13cmos5l_decap_4
XFILLER_27_564 VPWR VGND sg13cmos5l_fill_1
XFILLER_42_523 VPWR VGND sg13cmos5l_decap_8
Xfanout40 _2151_/B _2088_/B VPWR VGND sg13cmos5l_buf_1
XFILLER_10_420 VPWR VGND sg13cmos5l_decap_8
Xfanout51 _2737_/A1 _2363_/A VPWR VGND sg13cmos5l_buf_1
Xfanout73 _2457_/A _2672_/A VPWR VGND sg13cmos5l_buf_1
Xfanout62 _2832_/S1 _3547_/Q VPWR VGND sg13cmos5l_buf_1
XFILLER_7_925 VPWR VGND sg13cmos5l_decap_8
Xfanout84 _2838_/B1 input1/X VPWR VGND sg13cmos5l_buf_1
XFILLER_6_413 VPWR VGND sg13cmos5l_decap_8
XFILLER_11_998 VPWR VGND sg13cmos5l_decap_8
XFILLER_2_663 VPWR VGND sg13cmos5l_decap_8
XFILLER_49_177 VPWR VGND sg13cmos5l_decap_8
XFILLER_46_895 VPWR VGND sg13cmos5l_decap_8
XFILLER_18_597 VPWR VGND sg13cmos5l_decap_8
X_3800_ _3800_/Q _3806_/CLK _3800_/D _3800_/RESET_B VPWR VGND sg13cmos5l_dfrbpq_1
X_1992_ _1992_/Y _1992_/A VPWR VGND sg13cmos5l_inv_1
X_3731_ _3731_/Q _3731_/CLK _3731_/D _3731_/RESET_B VPWR VGND sg13cmos5l_dfrbpq_1
X_3662_ _3662_/Q _3722_/CLK _3662_/D _3662_/RESET_B VPWR VGND sg13cmos5l_dfrbpq_1
Xclkload10 clkload10/Y _3629_/CLK VPWR VGND sg13cmos5l_inv_2
X_3593_ _3593_/Q _3665_/CLK _3593_/D _3593_/RESET_B VPWR VGND sg13cmos5l_dfrbpq_1
X_2613_ _3490_/D input10/X hold557/X _2617_/S VPWR VGND sg13cmos5l_mux2_1
X_2544_ _2544_/Y _2544_/A _2560_/A VPWR VGND sg13cmos5l_nor2_1
XFILLER_48_0 VPWR VGND sg13cmos5l_decap_8
X_2475_ _2530_/B _3783_/Q _3757_/Q _3785_/Q VPWR VGND sg13cmos5l_nand3_1
XFILLER_37_840 VPWR VGND sg13cmos5l_decap_8
XFILLER_24_512 VPWR VGND sg13cmos5l_fill_1
X_3027_ _3632_/D _3347_/A _3027_/B VPWR VGND sg13cmos5l_and2_1
X_3757__464 _3757_/RESET_B VPWR VGND sg13cmos5l_tiehi
XFILLER_24_534 VPWR VGND sg13cmos5l_decap_8
XFILLER_24_567 VPWR VGND sg13cmos5l_decap_4
XFILLER_11_239 VPWR VGND sg13cmos5l_fill_1
Xclkload4 clkload4/X clkload4/A VPWR VGND sg13cmos5l_buf_8
X_3764__457 _3764_/RESET_B VPWR VGND sg13cmos5l_tiehi
XFILLER_8_1010 VPWR VGND sg13cmos5l_decap_8
XFILLER_43_821 VPWR VGND sg13cmos5l_fill_1
XFILLER_15_512 VPWR VGND sg13cmos5l_decap_8
XFILLER_27_350 VPWR VGND sg13cmos5l_fill_2
XFILLER_28_862 VPWR VGND sg13cmos5l_fill_2
XFILLER_34_309 VPWR VGND sg13cmos5l_decap_8
XFILLER_27_372 VPWR VGND sg13cmos5l_decap_8
XFILLER_42_342 VPWR VGND sg13cmos5l_decap_8
XFILLER_24_82 VPWR VGND sg13cmos5l_decap_8
XFILLER_7_777 VPWR VGND sg13cmos5l_fill_2
XFILLER_10_272 VPWR VGND sg13cmos5l_decap_8
XFILLER_40_92 VPWR VGND sg13cmos5l_fill_1
XFILLER_3_983 VPWR VGND sg13cmos5l_decap_8
XFILLER_2_482 VPWR VGND sg13cmos5l_fill_1
XFILLER_2_493 VPWR VGND sg13cmos5l_decap_8
X_2260_ _2260_/Y _1959_/Y _2254_/A _2259_/A _2421_/A _2255_/Y VPWR VGND sg13cmos5l_a221oi_1
X_2191_ _2198_/C _2186_/Y _2190_/Y _2171_/Y VPWR VGND sg13cmos5l_o21ai_1
XFILLER_37_136 VPWR VGND sg13cmos5l_decap_8
XFILLER_19_851 VPWR VGND sg13cmos5l_fill_2
XFILLER_37_158 VPWR VGND sg13cmos5l_fill_1
XFILLER_18_372 VPWR VGND sg13cmos5l_decap_8
XFILLER_19_895 VPWR VGND sg13cmos5l_decap_8
XFILLER_34_876 VPWR VGND sg13cmos5l_decap_8
XFILLER_34_887 VPWR VGND sg13cmos5l_fill_2
XFILLER_21_537 VPWR VGND sg13cmos5l_fill_1
X_1975_ _2467_/A _1975_/A VPWR VGND sg13cmos5l_inv_1
XFILLER_14_1015 VPWR VGND sg13cmos5l_decap_8
XFILLER_21_548 VPWR VGND sg13cmos5l_fill_1
XFILLER_21_559 VPWR VGND sg13cmos5l_decap_8
X_3714_ _3714_/Q clkload3/A _3714_/D _3714_/RESET_B VPWR VGND sg13cmos5l_dfrbpq_1
X_3645_ _3645_/Q _3666_/CLK _3645_/D _3645_/RESET_B VPWR VGND sg13cmos5l_dfrbpq_1
X_3576_ _3576_/Q _3629_/CLK _3576_/D _3576_/RESET_B VPWR VGND sg13cmos5l_dfrbpq_1
X_2527_ _2529_/C _2527_/A _2527_/B _2527_/C VPWR VGND sg13cmos5l_nor3_1
X_2458_ _2458_/Y _3781_/Q _3020_/A2 _3459_/A VPWR VGND sg13cmos5l_o21ai_1
X_2389_ _2389_/Y _2411_/A _2373_/X _2393_/A _2387_/Y VPWR VGND sg13cmos5l_a22oi_1
XFILLER_21_1008 VPWR VGND sg13cmos5l_decap_8
XFILLER_28_136 VPWR VGND sg13cmos5l_decap_8
XFILLER_43_106 VPWR VGND sg13cmos5l_decap_8
XFILLER_43_139 VPWR VGND sg13cmos5l_decap_8
XFILLER_40_802 VPWR VGND sg13cmos5l_decap_8
XFILLER_24_331 VPWR VGND sg13cmos5l_fill_1
XFILLER_12_504 VPWR VGND sg13cmos5l_decap_8
XFILLER_40_857 VPWR VGND sg13cmos5l_decap_8
XFILLER_4_714 VPWR VGND sg13cmos5l_fill_1
XFILLER_4_758 VPWR VGND sg13cmos5l_decap_4
XFILLER_10_40 VPWR VGND sg13cmos5l_fill_1
XFILLER_0_986 VPWR VGND sg13cmos5l_decap_8
XFILLER_48_957 VPWR VGND sg13cmos5l_decap_8
XFILLER_19_71 VPWR VGND sg13cmos5l_decap_8
XFILLER_43_662 VPWR VGND sg13cmos5l_decap_4
XFILLER_31_802 VPWR VGND sg13cmos5l_decap_4
XFILLER_35_81 VPWR VGND sg13cmos5l_decap_8
XFILLER_11_570 VPWR VGND sg13cmos5l_decap_8
Xhold508 _2027_/A _3797_/Q VPWR VGND sg13cmos5l_dlygate4sd3_1
X_3430_ _3430_/Y _3336_/A _3427_/X _3437_/C _3429_/Y VPWR VGND sg13cmos5l_a22oi_1
Xhold519 _3556_/D _2720_/Y VPWR VGND sg13cmos5l_dlygate4sd3_1
X_3361_ _3388_/A _3395_/A _3353_/B _3357_/X _3358_/Y _3292_/B VPWR VGND sg13cmos5l_a221oi_1
XFILLER_44_1008 VPWR VGND sg13cmos5l_decap_8
X_2312_ _2312_/Y _2311_/B _2311_/C _2311_/A VPWR VGND sg13cmos5l_a21oi_1
XFILLER_3_780 VPWR VGND sg13cmos5l_decap_8
X_3292_ _3677_/D _3352_/B _3292_/B VPWR VGND sg13cmos5l_and2_1
XFILLER_39_924 VPWR VGND sg13cmos5l_decap_8
XFILLER_38_412 VPWR VGND sg13cmos5l_decap_8
X_2243_ _2243_/Y _3717_/Q _3766_/Q VPWR VGND sg13cmos5l_nand2b_1
XFILLER_38_434 VPWR VGND sg13cmos5l_fill_1
XFILLER_38_423 VPWR VGND sg13cmos5l_fill_2
X_2174_ _2174_/X _2185_/B _2181_/C VPWR VGND sg13cmos5l_and2_1
XFILLER_25_128 VPWR VGND sg13cmos5l_fill_2
XFILLER_25_139 VPWR VGND sg13cmos5l_decap_4
XFILLER_15_18 VPWR VGND sg13cmos5l_decap_8
XFILLER_34_662 VPWR VGND sg13cmos5l_fill_2
XFILLER_40_109 VPWR VGND sg13cmos5l_decap_8
XFILLER_21_301 VPWR VGND sg13cmos5l_fill_2
X_1958_ _2421_/A _1958_/A VPWR VGND sg13cmos5l_inv_1
XFILLER_31_39 VPWR VGND sg13cmos5l_fill_1
X_3628_ _3628_/Q _3664_/CLK _3628_/D _3628_/RESET_B VPWR VGND sg13cmos5l_dfrbpq_1
Xoutput17 uo_out[3] _3551_/Q VPWR VGND sg13cmos5l_buf_1
XFILLER_0_227 VPWR VGND sg13cmos5l_decap_8
X_3559_ _3559_/Q clkload2/A _3559_/D _3559_/RESET_B VPWR VGND sg13cmos5l_dfrbpq_1
XFILLER_5_1013 VPWR VGND sg13cmos5l_decap_8
XFILLER_45_938 VPWR VGND sg13cmos5l_decap_8
XFILLER_16_128 VPWR VGND sg13cmos5l_fill_1
XFILLER_40_621 VPWR VGND sg13cmos5l_decap_4
XFILLER_40_610 VPWR VGND sg13cmos5l_fill_2
XFILLER_40_654 VPWR VGND sg13cmos5l_fill_1
XFILLER_12_378 VPWR VGND sg13cmos5l_fill_1
XFILLER_4_511 VPWR VGND sg13cmos5l_decap_8
XFILLER_4_577 VPWR VGND sg13cmos5l_decap_8
XFILLER_0_783 VPWR VGND sg13cmos5l_decap_8
XFILLER_48_754 VPWR VGND sg13cmos5l_decap_8
XFILLER_47_264 VPWR VGND sg13cmos5l_decap_8
XFILLER_47_242 VPWR VGND sg13cmos5l_fill_2
XFILLER_36_938 VPWR VGND sg13cmos5l_decap_8
XFILLER_43_470 VPWR VGND sg13cmos5l_fill_2
X_2930_ _2930_/Y _2912_/C _2929_/Y _2926_/Y VPWR VGND sg13cmos5l_a21oi_1
XFILLER_16_673 VPWR VGND sg13cmos5l_decap_8
XFILLER_15_194 VPWR VGND sg13cmos5l_decap_4
XFILLER_31_632 VPWR VGND sg13cmos5l_fill_1
X_2861_ _2861_/Y _3029_/A _2858_/Y _2860_/Y VPWR VGND sg13cmos5l_o21ai_1
X_2792_ _2793_/B _2683_/B _2789_/X _2790_/Y _2791_/X VPWR VGND sg13cmos5l_a22oi_1
XFILLER_30_197 VPWR VGND sg13cmos5l_decap_4
X_3413_ _3704_/D _3466_/B _3413_/B VPWR VGND sg13cmos5l_nor2_1
Xheichips26_dna_sequencer_90 uio_oe[6] VPWR VGND sg13cmos5l_tielo
X_3344_ _3344_/Y _1930_/Y _3344_/A2 _3343_/Y VPWR VGND sg13cmos5l_a21oi_1
X_3275_ _3275_/Y _3667_/Q _3646_/Q VPWR VGND sg13cmos5l_nor2_1
XFILLER_39_743 VPWR VGND sg13cmos5l_fill_1
X_2226_ _2226_/Y _3709_/Q _2231_/A VPWR VGND sg13cmos5l_nand2b_1
XFILLER_38_286 VPWR VGND sg13cmos5l_fill_1
X_2157_ _2161_/A _2087_/A _2087_/B _2156_/X VPWR VGND sg13cmos5l_o21ai_1
XFILLER_26_17 VPWR VGND sg13cmos5l_fill_2
XFILLER_26_415 VPWR VGND sg13cmos5l_fill_2
X_2088_ _2089_/B _2088_/A _2088_/B VPWR VGND sg13cmos5l_xor2_1
XFILLER_35_993 VPWR VGND sg13cmos5l_decap_8
XFILLER_42_16 VPWR VGND sg13cmos5l_decap_8
XFILLER_34_481 VPWR VGND sg13cmos5l_decap_8
XFILLER_1_569 VPWR VGND sg13cmos5l_fill_1
XFILLER_18_927 VPWR VGND sg13cmos5l_decap_8
XFILLER_33_908 VPWR VGND sg13cmos5l_decap_8
XFILLER_26_982 VPWR VGND sg13cmos5l_decap_8
XFILLER_41_963 VPWR VGND sg13cmos5l_decap_8
XFILLER_13_665 VPWR VGND sg13cmos5l_fill_2
XFILLER_8_124 VPWR VGND sg13cmos5l_decap_8
XFILLER_12_186 VPWR VGND sg13cmos5l_decap_8
XFILLER_12_197 VPWR VGND sg13cmos5l_fill_2
XFILLER_5_831 VPWR VGND sg13cmos5l_decap_8
XFILLER_4_385 VPWR VGND sg13cmos5l_decap_4
X_3627__220 _3627_/RESET_B VPWR VGND sg13cmos5l_tiehi
X_3060_ _3061_/B _3633_/Q _3052_/C _3032_/Y VPWR VGND sg13cmos5l_a21oi_1
X_2011_ _2943_/A _3617_/Q VPWR VGND sg13cmos5l_inv_1
XFILLER_48_562 VPWR VGND sg13cmos5l_fill_2
XFILLER_36_702 VPWR VGND sg13cmos5l_decap_8
XFILLER_36_713 VPWR VGND sg13cmos5l_fill_1
X_2913_ _2913_/Y _2913_/A _2913_/B VPWR VGND sg13cmos5l_nand2_1
XFILLER_32_974 VPWR VGND sg13cmos5l_decap_8
X_2844_ _2846_/D _2844_/A _2844_/B VPWR VGND sg13cmos5l_xnor2_1
X_2775_ _2775_/Y _3577_/Q _2775_/B VPWR VGND sg13cmos5l_nand2b_1
X_3327_ _3327_/X _3327_/A _3327_/B VPWR VGND sg13cmos5l_or2_1
XFILLER_37_16 VPWR VGND sg13cmos5l_decap_8
X_3258_ _3258_/Y _3259_/B VPWR VGND sg13cmos5l_inv_1
X_3189_ _3665_/D _3189_/A _3190_/B VPWR VGND sg13cmos5l_nor2_1
X_2209_ _2231_/A _3713_/Q _2210_/B VPWR VGND sg13cmos5l_xnor2_1
XFILLER_26_201 VPWR VGND sg13cmos5l_decap_4
XFILLER_27_746 VPWR VGND sg13cmos5l_decap_8
XFILLER_27_757 VPWR VGND sg13cmos5l_decap_8
XFILLER_27_768 VPWR VGND sg13cmos5l_decap_8
XFILLER_27_779 VPWR VGND sg13cmos5l_fill_1
XFILLER_23_963 VPWR VGND sg13cmos5l_decap_8
XFILLER_6_628 VPWR VGND sg13cmos5l_fill_2
XFILLER_5_105 VPWR VGND sg13cmos5l_fill_2
XFILLER_5_138 VPWR VGND sg13cmos5l_decap_8
XFILLER_2_856 VPWR VGND sg13cmos5l_decap_8
Xhold680 _3717_/D _3451_/Y VPWR VGND sg13cmos5l_dlygate4sd3_1
Xhold691 _3352_/A _3671_/Q VPWR VGND sg13cmos5l_dlygate4sd3_1
XFILLER_49_337 VPWR VGND sg13cmos5l_decap_8
XFILLER_40_1000 VPWR VGND sg13cmos5l_decap_8
XFILLER_18_724 VPWR VGND sg13cmos5l_decap_8
X_3700__314 _3700_/RESET_B VPWR VGND sg13cmos5l_tiehi
XFILLER_45_565 VPWR VGND sg13cmos5l_decap_8
XFILLER_18_779 VPWR VGND sg13cmos5l_decap_4
Xclkbuf_2_0__f_clk clkbuf_leaf_3_clk/A clkbuf_0_clk/X VPWR VGND sg13cmos5l_buf_8
XFILLER_45_598 VPWR VGND sg13cmos5l_decap_8
XFILLER_13_440 VPWR VGND sg13cmos5l_decap_8
XFILLER_13_451 VPWR VGND sg13cmos5l_fill_1
XFILLER_14_952 VPWR VGND sg13cmos5l_decap_8
XFILLER_9_411 VPWR VGND sg13cmos5l_decap_8
X_2560_ _2561_/C _2560_/A _2560_/B _2560_/C VPWR VGND sg13cmos5l_and3_1
X_2491_ _2491_/Y _2467_/A _3744_/Q _2257_/B VPWR VGND sg13cmos5l_a21oi_1
XFILLER_5_694 VPWR VGND sg13cmos5l_decap_8
XFILLER_4_75 VPWR VGND sg13cmos5l_fill_2
X_3112_ _3112_/Y _3192_/A _3192_/B VPWR VGND sg13cmos5l_nand2_1
X_3043_ _3043_/Y _3636_/Q _3052_/C _3040_/Y VPWR VGND sg13cmos5l_o21ai_1
XFILLER_23_29 VPWR VGND sg13cmos5l_decap_8
XFILLER_20_966 VPWR VGND sg13cmos5l_decap_8
XFILLER_31_292 VPWR VGND sg13cmos5l_decap_8
X_2827_ _2828_/A _2825_/Y _2826_/Y _2790_/A VPWR VGND sg13cmos5l_o21ai_1
X_2758_ _2772_/A _2901_/B _3452_/A VPWR VGND sg13cmos5l_nand2b_1
X_2689_ _3477_/C _2689_/A _2689_/B _2717_/B VPWR VGND sg13cmos5l_and3_1
XFILLER_24_1017 VPWR VGND sg13cmos5l_decap_8
XFILLER_24_1028 VPWR VGND sg13cmos5l_fill_1
XFILLER_27_532 VPWR VGND sg13cmos5l_fill_2
XFILLER_27_598 VPWR VGND sg13cmos5l_decap_8
Xfanout30 _2660_/S _2650_/Y VPWR VGND sg13cmos5l_buf_1
XFILLER_30_708 VPWR VGND sg13cmos5l_fill_1
Xfanout52 _2363_/A hold607/X VPWR VGND sg13cmos5l_buf_1
Xfanout74 _2672_/A _2838_/B1 VPWR VGND sg13cmos5l_buf_1
XFILLER_22_270 VPWR VGND sg13cmos5l_fill_1
Xfanout63 _2810_/A1 fanout67/X VPWR VGND sg13cmos5l_buf_1
Xfanout41 _3410_/A _3303_/A VPWR VGND sg13cmos5l_buf_1
XFILLER_7_904 VPWR VGND sg13cmos5l_decap_8
XFILLER_10_432 VPWR VGND sg13cmos5l_decap_8
XFILLER_10_443 VPWR VGND sg13cmos5l_fill_2
XFILLER_11_977 VPWR VGND sg13cmos5l_decap_8
XFILLER_22_292 VPWR VGND sg13cmos5l_fill_2
XFILLER_6_469 VPWR VGND sg13cmos5l_decap_8
X_3548__335 _3548_/RESET_B VPWR VGND sg13cmos5l_tiehi
XFILLER_49_167 VPWR VGND sg13cmos5l_fill_1
XFILLER_37_329 VPWR VGND sg13cmos5l_decap_4
XFILLER_38_92 VPWR VGND sg13cmos5l_decap_8
XFILLER_46_874 VPWR VGND sg13cmos5l_decap_8
XFILLER_33_502 VPWR VGND sg13cmos5l_decap_8
XFILLER_45_395 VPWR VGND sg13cmos5l_decap_8
X_3730_ _3730_/Q _3731_/CLK _3730_/D _3730_/RESET_B VPWR VGND sg13cmos5l_dfrbpq_1
XFILLER_14_793 VPWR VGND sg13cmos5l_decap_8
X_1991_ _2277_/A _3803_/Q VPWR VGND sg13cmos5l_inv_1
XFILLER_9_252 VPWR VGND sg13cmos5l_decap_8
X_3661_ _3661_/Q _3722_/CLK _3661_/D _3661_/RESET_B VPWR VGND sg13cmos5l_dfrbpq_1
X_3592_ _3592_/Q clkload9/A _3592_/D _3592_/RESET_B VPWR VGND sg13cmos5l_dfrbpq_1
X_2612_ _3489_/D input9/X hold628/X _2617_/S VPWR VGND sg13cmos5l_mux2_1
Xclkload11 clkload11/Y _3806_/CLK VPWR VGND sg13cmos5l_inv_1
XFILLER_6_981 VPWR VGND sg13cmos5l_decap_8
X_2543_ _2543_/Y _2533_/Y _2536_/X _2542_/Y VPWR VGND sg13cmos5l_o21ai_1
XFILLER_47_1028 VPWR VGND sg13cmos5l_fill_1
XFILLER_47_1017 VPWR VGND sg13cmos5l_decap_8
X_2474_ _2530_/A _3784_/Q _2545_/B VPWR VGND sg13cmos5l_nand2_1
XFILLER_18_18 VPWR VGND sg13cmos5l_fill_2
XFILLER_37_874 VPWR VGND sg13cmos5l_fill_2
XFILLER_37_863 VPWR VGND sg13cmos5l_decap_8
X_3599__255 _3599_/RESET_B VPWR VGND sg13cmos5l_tiehi
XFILLER_24_502 VPWR VGND sg13cmos5l_decap_4
X_3026_ _3631_/D _3460_/A _3026_/B VPWR VGND sg13cmos5l_and2_1
XFILLER_24_546 VPWR VGND sg13cmos5l_decap_8
Xclkload5 clkload5/X clkload5/A VPWR VGND sg13cmos5l_buf_8
XFILLER_30_1010 VPWR VGND sg13cmos5l_decap_8
XFILLER_20_796 VPWR VGND sg13cmos5l_decap_8
XFILLER_1_7 VPWR VGND sg13cmos5l_decap_8
XFILLER_46_148 VPWR VGND sg13cmos5l_decap_8
XFILLER_46_159 VPWR VGND sg13cmos5l_decap_8
XFILLER_28_885 VPWR VGND sg13cmos5l_decap_8
XFILLER_43_899 VPWR VGND sg13cmos5l_decap_8
XFILLER_24_50 VPWR VGND sg13cmos5l_fill_1
XFILLER_10_262 VPWR VGND sg13cmos5l_decap_4
XFILLER_7_767 VPWR VGND sg13cmos5l_decap_4
XFILLER_6_233 VPWR VGND sg13cmos5l_decap_4
XFILLER_11_796 VPWR VGND sg13cmos5l_decap_8
XFILLER_40_71 VPWR VGND sg13cmos5l_decap_8
XFILLER_6_299 VPWR VGND sg13cmos5l_fill_2
XFILLER_6_288 VPWR VGND sg13cmos5l_decap_8
XFILLER_3_962 VPWR VGND sg13cmos5l_decap_8
XFILLER_34_7 VPWR VGND sg13cmos5l_fill_2
X_2190_ _2190_/Y _2184_/Y _2185_/X _2198_/B VPWR VGND sg13cmos5l_o21ai_1
XFILLER_1_21 VPWR VGND sg13cmos5l_decap_8
XFILLER_1_65 VPWR VGND sg13cmos5l_decap_8
XFILLER_46_660 VPWR VGND sg13cmos5l_fill_2
XFILLER_18_340 VPWR VGND sg13cmos5l_decap_8
XFILLER_46_682 VPWR VGND sg13cmos5l_decap_8
XFILLER_34_844 VPWR VGND sg13cmos5l_decap_8
XFILLER_33_365 VPWR VGND sg13cmos5l_fill_2
XFILLER_33_376 VPWR VGND sg13cmos5l_fill_2
X_1974_ _2466_/A _1974_/A VPWR VGND sg13cmos5l_inv_1
XFILLER_14_590 VPWR VGND sg13cmos5l_decap_8
X_3713_ _3713_/Q _3766_/CLK _3713_/D _3713_/RESET_B VPWR VGND sg13cmos5l_dfrbpq_1
X_3644_ _3644_/Q _3666_/CLK _3644_/D _3644_/RESET_B VPWR VGND sg13cmos5l_dfrbpq_1
X_3787__425 _3787_/RESET_B VPWR VGND sg13cmos5l_tiehi
XFILLER_20_19 VPWR VGND sg13cmos5l_decap_4
X_3575_ _3575_/Q clkload9/A _3575_/D _3575_/RESET_B VPWR VGND sg13cmos5l_dfrbpq_1
X_2526_ _2529_/B _2521_/B _2521_/C _2404_/Y VPWR VGND sg13cmos5l_a21oi_1
X_2457_ _3780_/D _2457_/A _2457_/B VPWR VGND sg13cmos5l_and2_1
XFILLER_29_17 VPWR VGND sg13cmos5l_decap_8
XFILLER_29_28 VPWR VGND sg13cmos5l_fill_2
X_2388_ _2388_/X _2388_/A _2388_/B VPWR VGND sg13cmos5l_xor2_1
XFILLER_45_16 VPWR VGND sg13cmos5l_decap_8
XFILLER_44_619 VPWR VGND sg13cmos5l_decap_8
X_3794__418 _3794_/RESET_B VPWR VGND sg13cmos5l_tiehi
XFILLER_25_811 VPWR VGND sg13cmos5l_fill_1
XFILLER_43_129 VPWR VGND sg13cmos5l_fill_1
X_3009_ _3009_/Y _3002_/Y _3006_/Y _3008_/Y VPWR VGND sg13cmos5l_o21ai_1
XFILLER_25_855 VPWR VGND sg13cmos5l_decap_8
X_3538__345 _3538_/RESET_B VPWR VGND sg13cmos5l_tiehi
XFILLER_25_899 VPWR VGND sg13cmos5l_fill_2
XFILLER_8_509 VPWR VGND sg13cmos5l_fill_2
X_3770__451 _3770_/RESET_B VPWR VGND sg13cmos5l_tiehi
XFILLER_4_726 VPWR VGND sg13cmos5l_decap_8
XFILLER_3_236 VPWR VGND sg13cmos5l_decap_8
XFILLER_0_965 VPWR VGND sg13cmos5l_decap_8
X_3545__338 _3545_/RESET_B VPWR VGND sg13cmos5l_tiehi
XFILLER_48_936 VPWR VGND sg13cmos5l_decap_8
XFILLER_47_479 VPWR VGND sg13cmos5l_decap_8
XFILLER_47_457 VPWR VGND sg13cmos5l_fill_2
XFILLER_19_94 VPWR VGND sg13cmos5l_fill_1
XFILLER_16_844 VPWR VGND sg13cmos5l_decap_8
XFILLER_16_866 VPWR VGND sg13cmos5l_decap_8
XFILLER_27_192 VPWR VGND sg13cmos5l_decap_8
XFILLER_30_302 VPWR VGND sg13cmos5l_decap_8
XFILLER_42_195 VPWR VGND sg13cmos5l_decap_8
XFILLER_30_346 VPWR VGND sg13cmos5l_decap_4
XFILLER_7_564 VPWR VGND sg13cmos5l_decap_8
Xhold509 _2576_/B _2575_/Y VPWR VGND sg13cmos5l_dlygate4sd3_1
X_3589__265 _3589_/RESET_B VPWR VGND sg13cmos5l_tiehi
XFILLER_7_597 VPWR VGND sg13cmos5l_decap_8
X_3360_ _3360_/X _3391_/B _3391_/C VPWR VGND sg13cmos5l_and2_1
X_2311_ _2311_/Y _2311_/A _2311_/B _2311_/C VPWR VGND sg13cmos5l_nand3_1
X_3291_ _3292_/B _3103_/B _3288_/A _3290_/Y VPWR VGND sg13cmos5l_o21ai_1
XFILLER_32_4 VPWR VGND sg13cmos5l_decap_8
XFILLER_38_402 VPWR VGND sg13cmos5l_fill_1
X_2242_ _2242_/Y _2466_/A _3716_/Q _3715_/Q _2195_/A _2241_/Y VPWR VGND sg13cmos5l_a221oi_1
X_2173_ _2181_/C _3737_/Q _3736_/Q _3738_/Q VPWR VGND sg13cmos5l_o21ai_1
X_3596__258 _3596_/RESET_B VPWR VGND sg13cmos5l_tiehi
X_3672__146 _3672_/RESET_B VPWR VGND sg13cmos5l_tiehi
XFILLER_21_335 VPWR VGND sg13cmos5l_fill_1
XFILLER_21_379 VPWR VGND sg13cmos5l_decap_8
X_1957_ _1957_/Y _1957_/A VPWR VGND sg13cmos5l_inv_1
X_3627_ _3627_/Q _3629_/CLK _3627_/D _3627_/RESET_B VPWR VGND sg13cmos5l_dfrbpq_1
Xoutput18 uo_out[4] _3552_/Q VPWR VGND sg13cmos5l_buf_1
X_3558_ _3558_/Q clkload2/A _3558_/D _3558_/RESET_B VPWR VGND sg13cmos5l_dfrbpq_1
X_2509_ _2534_/A _2198_/A _2493_/X _2507_/Y VPWR VGND sg13cmos5l_a21o_1
XFILLER_0_206 VPWR VGND sg13cmos5l_decap_8
X_3489_ _3489_/Q clkload7/A _3489_/D _3489_/RESET_B VPWR VGND sg13cmos5l_dfrbpq_1
XFILLER_45_917 VPWR VGND sg13cmos5l_decap_8
XFILLER_29_468 VPWR VGND sg13cmos5l_decap_8
XFILLER_29_479 VPWR VGND sg13cmos5l_fill_2
XFILLER_44_438 VPWR VGND sg13cmos5l_decap_8
XFILLER_38_991 VPWR VGND sg13cmos5l_decap_8
XFILLER_9_807 VPWR VGND sg13cmos5l_fill_1
XFILLER_13_869 VPWR VGND sg13cmos5l_decap_8
XFILLER_8_317 VPWR VGND sg13cmos5l_decap_8
XFILLER_21_891 VPWR VGND sg13cmos5l_decap_8
XFILLER_20_390 VPWR VGND sg13cmos5l_decap_4
XFILLER_0_762 VPWR VGND sg13cmos5l_decap_8
XFILLER_29_980 VPWR VGND sg13cmos5l_decap_8
XFILLER_46_81 VPWR VGND sg13cmos5l_fill_2
XFILLER_16_652 VPWR VGND sg13cmos5l_decap_8
XFILLER_44_994 VPWR VGND sg13cmos5l_decap_8
X_2860_ _2860_/Y _3610_/Q _3588_/Q _2860_/C VPWR VGND sg13cmos5l_nand3_1
X_2791_ _2791_/X _3541_/Q _3524_/Q _3507_/Q _3490_/Q _2819_/S0 _2810_/B1 VPWR VGND
+ sg13cmos5l_mux4_1
XFILLER_30_176 VPWR VGND sg13cmos5l_decap_8
XFILLER_7_64 VPWR VGND sg13cmos5l_decap_8
XFILLER_7_53 VPWR VGND sg13cmos5l_fill_1
XFILLER_11_1019 VPWR VGND sg13cmos5l_decap_8
XFILLER_8_884 VPWR VGND sg13cmos5l_decap_8
XFILLER_7_372 VPWR VGND sg13cmos5l_decap_8
X_3784__428 _3784_/RESET_B VPWR VGND sg13cmos5l_tiehi
X_3412_ _3702_/D _3401_/A _3408_/A _3411_/Y VPWR VGND sg13cmos5l_a21oi_1
Xheichips26_dna_sequencer_91 uio_oe[7] VPWR VGND sg13cmos5l_tielo
X_3343_ _3343_/Y _3690_/Q _3344_/A2 _3347_/A VPWR VGND sg13cmos5l_o21ai_1
X_3528__355 _3528_/RESET_B VPWR VGND sg13cmos5l_tiehi
X_3274_ _3294_/A _3646_/Q _3274_/B VPWR VGND sg13cmos5l_xnor2_1
XFILLER_38_221 VPWR VGND sg13cmos5l_decap_4
X_2225_ _2237_/S _2232_/B _2232_/C VPWR VGND sg13cmos5l_nand2_1
X_3760__461 _3760_/RESET_B VPWR VGND sg13cmos5l_tiehi
XFILLER_39_777 VPWR VGND sg13cmos5l_decap_8
XFILLER_39_799 VPWR VGND sg13cmos5l_fill_2
X_2156_ _2156_/X _2156_/A _2156_/B VPWR VGND sg13cmos5l_and2_1
XFILLER_42_909 VPWR VGND sg13cmos5l_decap_8
Xclkbuf_leaf_18_clk _3766_/CLK clkbuf_leaf_2_clk/A VPWR VGND sg13cmos5l_buf_8
X_2087_ _2152_/A _2087_/A _2087_/B VPWR VGND sg13cmos5l_nor2_1
XFILLER_35_972 VPWR VGND sg13cmos5l_decap_8
XFILLER_21_154 VPWR VGND sg13cmos5l_decap_8
X_2989_ _3055_/A _2871_/B _2981_/B _2988_/Y VPWR VGND sg13cmos5l_o21ai_1
X_3535__348 _3535_/RESET_B VPWR VGND sg13cmos5l_tiehi
XFILLER_21_187 VPWR VGND sg13cmos5l_decap_4
XFILLER_1_526 VPWR VGND sg13cmos5l_decap_8
XFILLER_1_537 VPWR VGND sg13cmos5l_fill_1
XFILLER_18_906 VPWR VGND sg13cmos5l_fill_1
XFILLER_18_939 VPWR VGND sg13cmos5l_decap_8
XFILLER_29_265 VPWR VGND sg13cmos5l_decap_8
XFILLER_26_961 VPWR VGND sg13cmos5l_decap_8
XFILLER_41_942 VPWR VGND sg13cmos5l_decap_8
XFILLER_40_452 VPWR VGND sg13cmos5l_decap_4
XFILLER_5_810 VPWR VGND sg13cmos5l_decap_8
XFILLER_4_320 VPWR VGND sg13cmos5l_fill_2
XFILLER_5_887 VPWR VGND sg13cmos5l_decap_8
XFILLER_4_364 VPWR VGND sg13cmos5l_fill_2
X_3586__268 _3586_/RESET_B VPWR VGND sg13cmos5l_tiehi
X_2010_ _3052_/B _3635_/Q VPWR VGND sg13cmos5l_inv_1
XFILLER_36_736 VPWR VGND sg13cmos5l_decap_8
XFILLER_36_758 VPWR VGND sg13cmos5l_fill_2
XFILLER_36_747 VPWR VGND sg13cmos5l_fill_2
XFILLER_24_909 VPWR VGND sg13cmos5l_decap_8
X_3773__129 _3773_/D VPWR VGND sg13cmos5l_tielo
XFILLER_17_983 VPWR VGND sg13cmos5l_decap_8
X_3558__315 _3558_/RESET_B VPWR VGND sg13cmos5l_tiehi
XFILLER_23_408 VPWR VGND sg13cmos5l_decap_4
XFILLER_44_791 VPWR VGND sg13cmos5l_decap_8
X_2912_ _2913_/B _2912_/A _2912_/B _2912_/C _2921_/A VPWR VGND sg13cmos5l_nand4_1
X_2843_ _2846_/C _2843_/A _2843_/B VPWR VGND sg13cmos5l_xnor2_1
X_2774_ _2774_/Y _2775_/B _2761_/Y hold693/X VPWR VGND sg13cmos5l_o21ai_1
X_3714__282 _3714_/RESET_B VPWR VGND sg13cmos5l_tiehi
Xclkbuf_leaf_7_clk _3574_/CLK clkbuf_leaf_9_clk/A VPWR VGND sg13cmos5l_buf_8
X_3326_ _3327_/B _3336_/B _3323_/Y _3336_/A VPWR VGND sg13cmos5l_o21ai_1
X_3257_ _3259_/B _2130_/Y _3251_/Y _3266_/S VPWR VGND sg13cmos5l_mux2_1
XFILLER_2_1028 VPWR VGND sg13cmos5l_fill_1
XFILLER_2_1017 VPWR VGND sg13cmos5l_decap_8
X_2208_ _2210_/B _3712_/Q _3711_/Q _3710_/Q _3709_/Q VPWR VGND sg13cmos5l_nor4_1
XFILLER_27_714 VPWR VGND sg13cmos5l_fill_1
X_3188_ _3664_/D _3188_/A _3190_/B VPWR VGND sg13cmos5l_nor2_1
X_2139_ _3419_/B _2096_/Y _2138_/B _2138_/Y VPWR VGND sg13cmos5l_o21ai_1
XFILLER_23_931 VPWR VGND sg13cmos5l_decap_8
XFILLER_23_942 VPWR VGND sg13cmos5l_decap_8
XFILLER_22_452 VPWR VGND sg13cmos5l_fill_1
XFILLER_2_835 VPWR VGND sg13cmos5l_decap_8
Xhold681 _3336_/B _3685_/Q VPWR VGND sg13cmos5l_dlygate4sd3_1
Xhold670 _2711_/A _3555_/Q VPWR VGND sg13cmos5l_dlygate4sd3_1
Xhold692 _2773_/A _3577_/Q VPWR VGND sg13cmos5l_dlygate4sd3_1
XFILLER_49_327 VPWR VGND sg13cmos5l_fill_2
XFILLER_18_703 VPWR VGND sg13cmos5l_decap_8
XFILLER_27_94 VPWR VGND sg13cmos5l_fill_2
XFILLER_32_216 VPWR VGND sg13cmos5l_decap_4
X_3518__365 _3518_/RESET_B VPWR VGND sg13cmos5l_tiehi
XFILLER_9_489 VPWR VGND sg13cmos5l_decap_8
X_2490_ _2490_/Y _2484_/Y _2488_/Y _2489_/Y VPWR VGND sg13cmos5l_o21ai_1
XFILLER_4_150 VPWR VGND sg13cmos5l_fill_1
X_3111_ _3192_/B _3111_/A _3111_/B _3111_/C VPWR VGND sg13cmos5l_or3_1
XFILLER_49_894 VPWR VGND sg13cmos5l_decap_8
X_3525__358 _3525_/RESET_B VPWR VGND sg13cmos5l_tiehi
X_3042_ _3042_/Y _3042_/A _3042_/B VPWR VGND sg13cmos5l_nor2_1
XFILLER_36_577 VPWR VGND sg13cmos5l_decap_8
XFILLER_17_780 VPWR VGND sg13cmos5l_decap_8
XFILLER_17_1025 VPWR VGND sg13cmos5l_decap_4
XFILLER_31_271 VPWR VGND sg13cmos5l_decap_8
XFILLER_20_945 VPWR VGND sg13cmos5l_decap_8
X_2826_ _2826_/Y _2826_/A1 _3498_/Q _2826_/B1 VPWR VGND sg13cmos5l_o21ai_1
XFILLER_9_990 VPWR VGND sg13cmos5l_decap_8
X_2757_ _3571_/D _2757_/A _2748_/Y VPWR VGND sg13cmos5l_nor2b_1
X_2688_ _3477_/B _2689_/B _2717_/B _2689_/A VPWR VGND sg13cmos5l_a21oi_1
X_3309_ _3319_/B _3305_/Y _3307_/Y _3308_/Y VPWR VGND sg13cmos5l_o21ai_1
XFILLER_27_544 VPWR VGND sg13cmos5l_fill_2
XFILLER_27_577 VPWR VGND sg13cmos5l_decap_8
Xfanout31 _2649_/S _2648_/S VPWR VGND sg13cmos5l_buf_1
XFILLER_11_901 VPWR VGND sg13cmos5l_decap_8
XFILLER_23_750 VPWR VGND sg13cmos5l_fill_2
Xfanout20 _3020_/A2 _3179_/A2 VPWR VGND sg13cmos5l_buf_1
Xfanout64 _2819_/S0 fanout67/X VPWR VGND sg13cmos5l_buf_1
Xfanout53 _2257_/B _2202_/A VPWR VGND sg13cmos5l_buf_1
XFILLER_11_912 VPWR VGND sg13cmos5l_decap_8
Xfanout42 _3352_/B _3236_/Y VPWR VGND sg13cmos5l_buf_1
XFILLER_23_783 VPWR VGND sg13cmos5l_fill_2
Xfanout75 _2755_/A _2838_/B1 VPWR VGND sg13cmos5l_buf_1
XFILLER_10_455 VPWR VGND sg13cmos5l_decap_4
XFILLER_13_63 VPWR VGND sg13cmos5l_decap_8
XFILLER_37_308 VPWR VGND sg13cmos5l_decap_4
XFILLER_46_853 VPWR VGND sg13cmos5l_decap_8
XFILLER_21_709 VPWR VGND sg13cmos5l_decap_8
X_1990_ _1990_/Y _1990_/A VPWR VGND sg13cmos5l_inv_1
X_3660_ _3660_/Q _3664_/CLK _3660_/D _3660_/RESET_B VPWR VGND sg13cmos5l_dfrbpq_1
X_3591_ _3591_/Q clkload9/A _3591_/D _3591_/RESET_B VPWR VGND sg13cmos5l_dfrbpq_1
Xclkload12 clkload12/Y _3728_/CLK VPWR VGND sg13cmos5l_inv_1
X_2611_ _3488_/D input8/X hold558/X _2617_/S VPWR VGND sg13cmos5l_mux2_1
XFILLER_6_960 VPWR VGND sg13cmos5l_decap_8
X_2542_ _2542_/Y _2544_/A _2560_/A VPWR VGND sg13cmos5l_nand2_1
X_2473_ _2473_/Y _3788_/Q _2545_/B VPWR VGND sg13cmos5l_nor2_1
X_3025_ _3630_/D _3025_/A _3025_/B VPWR VGND sg13cmos5l_and2_1
XFILLER_11_208 VPWR VGND sg13cmos5l_decap_4
Xclkload6 clkload6/Y clkload6/A VPWR VGND sg13cmos5l_inv_1
X_2809_ _2809_/X _3538_/Q _3521_/Q _3504_/Q _3487_/Q _2819_/S0 _2810_/B1 VPWR VGND
+ sg13cmos5l_mux4_1
X_3789_ _3789_/Q clkload4/A _3789_/D _3789_/RESET_B VPWR VGND sg13cmos5l_dfrbpq_1
XFILLER_47_628 VPWR VGND sg13cmos5l_decap_8
X_3508__375 _3508_/RESET_B VPWR VGND sg13cmos5l_tiehi
XFILLER_46_127 VPWR VGND sg13cmos5l_decap_8
XFILLER_43_812 VPWR VGND sg13cmos5l_decap_8
XFILLER_27_352 VPWR VGND sg13cmos5l_fill_1
XFILLER_28_864 VPWR VGND sg13cmos5l_fill_1
XFILLER_43_878 VPWR VGND sg13cmos5l_decap_8
XFILLER_11_720 VPWR VGND sg13cmos5l_decap_4
XFILLER_24_62 VPWR VGND sg13cmos5l_decap_8
XFILLER_10_241 VPWR VGND sg13cmos5l_decap_8
XFILLER_11_775 VPWR VGND sg13cmos5l_decap_8
X_3515__368 _3515_/RESET_B VPWR VGND sg13cmos5l_tiehi
XFILLER_7_746 VPWR VGND sg13cmos5l_decap_8
XFILLER_10_285 VPWR VGND sg13cmos5l_decap_8
XFILLER_10_296 VPWR VGND sg13cmos5l_fill_1
XFILLER_3_941 VPWR VGND sg13cmos5l_decap_8
XFILLER_2_440 VPWR VGND sg13cmos5l_decap_8
X_3806__209 _3806_/RESET_B VPWR VGND sg13cmos5l_tiehi
XFILLER_38_628 VPWR VGND sg13cmos5l_decap_8
XFILLER_1_44 VPWR VGND sg13cmos5l_decap_8
XFILLER_33_344 VPWR VGND sg13cmos5l_decap_8
XFILLER_21_517 VPWR VGND sg13cmos5l_fill_1
XFILLER_21_528 VPWR VGND sg13cmos5l_decap_8
X_1973_ _2195_/A _2465_/A VPWR VGND sg13cmos5l_inv_1
X_3712_ _3712_/Q _3712_/CLK _3712_/D _3712_/RESET_B VPWR VGND sg13cmos5l_dfrbpq_1
X_3643_ _3643_/Q _3698_/CLK _3643_/D _3643_/RESET_B VPWR VGND sg13cmos5l_dfrbpq_1
X_3574_ _3574_/Q _3574_/CLK _3574_/D _3574_/RESET_B VPWR VGND sg13cmos5l_dfrbpq_1
X_2525_ _2553_/A _2473_/Y _2481_/Y _2524_/X VPWR VGND sg13cmos5l_o21ai_1
X_2456_ _3778_/D hold652/X _2455_/Y _2558_/A VPWR VGND sg13cmos5l_a21oi_1
X_3566__299 _3566_/RESET_B VPWR VGND sg13cmos5l_tiehi
X_2387_ _2387_/Y _3772_/Q _2388_/B VPWR VGND sg13cmos5l_xnor2_1
XFILLER_28_105 VPWR VGND sg13cmos5l_decap_8
XFILLER_29_628 VPWR VGND sg13cmos5l_decap_8
X_3008_ _3008_/Y _3623_/Q _3002_/B _3007_/Y _3624_/Q VPWR VGND sg13cmos5l_a22oi_1
XFILLER_24_344 VPWR VGND sg13cmos5l_decap_8
XFILLER_25_878 VPWR VGND sg13cmos5l_decap_8
XFILLER_36_193 VPWR VGND sg13cmos5l_fill_2
X_3753__138 _3753_/RESET_B VPWR VGND sg13cmos5l_tiehi
X_3690__406 _3690_/RESET_B VPWR VGND sg13cmos5l_tiehi
XFILLER_3_215 VPWR VGND sg13cmos5l_decap_8
XFILLER_0_944 VPWR VGND sg13cmos5l_decap_8
XFILLER_48_915 VPWR VGND sg13cmos5l_decap_8
XFILLER_19_40 VPWR VGND sg13cmos5l_decap_8
XFILLER_34_119 VPWR VGND sg13cmos5l_decap_8
XFILLER_42_141 VPWR VGND sg13cmos5l_fill_2
XFILLER_37_1028 VPWR VGND sg13cmos5l_fill_1
XFILLER_37_1017 VPWR VGND sg13cmos5l_decap_8
XFILLER_35_94 VPWR VGND sg13cmos5l_decap_8
XFILLER_11_583 VPWR VGND sg13cmos5l_decap_4
XFILLER_7_543 VPWR VGND sg13cmos5l_decap_8
X_2310_ _2310_/Y _2229_/A _2229_/B _2194_/B VPWR VGND sg13cmos5l_o21ai_1
X_3290_ _3290_/Y _3288_/A _3288_/B _3289_/Y VPWR VGND sg13cmos5l_o21ai_1
X_2241_ _2241_/Y _3764_/Q _2251_/B _2000_/Y _3763_/Q VPWR VGND sg13cmos5l_a22oi_1
XFILLER_25_4 VPWR VGND sg13cmos5l_decap_8
XFILLER_39_959 VPWR VGND sg13cmos5l_decap_8
X_2172_ _2198_/A _2465_/A _3765_/Q VPWR VGND sg13cmos5l_xnor2_1
XFILLER_26_609 VPWR VGND sg13cmos5l_fill_2
XFILLER_19_683 VPWR VGND sg13cmos5l_decap_8
XFILLER_19_694 VPWR VGND sg13cmos5l_fill_1
XFILLER_25_108 VPWR VGND sg13cmos5l_decap_4
XFILLER_34_664 VPWR VGND sg13cmos5l_fill_1
XFILLER_21_314 VPWR VGND sg13cmos5l_decap_8
XFILLER_21_358 VPWR VGND sg13cmos5l_decap_8
X_1956_ _1956_/Y _1956_/A VPWR VGND sg13cmos5l_inv_1
X_3626_ _3626_/Q _3806_/CLK _3626_/D _3626_/RESET_B VPWR VGND sg13cmos5l_dfrbpq_1
Xoutput19 uo_out[5] _3553_/Q VPWR VGND sg13cmos5l_buf_1
X_3557_ _3557_/Q clkload1/A _3557_/D _3557_/RESET_B VPWR VGND sg13cmos5l_dfrbpq_1
X_2508_ _2508_/Y _2198_/A _2493_/X _2507_/Y VPWR VGND sg13cmos5l_a21oi_1
X_3488_ _3488_/Q clkload6/A _3488_/D _3488_/RESET_B VPWR VGND sg13cmos5l_dfrbpq_1
X_2439_ _2439_/Y _3794_/Q _2439_/B _3792_/Q VPWR VGND sg13cmos5l_nand3b_1
XFILLER_44_417 VPWR VGND sg13cmos5l_decap_8
XFILLER_38_970 VPWR VGND sg13cmos5l_decap_8
XFILLER_16_119 VPWR VGND sg13cmos5l_decap_8
X_3505__378 _3505_/RESET_B VPWR VGND sg13cmos5l_tiehi
XFILLER_13_826 VPWR VGND sg13cmos5l_decap_8
XFILLER_40_645 VPWR VGND sg13cmos5l_decap_8
XFILLER_13_848 VPWR VGND sg13cmos5l_decap_8
XFILLER_12_369 VPWR VGND sg13cmos5l_decap_8
XFILLER_21_52 VPWR VGND sg13cmos5l_decap_4
XFILLER_4_557 VPWR VGND sg13cmos5l_fill_1
XFILLER_4_546 VPWR VGND sg13cmos5l_decap_8
XFILLER_21_85 VPWR VGND sg13cmos5l_fill_1
XFILLER_0_741 VPWR VGND sg13cmos5l_decap_8
XFILLER_48_712 VPWR VGND sg13cmos5l_decap_8
XFILLER_36_907 VPWR VGND sg13cmos5l_decap_4
XFILLER_48_789 VPWR VGND sg13cmos5l_decap_8
XFILLER_44_973 VPWR VGND sg13cmos5l_decap_8
XFILLER_31_601 VPWR VGND sg13cmos5l_decap_4
X_3591__123 _3591_/D VPWR VGND sg13cmos5l_tielo
XFILLER_43_472 VPWR VGND sg13cmos5l_fill_1
XFILLER_30_122 VPWR VGND sg13cmos5l_fill_2
XFILLER_30_155 VPWR VGND sg13cmos5l_decap_8
X_2790_ _2790_/Y _2790_/A _3569_/Q VPWR VGND sg13cmos5l_nor2b_1
XFILLER_8_863 VPWR VGND sg13cmos5l_decap_8
XFILLER_7_32 VPWR VGND sg13cmos5l_fill_1
X_3411_ _3411_/Y _3401_/B _3408_/A _3236_/Y VPWR VGND sg13cmos5l_o21ai_1
Xheichips26_dna_sequencer_92 uio_out[0] VPWR VGND sg13cmos5l_tielo
X_3342_ _3689_/D _1931_/Y _3344_/A2 _3341_/Y VPWR VGND sg13cmos5l_a21oi_1
X_3273_ _3298_/A _3280_/B _3273_/B VPWR VGND sg13cmos5l_and2_1
XFILLER_39_712 VPWR VGND sg13cmos5l_decap_8
X_2224_ _2232_/C _2214_/Y _2222_/Y _2223_/Y VPWR VGND sg13cmos5l_o21ai_1
X_2155_ _2156_/B _2155_/A _2155_/B _2155_/C VPWR VGND sg13cmos5l_nand3_1
XFILLER_26_406 VPWR VGND sg13cmos5l_fill_2
XFILLER_26_417 VPWR VGND sg13cmos5l_fill_1
XFILLER_27_929 VPWR VGND sg13cmos5l_decap_8
X_2086_ _2087_/B _2076_/A _2088_/B _2085_/Y VPWR VGND sg13cmos5l_a21oi_1
XFILLER_34_450 VPWR VGND sg13cmos5l_fill_1
X_2988_ _2988_/Y _2981_/B _2982_/Y _2987_/Y VPWR VGND sg13cmos5l_o21ai_1
X_1939_ _3152_/B _1939_/A VPWR VGND sg13cmos5l_inv_1
X_3609_ _3609_/Q clkload9/A _3609_/D _3609_/RESET_B VPWR VGND sg13cmos5l_dfrbpq_1
XFILLER_27_1027 VPWR VGND sg13cmos5l_fill_2
XFILLER_45_726 VPWR VGND sg13cmos5l_decap_8
XFILLER_17_417 VPWR VGND sg13cmos5l_fill_2
XFILLER_26_940 VPWR VGND sg13cmos5l_decap_8
XFILLER_41_921 VPWR VGND sg13cmos5l_decap_8
XFILLER_16_74 VPWR VGND sg13cmos5l_fill_1
XFILLER_16_96 VPWR VGND sg13cmos5l_decap_8
XFILLER_40_431 VPWR VGND sg13cmos5l_decap_8
XFILLER_41_998 VPWR VGND sg13cmos5l_decap_8
XFILLER_40_486 VPWR VGND sg13cmos5l_decap_8
XFILLER_40_475 VPWR VGND sg13cmos5l_decap_8
XFILLER_9_627 VPWR VGND sg13cmos5l_decap_8
XFILLER_12_166 VPWR VGND sg13cmos5l_decap_4
XFILLER_32_73 VPWR VGND sg13cmos5l_decap_8
XFILLER_32_84 VPWR VGND sg13cmos5l_fill_1
XFILLER_5_866 VPWR VGND sg13cmos5l_decap_8
XFILLER_4_343 VPWR VGND sg13cmos5l_decap_8
XFILLER_0_593 VPWR VGND sg13cmos5l_decap_8
XFILLER_17_962 VPWR VGND sg13cmos5l_decap_8
XFILLER_35_269 VPWR VGND sg13cmos5l_decap_8
X_2911_ _3609_/D _2911_/A _2911_/B VPWR VGND sg13cmos5l_and2_1
X_3790__422 _3790_/RESET_B VPWR VGND sg13cmos5l_tiehi
XFILLER_16_494 VPWR VGND sg13cmos5l_fill_2
XFILLER_32_921 VPWR VGND sg13cmos5l_decap_4
X_2842_ _3583_/D _2843_/B _3584_/D VPWR VGND sg13cmos5l_and2_1
X_2773_ _2888_/A _2773_/A _3575_/Q VPWR VGND sg13cmos5l_nor2b_1
XFILLER_7_181 VPWR VGND sg13cmos5l_decap_8
X_3325_ _3327_/A _3318_/Y _3322_/Y _3323_/Y _3685_/Q _3324_/Y VPWR VGND sg13cmos5l_a221oi_1
X_3256_ _3266_/S _3261_/A _3261_/B VPWR VGND sg13cmos5l_and2_1
XFILLER_39_553 VPWR VGND sg13cmos5l_decap_4
X_2207_ _2217_/B _3711_/Q _3710_/Q _3709_/Q VPWR VGND sg13cmos5l_or3_1
X_3541__342 _3541_/RESET_B VPWR VGND sg13cmos5l_tiehi
XFILLER_39_586 VPWR VGND sg13cmos5l_decap_8
X_3187_ _3663_/D _3187_/A _3190_/B VPWR VGND sg13cmos5l_nor2_1
X_2138_ _2138_/Y _2138_/A _2138_/B VPWR VGND sg13cmos5l_nand2_1
XFILLER_42_707 VPWR VGND sg13cmos5l_decap_4
X_2069_ _2111_/B _2069_/A _2069_/B VPWR VGND sg13cmos5l_or2_1
XFILLER_23_998 VPWR VGND sg13cmos5l_decap_8
XFILLER_33_1020 VPWR VGND sg13cmos5l_decap_8
XFILLER_6_608 VPWR VGND sg13cmos5l_fill_1
XFILLER_10_637 VPWR VGND sg13cmos5l_decap_8
XFILLER_2_814 VPWR VGND sg13cmos5l_decap_8
Xhold671 _2457_/B _3751_/Q VPWR VGND sg13cmos5l_dlygate4sd3_1
Xhold660 _3452_/B _3687_/Q VPWR VGND sg13cmos5l_dlygate4sd3_1
XFILLER_49_306 VPWR VGND sg13cmos5l_decap_8
Xhold693 hold693/X _2888_/A VPWR VGND sg13cmos5l_dlygate4sd3_1
Xhold682 hold682/X _3336_/Y VPWR VGND sg13cmos5l_dlygate4sd3_1
XFILLER_45_523 VPWR VGND sg13cmos5l_decap_4
XFILLER_27_62 VPWR VGND sg13cmos5l_decap_8
X_3592__262 _3592_/RESET_B VPWR VGND sg13cmos5l_tiehi
XFILLER_43_72 VPWR VGND sg13cmos5l_decap_8
XFILLER_41_784 VPWR VGND sg13cmos5l_decap_8
XFILLER_41_762 VPWR VGND sg13cmos5l_decap_8
XFILLER_14_987 VPWR VGND sg13cmos5l_decap_8
XFILLER_5_674 VPWR VGND sg13cmos5l_decap_8
XFILLER_4_184 VPWR VGND sg13cmos5l_decap_8
X_3110_ _3192_/A _3111_/B _3111_/C _3109_/X VPWR VGND sg13cmos5l_o21ai_1
XFILLER_4_99 VPWR VGND sg13cmos5l_decap_8
XFILLER_49_873 VPWR VGND sg13cmos5l_decap_8
X_3041_ _3042_/B _3635_/Q _3052_/C VPWR VGND sg13cmos5l_xnor2_1
XFILLER_36_512 VPWR VGND sg13cmos5l_fill_1
XFILLER_23_206 VPWR VGND sg13cmos5l_decap_8
XFILLER_17_1004 VPWR VGND sg13cmos5l_decap_8
XFILLER_20_924 VPWR VGND sg13cmos5l_decap_8
X_2825_ _2825_/Y _3481_/Q _2826_/A1 VPWR VGND sg13cmos5l_nor2b_1
X_2756_ _3570_/D _2756_/A _2756_/B _2757_/A VPWR VGND sg13cmos5l_nor3_1
X_2687_ _3546_/D _2689_/B _2717_/B _2686_/Y VPWR VGND sg13cmos5l_a21oi_1
X_3308_ _3308_/Y _3703_/Q _3175_/A _3654_/Q _3465_/A VPWR VGND sg13cmos5l_a22oi_1
XFILLER_39_350 VPWR VGND sg13cmos5l_fill_2
X_3239_ _3240_/B _3674_/Q _3675_/Q _3672_/Q _3673_/Q VPWR VGND sg13cmos5l_nor4_1
XFILLER_27_534 VPWR VGND sg13cmos5l_fill_1
XFILLER_42_537 VPWR VGND sg13cmos5l_decap_8
XFILLER_14_217 VPWR VGND sg13cmos5l_decap_8
Xfanout21 _2907_/A2 _2293_/X VPWR VGND sg13cmos5l_buf_1
Xfanout54 _2465_/A hold805/X VPWR VGND sg13cmos5l_buf_1
Xfanout43 _3143_/A _3190_/B VPWR VGND sg13cmos5l_buf_1
Xfanout65 _2826_/A1 fanout67/X VPWR VGND sg13cmos5l_buf_1
Xfanout32 _2637_/S _2636_/S VPWR VGND sg13cmos5l_buf_1
Xfanout76 _3452_/A _3025_/A VPWR VGND sg13cmos5l_buf_1
X_3613__118 _3613_/D VPWR VGND sg13cmos5l_tielo
XFILLER_7_939 VPWR VGND sg13cmos5l_decap_8
XFILLER_6_427 VPWR VGND sg13cmos5l_fill_2
Xhold490 _1927_/A _3689_/Q VPWR VGND sg13cmos5l_dlygate4sd3_1
XFILLER_2_699 VPWR VGND sg13cmos5l_decap_8
XFILLER_2_677 VPWR VGND sg13cmos5l_decap_8
XFILLER_49_147 VPWR VGND sg13cmos5l_decap_8
X_3624__225 _3624_/RESET_B VPWR VGND sg13cmos5l_tiehi
XFILLER_38_72 VPWR VGND sg13cmos5l_decap_8
XFILLER_46_832 VPWR VGND sg13cmos5l_decap_8
XFILLER_18_567 VPWR VGND sg13cmos5l_fill_2
XFILLER_14_751 VPWR VGND sg13cmos5l_decap_8
XFILLER_9_232 VPWR VGND sg13cmos5l_decap_4
X_3590_ _3590_/Q clkload9/A _3590_/D _3590_/RESET_B VPWR VGND sg13cmos5l_dfrbpq_1
XFILLER_9_298 VPWR VGND sg13cmos5l_fill_2
Xclkload13 clkload13/X _3731_/CLK VPWR VGND sg13cmos5l_buf_8
X_2610_ _3487_/D input7/X hold555/X _2617_/S VPWR VGND sg13cmos5l_mux2_1
X_2541_ _2560_/A _2473_/Y _2481_/Y _2540_/Y VPWR VGND sg13cmos5l_o21ai_1
X_3531__352 _3531_/RESET_B VPWR VGND sg13cmos5l_tiehi
XFILLER_5_482 VPWR VGND sg13cmos5l_decap_8
X_2472_ _2482_/B _2470_/Y _2471_/Y _2469_/Y VPWR VGND sg13cmos5l_a21oi_1
XFILLER_49_681 VPWR VGND sg13cmos5l_decap_8
XFILLER_37_821 VPWR VGND sg13cmos5l_decap_4
X_3024_ _3024_/Y _1936_/Y _3179_/A2 _3023_/Y VPWR VGND sg13cmos5l_a21oi_1
XFILLER_37_854 VPWR VGND sg13cmos5l_decap_4
XFILLER_36_375 VPWR VGND sg13cmos5l_decap_8
XFILLER_36_386 VPWR VGND sg13cmos5l_fill_2
XFILLER_32_581 VPWR VGND sg13cmos5l_decap_8
Xclkload7 clkload7/Y clkload7/A VPWR VGND sg13cmos5l_inv_1
XFILLER_20_765 VPWR VGND sg13cmos5l_decap_4
X_3788_ _3788_/Q clkload3/A _3788_/D _3788_/RESET_B VPWR VGND sg13cmos5l_dfrbpq_1
X_2808_ _3579_/D _1943_/Y hold536/X _2807_/Y VPWR VGND sg13cmos5l_a21oi_1
XFILLER_4_909 VPWR VGND sg13cmos5l_decap_8
XFILLER_3_408 VPWR VGND sg13cmos5l_decap_8
X_2739_ _2739_/Y _2364_/A _2738_/Y _3801_/D VPWR VGND sg13cmos5l_a21oi_1
XFILLER_8_1024 VPWR VGND sg13cmos5l_decap_4
XFILLER_47_607 VPWR VGND sg13cmos5l_decap_8
X_3582__272 _3582_/RESET_B VPWR VGND sg13cmos5l_tiehi
XFILLER_28_843 VPWR VGND sg13cmos5l_decap_8
XFILLER_27_331 VPWR VGND sg13cmos5l_fill_1
XFILLER_15_526 VPWR VGND sg13cmos5l_decap_8
XFILLER_27_386 VPWR VGND sg13cmos5l_fill_2
XFILLER_42_323 VPWR VGND sg13cmos5l_decap_8
XFILLER_42_356 VPWR VGND sg13cmos5l_fill_2
XFILLER_11_710 VPWR VGND sg13cmos5l_fill_1
XFILLER_11_743 VPWR VGND sg13cmos5l_decap_4
XFILLER_7_725 VPWR VGND sg13cmos5l_decap_8
XFILLER_24_96 VPWR VGND sg13cmos5l_decap_8
XFILLER_6_213 VPWR VGND sg13cmos5l_fill_1
XFILLER_6_202 VPWR VGND sg13cmos5l_fill_2
XFILLER_6_257 VPWR VGND sg13cmos5l_decap_8
XFILLER_3_920 VPWR VGND sg13cmos5l_decap_8
XFILLER_3_997 VPWR VGND sg13cmos5l_decap_8
XFILLER_49_71 VPWR VGND sg13cmos5l_decap_8
XFILLER_38_607 VPWR VGND sg13cmos5l_decap_8
XFILLER_34_802 VPWR VGND sg13cmos5l_fill_1
X_3594__121 _3594_/D VPWR VGND sg13cmos5l_tielo
XFILLER_33_367 VPWR VGND sg13cmos5l_fill_1
X_1972_ _1972_/Y _1972_/A VPWR VGND sg13cmos5l_inv_1
XFILLER_33_389 VPWR VGND sg13cmos5l_decap_8
X_3711_ _3711_/Q _3766_/CLK _3711_/D _3711_/RESET_B VPWR VGND sg13cmos5l_dfrbpq_1
X_3642_ _3642_/Q _3666_/CLK _3642_/D _3642_/RESET_B VPWR VGND sg13cmos5l_dfrbpq_1
X_3573_ _3573_/Q _3574_/CLK _3573_/D _3573_/RESET_B VPWR VGND sg13cmos5l_dfrbpq_1
XFILLER_46_0 VPWR VGND sg13cmos5l_decap_4
X_2524_ _2524_/X _2524_/A _2524_/B VPWR VGND sg13cmos5l_xor2_1
X_2455_ _2455_/Y _2455_/A _2455_/B VPWR VGND sg13cmos5l_nand2_1
X_3683__436 _3683_/RESET_B VPWR VGND sg13cmos5l_tiehi
X_2386_ _2395_/B _3772_/Q _2386_/B VPWR VGND sg13cmos5l_nor2_1
XFILLER_29_607 VPWR VGND sg13cmos5l_decap_8
X_3007_ _3007_/Y _3190_/A _3639_/Q _2899_/A _2899_/B VPWR VGND sg13cmos5l_a22oi_1
XFILLER_24_312 VPWR VGND sg13cmos5l_decap_4
XFILLER_40_816 VPWR VGND sg13cmos5l_fill_2
XFILLER_10_21 VPWR VGND sg13cmos5l_decap_4
XFILLER_0_923 VPWR VGND sg13cmos5l_decap_8
XFILLER_10_98 VPWR VGND sg13cmos5l_decap_8
XFILLER_47_404 VPWR VGND sg13cmos5l_decap_4
XFILLER_19_128 VPWR VGND sg13cmos5l_decap_8
XFILLER_47_448 VPWR VGND sg13cmos5l_fill_1
XFILLER_19_85 VPWR VGND sg13cmos5l_decap_8
X_3521__362 _3521_/RESET_B VPWR VGND sg13cmos5l_tiehi
XFILLER_7_500 VPWR VGND sg13cmos5l_decap_8
XFILLER_30_359 VPWR VGND sg13cmos5l_decap_4
XFILLER_7_522 VPWR VGND sg13cmos5l_decap_8
X_2240_ _3744_/D _2361_/A _2347_/B VPWR VGND sg13cmos5l_nor2_1
XFILLER_3_794 VPWR VGND sg13cmos5l_decap_8
XFILLER_39_905 VPWR VGND sg13cmos5l_fill_1
XFILLER_39_938 VPWR VGND sg13cmos5l_decap_8
X_2171_ _2171_/Y _3740_/Q _2171_/B VPWR VGND sg13cmos5l_xnor2_1
XFILLER_18_4 VPWR VGND sg13cmos5l_decap_8
XFILLER_20_1022 VPWR VGND sg13cmos5l_decap_8
XFILLER_47_982 VPWR VGND sg13cmos5l_decap_8
XFILLER_19_662 VPWR VGND sg13cmos5l_decap_8
XFILLER_22_805 VPWR VGND sg13cmos5l_fill_1
XFILLER_15_890 VPWR VGND sg13cmos5l_decap_8
XFILLER_22_849 VPWR VGND sg13cmos5l_decap_8
XFILLER_33_175 VPWR VGND sg13cmos5l_decap_8
X_1955_ _1955_/Y _1955_/A VPWR VGND sg13cmos5l_inv_1
XFILLER_30_893 VPWR VGND sg13cmos5l_fill_1
X_3625_ _3625_/Q _3722_/CLK _3625_/D _3625_/RESET_B VPWR VGND sg13cmos5l_dfrbpq_1
X_3556_ _3556_/Q clkload2/A _3556_/D _3556_/RESET_B VPWR VGND sg13cmos5l_dfrbpq_1
X_2507_ _2507_/Y _2507_/A _2507_/B _2507_/C VPWR VGND sg13cmos5l_nor3_1
X_3487_ _3487_/Q clkload6/A _3487_/D _3487_/RESET_B VPWR VGND sg13cmos5l_dfrbpq_1
X_2438_ _2438_/X _3776_/Q _2438_/B VPWR VGND sg13cmos5l_or2_1
XFILLER_5_1027 VPWR VGND sg13cmos5l_fill_2
X_2369_ _2376_/A _3770_/Q _3768_/Q _3769_/Q VPWR VGND sg13cmos5l_or3_1
XFILLER_13_805 VPWR VGND sg13cmos5l_decap_8
XFILLER_24_153 VPWR VGND sg13cmos5l_decap_8
XFILLER_12_304 VPWR VGND sg13cmos5l_decap_8
XFILLER_40_679 VPWR VGND sg13cmos5l_decap_8
XFILLER_21_20 VPWR VGND sg13cmos5l_decap_8
XFILLER_4_525 VPWR VGND sg13cmos5l_decap_8
XFILLER_21_75 VPWR VGND sg13cmos5l_fill_1
XFILLER_43_1011 VPWR VGND sg13cmos5l_decap_8
XFILLER_0_797 VPWR VGND sg13cmos5l_decap_8
XFILLER_48_768 VPWR VGND sg13cmos5l_decap_8
XFILLER_47_278 VPWR VGND sg13cmos5l_fill_1
XFILLER_35_429 VPWR VGND sg13cmos5l_decap_8
XFILLER_46_83 VPWR VGND sg13cmos5l_fill_1
XFILLER_44_952 VPWR VGND sg13cmos5l_decap_8
XFILLER_16_621 VPWR VGND sg13cmos5l_decap_8
XFILLER_28_470 VPWR VGND sg13cmos5l_fill_2
XFILLER_43_451 VPWR VGND sg13cmos5l_fill_1
XFILLER_15_120 VPWR VGND sg13cmos5l_decap_8
XFILLER_15_142 VPWR VGND sg13cmos5l_decap_8
XFILLER_15_153 VPWR VGND sg13cmos5l_fill_2
XFILLER_16_687 VPWR VGND sg13cmos5l_decap_8
XFILLER_30_101 VPWR VGND sg13cmos5l_decap_8
XFILLER_12_882 VPWR VGND sg13cmos5l_decap_8
XFILLER_8_842 VPWR VGND sg13cmos5l_decap_8
XFILLER_7_22 VPWR VGND sg13cmos5l_fill_2
X_3410_ _3701_/D _3410_/A _3410_/B _3410_/C VPWR VGND sg13cmos5l_nor3_1
Xheichips26_dna_sequencer_93 uio_out[1] VPWR VGND sg13cmos5l_tielo
X_3341_ _3341_/Y _1927_/A _3344_/A2 _3186_/A VPWR VGND sg13cmos5l_o21ai_1
X_3272_ _3273_/B _3646_/Q _3647_/Q _3648_/Q VPWR VGND sg13cmos5l_o21ai_1
X_2223_ _2223_/Y _2228_/B _2210_/X _2214_/B _2214_/A VPWR VGND sg13cmos5l_a22oi_1
X_2154_ _2154_/X _2154_/A _2154_/B VPWR VGND sg13cmos5l_or2_1
XFILLER_38_278 VPWR VGND sg13cmos5l_fill_1
X_2085_ _2085_/Y hold821/X _2151_/B _2084_/Y VPWR VGND sg13cmos5l_a21oi_1
X_2987_ _2987_/Y _2987_/A _2974_/Y VPWR VGND sg13cmos5l_nor2b_1
X_1938_ _1938_/Y _1938_/A VPWR VGND sg13cmos5l_inv_1
Xhold820 _3274_/B _3647_/Q VPWR VGND sg13cmos5l_dlygate4sd3_1
X_3608_ _3608_/Q clkload9/A _3608_/D _3608_/RESET_B VPWR VGND sg13cmos5l_dfrbpq_1
XFILLER_27_1006 VPWR VGND sg13cmos5l_decap_8
X_3511__372 _3511_/RESET_B VPWR VGND sg13cmos5l_tiehi
X_3539_ _3539_/Q clkload6/A _3539_/D _3539_/RESET_B VPWR VGND sg13cmos5l_dfrbpq_1
XFILLER_45_705 VPWR VGND sg13cmos5l_decap_8
XFILLER_17_407 VPWR VGND sg13cmos5l_fill_1
XFILLER_16_20 VPWR VGND sg13cmos5l_decap_8
XFILLER_41_900 VPWR VGND sg13cmos5l_decap_8
X_3655__110 _3655_/D VPWR VGND sg13cmos5l_tielo
XFILLER_26_996 VPWR VGND sg13cmos5l_decap_8
XFILLER_41_977 VPWR VGND sg13cmos5l_decap_8
XFILLER_12_123 VPWR VGND sg13cmos5l_decap_8
XFILLER_12_134 VPWR VGND sg13cmos5l_fill_1
XFILLER_5_845 VPWR VGND sg13cmos5l_decap_8
XFILLER_4_322 VPWR VGND sg13cmos5l_fill_1
X_3783__430 _3783_/RESET_B VPWR VGND sg13cmos5l_tiehi
XFILLER_0_561 VPWR VGND sg13cmos5l_decap_8
XFILLER_35_215 VPWR VGND sg13cmos5l_decap_8
XFILLER_16_440 VPWR VGND sg13cmos5l_decap_8
X_2910_ _3606_/D _3025_/A _2919_/B VPWR VGND sg13cmos5l_and2_1
XFILLER_31_443 VPWR VGND sg13cmos5l_decap_4
X_2841_ _3582_/D _2844_/B _3584_/D VPWR VGND sg13cmos5l_and2_1
XFILLER_32_988 VPWR VGND sg13cmos5l_decap_8
X_2772_ _3573_/D _2772_/A _2772_/B VPWR VGND sg13cmos5l_nor2_1
XFILLER_12_690 VPWR VGND sg13cmos5l_decap_8
XFILLER_8_672 VPWR VGND sg13cmos5l_fill_1
XFILLER_8_661 VPWR VGND sg13cmos5l_decap_8
XFILLER_7_171 VPWR VGND sg13cmos5l_fill_1
X_3324_ _3324_/Y _3324_/A _3333_/A VPWR VGND sg13cmos5l_nor2_1
X_3255_ _3261_/B _3247_/Y _3250_/Y _3254_/Y VPWR VGND sg13cmos5l_o21ai_1
X_2206_ _3739_/D _2361_/A _2347_/A VPWR VGND sg13cmos5l_nor2_1
X_3186_ _3662_/D _3186_/A _3203_/B VPWR VGND sg13cmos5l_and2_1
X_2137_ _2137_/Y _3418_/B _2137_/B _2137_/C VPWR VGND sg13cmos5l_nand3_1
X_2068_ _2069_/B _3708_/Q _2068_/B VPWR VGND sg13cmos5l_xor2_1
XFILLER_22_443 VPWR VGND sg13cmos5l_decap_8
X_3691__332 _3691_/RESET_B VPWR VGND sg13cmos5l_tiehi
XFILLER_34_281 VPWR VGND sg13cmos5l_decap_8
XFILLER_23_977 VPWR VGND sg13cmos5l_decap_8
Xhold672 _1964_/A _3613_/Q VPWR VGND sg13cmos5l_dlygate4sd3_1
Xhold650 _3783_/D _2463_/Y VPWR VGND sg13cmos5l_dlygate4sd3_1
Xhold661 _3348_/A _3667_/Q VPWR VGND sg13cmos5l_dlygate4sd3_1
Xhold683 _3685_/D _3337_/Y VPWR VGND sg13cmos5l_dlygate4sd3_1
Xhold694 hold694/X _3683_/Q VPWR VGND sg13cmos5l_dlygate4sd3_1
X_3726__177 _3726_/RESET_B VPWR VGND sg13cmos5l_tiehi
XFILLER_40_1014 VPWR VGND sg13cmos5l_decap_8
XFILLER_45_502 VPWR VGND sg13cmos5l_decap_8
XFILLER_45_546 VPWR VGND sg13cmos5l_decap_8
XFILLER_17_226 VPWR VGND sg13cmos5l_decap_8
XFILLER_18_738 VPWR VGND sg13cmos5l_decap_8
XFILLER_18_749 VPWR VGND sg13cmos5l_fill_1
XFILLER_45_579 VPWR VGND sg13cmos5l_decap_8
XFILLER_27_96 VPWR VGND sg13cmos5l_fill_1
XFILLER_14_922 VPWR VGND sg13cmos5l_fill_2
XFILLER_26_771 VPWR VGND sg13cmos5l_decap_8
XFILLER_14_966 VPWR VGND sg13cmos5l_decap_8
XFILLER_9_425 VPWR VGND sg13cmos5l_decap_8
XFILLER_9_436 VPWR VGND sg13cmos5l_fill_2
XFILLER_5_620 VPWR VGND sg13cmos5l_decap_4
XFILLER_5_653 VPWR VGND sg13cmos5l_fill_2
XFILLER_5_642 VPWR VGND sg13cmos5l_decap_8
XFILLER_4_141 VPWR VGND sg13cmos5l_decap_8
XFILLER_5_686 VPWR VGND sg13cmos5l_decap_4
XFILLER_4_12 VPWR VGND sg13cmos5l_fill_2
XFILLER_4_67 VPWR VGND sg13cmos5l_fill_1
XFILLER_49_852 VPWR VGND sg13cmos5l_decap_8
XFILLER_1_892 VPWR VGND sg13cmos5l_decap_8
X_3040_ _3040_/Y _3635_/Q _3052_/C VPWR VGND sg13cmos5l_nand2_1
XFILLER_36_524 VPWR VGND sg13cmos5l_fill_2
XFILLER_36_557 VPWR VGND sg13cmos5l_fill_1
X_3501__382 _3501_/RESET_B VPWR VGND sg13cmos5l_tiehi
XFILLER_16_292 VPWR VGND sg13cmos5l_decap_8
X_2824_ _2824_/Y _2832_/S0 _3532_/Q _2823_/Y VPWR VGND sg13cmos5l_o21ai_1
X_2755_ _2757_/A _2755_/A _2755_/B VPWR VGND sg13cmos5l_nand2_1
X_2686_ _2686_/Y _2689_/B _2717_/B _2672_/A VPWR VGND sg13cmos5l_o21ai_1
X_3307_ _3307_/Y _3465_/A _3654_/Q _3306_/Y VPWR VGND sg13cmos5l_o21ai_1
X_3238_ _3249_/B _3674_/Q _3672_/Q _3673_/Q VPWR VGND sg13cmos5l_or3_1
XFILLER_39_384 VPWR VGND sg13cmos5l_fill_2
X_3169_ _3169_/Y _2009_/A _3168_/Y _3108_/A VPWR VGND sg13cmos5l_o21ai_1
XFILLER_27_513 VPWR VGND sg13cmos5l_fill_1
XFILLER_15_719 VPWR VGND sg13cmos5l_decap_8
XFILLER_27_557 VPWR VGND sg13cmos5l_decap_8
Xfanout22 _3179_/A2 _2293_/X VPWR VGND sg13cmos5l_buf_1
Xfanout55 _3463_/A _2108_/A VPWR VGND sg13cmos5l_buf_1
XFILLER_23_752 VPWR VGND sg13cmos5l_fill_1
XFILLER_23_763 VPWR VGND sg13cmos5l_fill_2
Xfanout33 _2617_/S _2616_/S VPWR VGND sg13cmos5l_buf_1
Xfanout44 _3190_/B _3076_/Y VPWR VGND sg13cmos5l_buf_1
Xfanout66 _2832_/S0 fanout67/X VPWR VGND sg13cmos5l_buf_1
XFILLER_10_413 VPWR VGND sg13cmos5l_fill_1
Xfanout77 _3459_/A _3025_/A VPWR VGND sg13cmos5l_buf_1
XFILLER_7_918 VPWR VGND sg13cmos5l_decap_8
XFILLER_2_601 VPWR VGND sg13cmos5l_decap_8
XFILLER_2_645 VPWR VGND sg13cmos5l_decap_4
Xhold480 _2919_/B _3584_/Q VPWR VGND sg13cmos5l_dlygate4sd3_1
XFILLER_1_166 VPWR VGND sg13cmos5l_decap_4
Xhold491 _3721_/D _3456_/Y VPWR VGND sg13cmos5l_dlygate4sd3_1
XFILLER_49_126 VPWR VGND sg13cmos5l_decap_4
XFILLER_46_811 VPWR VGND sg13cmos5l_decap_8
XFILLER_18_513 VPWR VGND sg13cmos5l_decap_4
XFILLER_45_332 VPWR VGND sg13cmos5l_decap_8
XFILLER_46_888 VPWR VGND sg13cmos5l_decap_8
XFILLER_33_516 VPWR VGND sg13cmos5l_decap_8
XFILLER_9_211 VPWR VGND sg13cmos5l_decap_8
Xclkload14 clkload14/X _3712_/CLK VPWR VGND sg13cmos5l_buf_8
XFILLER_10_980 VPWR VGND sg13cmos5l_decap_8
X_2540_ _2540_/Y _2540_/A _2540_/B VPWR VGND sg13cmos5l_xnor2_1
XFILLER_6_995 VPWR VGND sg13cmos5l_decap_8
X_2471_ _2471_/Y _3781_/Q _3755_/Q VPWR VGND sg13cmos5l_xnor2_1
X_3668__164 _3668_/RESET_B VPWR VGND sg13cmos5l_tiehi
XFILLER_37_833 VPWR VGND sg13cmos5l_decap_8
X_3023_ _3023_/Y _3629_/Q _3179_/A2 _3025_/A VPWR VGND sg13cmos5l_o21ai_1
XFILLER_36_332 VPWR VGND sg13cmos5l_decap_4
XFILLER_20_733 VPWR VGND sg13cmos5l_fill_1
Xclkload8 clkload8/Y clkload8/A VPWR VGND sg13cmos5l_inv_2
X_3787_ _3787_/Q clkload3/A _3787_/D _3787_/RESET_B VPWR VGND sg13cmos5l_dfrbpq_1
X_2807_ _2807_/Y _2835_/A _2844_/B _2755_/A VPWR VGND sg13cmos5l_o21ai_1
XFILLER_30_1024 VPWR VGND sg13cmos5l_decap_4
X_2738_ _2738_/Y _2698_/B _2738_/B VPWR VGND sg13cmos5l_nand2b_1
X_2669_ _3534_/D input11/X hold553/X _2671_/S VPWR VGND sg13cmos5l_mux2_1
XFILLER_8_1003 VPWR VGND sg13cmos5l_decap_8
XFILLER_28_822 VPWR VGND sg13cmos5l_decap_8
XFILLER_27_343 VPWR VGND sg13cmos5l_decap_8
XFILLER_42_302 VPWR VGND sg13cmos5l_decap_4
XFILLER_15_505 VPWR VGND sg13cmos5l_decap_8
XFILLER_27_365 VPWR VGND sg13cmos5l_decap_8
XFILLER_28_899 VPWR VGND sg13cmos5l_decap_8
XFILLER_30_508 VPWR VGND sg13cmos5l_fill_1
XFILLER_40_85 VPWR VGND sg13cmos5l_fill_2
XFILLER_3_976 VPWR VGND sg13cmos5l_decap_8
XFILLER_2_475 VPWR VGND sg13cmos5l_decap_8
XFILLER_49_50 VPWR VGND sg13cmos5l_decap_8
XFILLER_37_129 VPWR VGND sg13cmos5l_decap_8
XFILLER_1_35 VPWR VGND sg13cmos5l_decap_4
XFILLER_1_79 VPWR VGND sg13cmos5l_decap_8
XFILLER_19_866 VPWR VGND sg13cmos5l_decap_8
XFILLER_18_365 VPWR VGND sg13cmos5l_decap_8
XFILLER_19_888 VPWR VGND sg13cmos5l_decap_8
XFILLER_46_696 VPWR VGND sg13cmos5l_fill_2
XFILLER_33_313 VPWR VGND sg13cmos5l_fill_2
XFILLER_34_858 VPWR VGND sg13cmos5l_decap_4
XFILLER_34_869 VPWR VGND sg13cmos5l_decap_8
X_3710_ _3710_/Q _3712_/CLK _3710_/D _3710_/RESET_B VPWR VGND sg13cmos5l_dfrbpq_1
X_1971_ _3437_/B _1971_/A VPWR VGND sg13cmos5l_inv_1
XFILLER_14_1008 VPWR VGND sg13cmos5l_decap_8
X_3641_ _3641_/Q _3666_/CLK _3641_/D _3641_/RESET_B VPWR VGND sg13cmos5l_dfrbpq_1
X_3572_ _3572_/Q _3574_/CLK _3572_/D _3572_/RESET_B VPWR VGND sg13cmos5l_dfrbpq_1
X_2523_ _2524_/B _3784_/Q _2482_/B _2469_/Y VPWR VGND sg13cmos5l_a21oi_1
XFILLER_5_280 VPWR VGND sg13cmos5l_fill_1
X_2454_ _2454_/Y _2442_/A _2451_/S _2453_/Y VPWR VGND sg13cmos5l_a21oi_1
X_2385_ _2393_/A _3793_/Q _2385_/B VPWR VGND sg13cmos5l_xor2_1
Xinput1 input1/X rst_n VPWR VGND sg13cmos5l_buf_1
XFILLER_28_129 VPWR VGND sg13cmos5l_decap_8
X_3006_ _3006_/Y _3006_/A _3006_/B VPWR VGND sg13cmos5l_nand2_1
XFILLER_36_151 VPWR VGND sg13cmos5l_fill_1
XFILLER_25_869 VPWR VGND sg13cmos5l_decap_4
XFILLER_4_707 VPWR VGND sg13cmos5l_decap_8
XFILLER_0_902 VPWR VGND sg13cmos5l_decap_8
XFILLER_10_77 VPWR VGND sg13cmos5l_decap_4
XFILLER_0_979 VPWR VGND sg13cmos5l_decap_8
XFILLER_19_64 VPWR VGND sg13cmos5l_decap_8
XFILLER_15_302 VPWR VGND sg13cmos5l_decap_8
XFILLER_43_622 VPWR VGND sg13cmos5l_decap_8
XFILLER_43_666 VPWR VGND sg13cmos5l_fill_1
XFILLER_42_143 VPWR VGND sg13cmos5l_fill_1
XFILLER_31_806 VPWR VGND sg13cmos5l_fill_2
XFILLER_35_74 VPWR VGND sg13cmos5l_decap_8
XFILLER_24_891 VPWR VGND sg13cmos5l_decap_8
XFILLER_30_316 VPWR VGND sg13cmos5l_decap_4
XFILLER_30_327 VPWR VGND sg13cmos5l_fill_1
XFILLER_11_563 VPWR VGND sg13cmos5l_decap_8
XFILLER_7_578 VPWR VGND sg13cmos5l_fill_2
XFILLER_3_773 VPWR VGND sg13cmos5l_decap_8
XFILLER_2_250 VPWR VGND sg13cmos5l_fill_1
X_3665__167 _3665_/RESET_B VPWR VGND sg13cmos5l_tiehi
XFILLER_2_283 VPWR VGND sg13cmos5l_decap_4
XFILLER_39_917 VPWR VGND sg13cmos5l_decap_8
XFILLER_2_294 VPWR VGND sg13cmos5l_decap_8
X_2170_ _2170_/X _3740_/Q _2171_/B VPWR VGND sg13cmos5l_xor2_1
XFILLER_19_630 VPWR VGND sg13cmos5l_fill_2
XFILLER_20_1001 VPWR VGND sg13cmos5l_decap_8
XFILLER_47_961 VPWR VGND sg13cmos5l_decap_8
XFILLER_18_140 VPWR VGND sg13cmos5l_decap_4
XFILLER_34_600 VPWR VGND sg13cmos5l_decap_8
XFILLER_46_493 VPWR VGND sg13cmos5l_decap_8
XFILLER_34_622 VPWR VGND sg13cmos5l_decap_8
XFILLER_34_633 VPWR VGND sg13cmos5l_fill_2
X_1954_ _1954_/Y _2027_/B VPWR VGND sg13cmos5l_inv_1
X_3752__140 _3752_/RESET_B VPWR VGND sg13cmos5l_tiehi
XFILLER_30_872 VPWR VGND sg13cmos5l_decap_8
X_3624_ _3624_/Q _3722_/CLK _3624_/D _3624_/RESET_B VPWR VGND sg13cmos5l_dfrbpq_1
X_3555_ _3555_/Q clkload2/A _3555_/D _3555_/RESET_B VPWR VGND sg13cmos5l_dfrbpq_1
X_2506_ _2507_/C _2511_/C _2505_/Y VPWR VGND sg13cmos5l_nor2b_1
X_3486_ _3486_/Q clkload6/A _3486_/D _3486_/RESET_B VPWR VGND sg13cmos5l_dfrbpq_1
X_2437_ _2437_/Y _3775_/Q _2430_/B _2438_/B _3776_/Q _2434_/Y VPWR VGND sg13cmos5l_a221oi_1
XFILLER_5_1006 VPWR VGND sg13cmos5l_decap_8
X_2368_ _2379_/A _3768_/Q _3769_/Q VPWR VGND sg13cmos5l_or2_1
X_2299_ _2299_/Y _3754_/Q _3458_/A2 _3461_/A VPWR VGND sg13cmos5l_o21ai_1
XFILLER_24_110 VPWR VGND sg13cmos5l_decap_8
XFILLER_40_625 VPWR VGND sg13cmos5l_fill_2
XFILLER_4_504 VPWR VGND sg13cmos5l_decap_8
XFILLER_0_776 VPWR VGND sg13cmos5l_decap_8
XFILLER_48_747 VPWR VGND sg13cmos5l_decap_8
XFILLER_47_235 VPWR VGND sg13cmos5l_decap_8
XFILLER_47_257 VPWR VGND sg13cmos5l_decap_8
XFILLER_44_931 VPWR VGND sg13cmos5l_decap_8
XFILLER_29_994 VPWR VGND sg13cmos5l_decap_8
XFILLER_43_430 VPWR VGND sg13cmos5l_decap_8
XFILLER_16_666 VPWR VGND sg13cmos5l_decap_8
XFILLER_43_463 VPWR VGND sg13cmos5l_decap_8
XFILLER_15_187 VPWR VGND sg13cmos5l_decap_8
XFILLER_30_124 VPWR VGND sg13cmos5l_fill_1
XFILLER_12_861 VPWR VGND sg13cmos5l_decap_8
XFILLER_11_360 VPWR VGND sg13cmos5l_decap_8
XFILLER_8_898 VPWR VGND sg13cmos5l_decap_8
XFILLER_7_353 VPWR VGND sg13cmos5l_fill_1
XFILLER_7_386 VPWR VGND sg13cmos5l_decap_8
X_3340_ _3688_/D _1932_/Y _3454_/A2 _3339_/Y VPWR VGND sg13cmos5l_a21oi_1
Xheichips26_dna_sequencer_94 uio_out[2] VPWR VGND sg13cmos5l_tielo
X_3271_ _3280_/B _3648_/Q _3646_/Q _3647_/Q VPWR VGND sg13cmos5l_or3_1
XFILLER_3_592 VPWR VGND sg13cmos5l_decap_8
XFILLER_30_4 VPWR VGND sg13cmos5l_fill_2
X_2222_ _2222_/Y _2217_/X _2221_/Y _2216_/X VPWR VGND sg13cmos5l_o21ai_1
X_2153_ _2154_/B _3417_/B _3413_/B _2158_/S VPWR VGND sg13cmos5l_mux2_1
XFILLER_26_408 VPWR VGND sg13cmos5l_fill_1
X_2084_ _2084_/Y _2082_/A _2156_/A _2083_/Y VPWR VGND sg13cmos5l_a21oi_1
XFILLER_34_441 VPWR VGND sg13cmos5l_decap_8
XFILLER_21_102 VPWR VGND sg13cmos5l_fill_2
XFILLER_22_614 VPWR VGND sg13cmos5l_decap_4
XFILLER_34_474 VPWR VGND sg13cmos5l_decap_8
XFILLER_35_986 VPWR VGND sg13cmos5l_decap_8
XFILLER_21_135 VPWR VGND sg13cmos5l_fill_2
XFILLER_22_658 VPWR VGND sg13cmos5l_fill_2
X_2986_ _3618_/D _3072_/A _2986_/B VPWR VGND sg13cmos5l_nor2_1
X_3689__410 _3689_/RESET_B VPWR VGND sg13cmos5l_tiehi
X_1937_ _1937_/Y _1937_/A VPWR VGND sg13cmos5l_inv_1
X_3607_ _3607_/Q clkload9/A _3607_/D _3607_/RESET_B VPWR VGND sg13cmos5l_dfrbpq_1
Xhold810 _2322_/A _3762_/Q VPWR VGND sg13cmos5l_dlygate4sd3_1
Xhold821 hold821/X _3729_/Q VPWR VGND sg13cmos5l_dlygate4sd3_1
X_3538_ _3538_/Q clkload7/A _3538_/D _3538_/RESET_B VPWR VGND sg13cmos5l_dfrbpq_1
X_3469_ _3471_/B _3469_/A _2154_/B VPWR VGND sg13cmos5l_nor2b_1
XFILLER_29_279 VPWR VGND sg13cmos5l_fill_1
XFILLER_26_975 VPWR VGND sg13cmos5l_decap_8
X_3579__278 _3579_/RESET_B VPWR VGND sg13cmos5l_tiehi
XFILLER_40_411 VPWR VGND sg13cmos5l_fill_1
XFILLER_16_54 VPWR VGND sg13cmos5l_fill_1
XFILLER_41_956 VPWR VGND sg13cmos5l_decap_8
XFILLER_8_117 VPWR VGND sg13cmos5l_decap_8
XFILLER_32_31 VPWR VGND sg13cmos5l_fill_2
XFILLER_5_824 VPWR VGND sg13cmos5l_decap_8
XFILLER_32_97 VPWR VGND sg13cmos5l_fill_1
XFILLER_10_1022 VPWR VGND sg13cmos5l_decap_8
XFILLER_4_378 VPWR VGND sg13cmos5l_decap_8
XFILLER_48_555 VPWR VGND sg13cmos5l_decap_8
XFILLER_44_772 VPWR VGND sg13cmos5l_fill_1
XFILLER_17_997 VPWR VGND sg13cmos5l_decap_8
XFILLER_31_400 VPWR VGND sg13cmos5l_decap_4
X_2840_ _3584_/D _3452_/A _2846_/B VPWR VGND sg13cmos5l_and2_1
XFILLER_32_967 VPWR VGND sg13cmos5l_decap_8
X_2771_ _2771_/Y _2771_/A _2771_/B VPWR VGND sg13cmos5l_nor2_1
XFILLER_7_150 VPWR VGND sg13cmos5l_decap_8
X_3323_ _3323_/Y _3702_/Q _3466_/A _3175_/A _3654_/Q VPWR VGND sg13cmos5l_a22oi_1
X_3254_ _3254_/Y _3252_/A _3265_/A _3248_/Y _2056_/A VPWR VGND sg13cmos5l_a22oi_1
X_2205_ _2347_/A _2512_/A _2205_/B VPWR VGND sg13cmos5l_nor2_1
X_3185_ _3661_/D _3460_/A _3185_/B VPWR VGND sg13cmos5l_and2_1
X_2136_ _2136_/Y _2137_/B _2137_/C VPWR VGND sg13cmos5l_nand2_1
XFILLER_26_205 VPWR VGND sg13cmos5l_fill_1
X_2067_ _2069_/A _3707_/Q _2115_/A VPWR VGND sg13cmos5l_xor2_1
XFILLER_34_260 VPWR VGND sg13cmos5l_decap_8
XFILLER_22_422 VPWR VGND sg13cmos5l_decap_8
XFILLER_23_956 VPWR VGND sg13cmos5l_decap_8
X_2969_ _3050_/A _2970_/B VPWR VGND sg13cmos5l_inv_1
Xhold640 _2771_/B _2767_/Y VPWR VGND sg13cmos5l_dlygate4sd3_1
Xhold651 _2443_/B _3793_/Q VPWR VGND sg13cmos5l_dlygate4sd3_1
XFILLER_2_849 VPWR VGND sg13cmos5l_decap_8
Xhold662 hold662/X _3746_/Q VPWR VGND sg13cmos5l_dlygate4sd3_1
Xhold673 _2759_/A _3574_/Q VPWR VGND sg13cmos5l_dlygate4sd3_1
Xhold684 _1969_/A _3733_/Q VPWR VGND sg13cmos5l_dlygate4sd3_1
Xhold695 _3683_/D _3332_/Y VPWR VGND sg13cmos5l_dlygate4sd3_1
XFILLER_18_717 VPWR VGND sg13cmos5l_decap_8
XFILLER_17_216 VPWR VGND sg13cmos5l_fill_1
XFILLER_26_750 VPWR VGND sg13cmos5l_decap_8
XFILLER_13_400 VPWR VGND sg13cmos5l_decap_8
XFILLER_14_901 VPWR VGND sg13cmos5l_decap_8
XFILLER_13_422 VPWR VGND sg13cmos5l_decap_8
XFILLER_1_871 VPWR VGND sg13cmos5l_decap_8
XFILLER_49_831 VPWR VGND sg13cmos5l_decap_8
XFILLER_17_750 VPWR VGND sg13cmos5l_fill_2
XFILLER_17_794 VPWR VGND sg13cmos5l_decap_8
XFILLER_32_731 VPWR VGND sg13cmos5l_decap_8
X_2823_ _2823_/Y _2832_/S0 _1992_/Y _2826_/B1 VPWR VGND sg13cmos5l_a21oi_1
XFILLER_20_959 VPWR VGND sg13cmos5l_decap_8
XFILLER_31_285 VPWR VGND sg13cmos5l_decap_8
X_2754_ _2756_/B _2754_/A _2754_/B VPWR VGND sg13cmos5l_nor2_1
X_3749__145 _3749_/RESET_B VPWR VGND sg13cmos5l_tiehi
X_2685_ _2717_/B _2698_/A _2755_/B VPWR VGND sg13cmos5l_nor2_1
X_3306_ _3306_/Y _3653_/Q _3701_/Q VPWR VGND sg13cmos5l_nand2b_1
X_3237_ _3303_/A _3452_/B _3347_/A VPWR VGND sg13cmos5l_nand2b_1
X_3168_ _3168_/Y _3167_/Y _3168_/B VPWR VGND sg13cmos5l_nand2b_1
XFILLER_27_525 VPWR VGND sg13cmos5l_decap_8
X_2119_ _2119_/Y _3731_/Q _3705_/Q _2118_/A VPWR VGND sg13cmos5l_a21oi_1
X_3099_ _3111_/C _3101_/B VPWR VGND sg13cmos5l_inv_1
Xfanout45 _3072_/A _3015_/A VPWR VGND sg13cmos5l_buf_1
Xfanout34 _2708_/A _2607_/X VPWR VGND sg13cmos5l_buf_1
Xfanout23 _3454_/A2 _3181_/A2 VPWR VGND sg13cmos5l_buf_1
Xfanout56 _3088_/A hold817/X VPWR VGND sg13cmos5l_buf_1
X_3617__234 _3617_/RESET_B VPWR VGND sg13cmos5l_tiehi
XFILLER_11_926 VPWR VGND sg13cmos5l_decap_4
XFILLER_13_11 VPWR VGND sg13cmos5l_fill_2
XFILLER_22_263 VPWR VGND sg13cmos5l_decap_8
Xfanout67 fanout67/X _3546_/Q VPWR VGND sg13cmos5l_buf_1
Xfanout78 _3025_/A _2303_/A VPWR VGND sg13cmos5l_buf_1
XFILLER_13_77 VPWR VGND sg13cmos5l_decap_4
XFILLER_13_99 VPWR VGND sg13cmos5l_fill_1
XFILLER_8_4 VPWR VGND sg13cmos5l_fill_2
Xhold470 _3184_/B _3630_/Q VPWR VGND sg13cmos5l_dlygate4sd3_1
Xhold481 _1989_/A _3514_/Q VPWR VGND sg13cmos5l_dlygate4sd3_1
Xhold492 _1931_/A _3658_/Q VPWR VGND sg13cmos5l_dlygate4sd3_1
XFILLER_49_116 VPWR VGND sg13cmos5l_fill_1
XFILLER_1_189 VPWR VGND sg13cmos5l_decap_4
XFILLER_46_867 VPWR VGND sg13cmos5l_decap_8
XFILLER_18_569 VPWR VGND sg13cmos5l_fill_1
XFILLER_45_388 VPWR VGND sg13cmos5l_decap_8
XFILLER_45_366 VPWR VGND sg13cmos5l_decap_8
XFILLER_13_252 VPWR VGND sg13cmos5l_decap_8
XFILLER_14_786 VPWR VGND sg13cmos5l_decap_8
Xclkload15 clkload15/X _3766_/CLK VPWR VGND sg13cmos5l_buf_8
XFILLER_6_974 VPWR VGND sg13cmos5l_decap_8
X_2470_ _2470_/Y _3782_/Q _3756_/Q VPWR VGND sg13cmos5l_xnor2_1
X_3022_ _3628_/D _1937_/Y _3181_/A2 _3021_/Y VPWR VGND sg13cmos5l_a21oi_1
XFILLER_24_506 VPWR VGND sg13cmos5l_fill_1
Xclkload9 clkload9/X clkload9/A VPWR VGND sg13cmos5l_buf_8
X_3786_ _3786_/Q clkload3/A _3786_/D _3786_/RESET_B VPWR VGND sg13cmos5l_dfrbpq_1
XFILLER_20_789 VPWR VGND sg13cmos5l_decap_8
XFILLER_30_1003 VPWR VGND sg13cmos5l_decap_8
X_2806_ _2844_/B _2788_/Y _2793_/X _2802_/Y _2805_/Y VPWR VGND sg13cmos5l_a22oi_1
X_2737_ _3566_/D _2737_/A1 _2455_/A _2736_/Y VPWR VGND sg13cmos5l_a21oi_1
X_2668_ _3533_/D input10/X hold546/X _2671_/S VPWR VGND sg13cmos5l_mux2_1
X_2599_ _3478_/D hold550/X input6/X _2606_/S VPWR VGND sg13cmos5l_mux2_1
XFILLER_28_878 VPWR VGND sg13cmos5l_decap_8
XFILLER_42_358 VPWR VGND sg13cmos5l_fill_1
XFILLER_24_32 VPWR VGND sg13cmos5l_decap_8
XFILLER_24_76 VPWR VGND sg13cmos5l_fill_2
XFILLER_7_716 VPWR VGND sg13cmos5l_fill_2
XFILLER_7_705 VPWR VGND sg13cmos5l_decap_8
XFILLER_6_226 VPWR VGND sg13cmos5l_decap_8
XFILLER_6_204 VPWR VGND sg13cmos5l_fill_1
XFILLER_10_255 VPWR VGND sg13cmos5l_decap_8
XFILLER_10_266 VPWR VGND sg13cmos5l_fill_1
XFILLER_11_789 VPWR VGND sg13cmos5l_decap_8
XFILLER_40_53 VPWR VGND sg13cmos5l_decap_8
XFILLER_6_237 VPWR VGND sg13cmos5l_fill_1
XFILLER_40_64 VPWR VGND sg13cmos5l_decap_8
XFILLER_3_955 VPWR VGND sg13cmos5l_decap_8
XFILLER_2_421 VPWR VGND sg13cmos5l_fill_1
XFILLER_46_1021 VPWR VGND sg13cmos5l_decap_8
X_3706__302 _3706_/RESET_B VPWR VGND sg13cmos5l_tiehi
XFILLER_2_454 VPWR VGND sg13cmos5l_decap_4
XFILLER_49_84 VPWR VGND sg13cmos5l_decap_4
XFILLER_1_14 VPWR VGND sg13cmos5l_decap_8
XFILLER_19_801 VPWR VGND sg13cmos5l_fill_1
XFILLER_19_823 VPWR VGND sg13cmos5l_fill_1
XFILLER_1_58 VPWR VGND sg13cmos5l_decap_4
XFILLER_46_675 VPWR VGND sg13cmos5l_decap_8
XFILLER_19_878 VPWR VGND sg13cmos5l_decap_4
XFILLER_34_837 VPWR VGND sg13cmos5l_decap_8
X_1970_ _2307_/A _1970_/A VPWR VGND sg13cmos5l_inv_1
XFILLER_33_358 VPWR VGND sg13cmos5l_decap_8
XFILLER_42_881 VPWR VGND sg13cmos5l_decap_8
XFILLER_14_583 VPWR VGND sg13cmos5l_decap_8
X_3640_ _3640_/Q _3666_/CLK _3640_/D _3640_/RESET_B VPWR VGND sg13cmos5l_dfrbpq_1
X_3571_ _3571_/Q clkload6/A _3571_/D _3571_/RESET_B VPWR VGND sg13cmos5l_dfrbpq_1
X_2522_ _2522_/Y _2520_/Y _2521_/X _2550_/A VPWR VGND sg13cmos5l_o21ai_1
X_2453_ _2453_/Y _2442_/B _2451_/S _2465_/B VPWR VGND sg13cmos5l_o21ai_1
X_2384_ _2391_/B _3793_/Q _3792_/Q _3791_/Q _2428_/B VPWR VGND sg13cmos5l_nor4_1
X_3607__244 _3607_/RESET_B VPWR VGND sg13cmos5l_tiehi
Xinput2 input2/X ui_in[0] VPWR VGND sg13cmos5l_buf_1
XFILLER_49_491 VPWR VGND sg13cmos5l_decap_8
X_3005_ _3006_/B _2998_/Y _3003_/Y _3004_/Y _2999_/Y VPWR VGND sg13cmos5l_a22oi_1
XFILLER_37_675 VPWR VGND sg13cmos5l_fill_2
XFILLER_25_804 VPWR VGND sg13cmos5l_decap_8
XFILLER_36_130 VPWR VGND sg13cmos5l_decap_8
XFILLER_37_697 VPWR VGND sg13cmos5l_decap_8
XFILLER_25_848 VPWR VGND sg13cmos5l_decap_8
XFILLER_24_358 VPWR VGND sg13cmos5l_decap_4
X_3614__237 _3614_/RESET_B VPWR VGND sg13cmos5l_tiehi
XFILLER_20_564 VPWR VGND sg13cmos5l_decap_8
XFILLER_4_719 VPWR VGND sg13cmos5l_decap_8
X_3769_ _3769_/Q clkload4/A _3769_/D _3769_/RESET_B VPWR VGND sg13cmos5l_dfrbpq_1
XFILLER_10_45 VPWR VGND sg13cmos5l_decap_4
XFILLER_3_229 VPWR VGND sg13cmos5l_decap_8
XFILLER_0_958 VPWR VGND sg13cmos5l_decap_8
XFILLER_48_929 VPWR VGND sg13cmos5l_decap_8
XFILLER_19_54 VPWR VGND sg13cmos5l_decap_4
XFILLER_19_119 VPWR VGND sg13cmos5l_decap_4
XFILLER_16_837 VPWR VGND sg13cmos5l_decap_8
XFILLER_27_163 VPWR VGND sg13cmos5l_decap_8
XFILLER_35_53 VPWR VGND sg13cmos5l_decap_8
XFILLER_35_64 VPWR VGND sg13cmos5l_fill_1
XFILLER_42_188 VPWR VGND sg13cmos5l_decap_8
XFILLER_30_339 VPWR VGND sg13cmos5l_decap_8
XFILLER_7_557 VPWR VGND sg13cmos5l_decap_8
XFILLER_3_763 VPWR VGND sg13cmos5l_decap_4
XFILLER_47_940 VPWR VGND sg13cmos5l_decap_8
XFILLER_33_122 VPWR VGND sg13cmos5l_decap_8
XFILLER_21_328 VPWR VGND sg13cmos5l_decap_8
XFILLER_33_188 VPWR VGND sg13cmos5l_decap_4
X_3713__103 _3713_/D VPWR VGND sg13cmos5l_tielo
X_1953_ _2692_/A input4/X VPWR VGND sg13cmos5l_inv_1
XFILLER_30_851 VPWR VGND sg13cmos5l_decap_8
X_3623_ _3623_/Q _3698_/CLK _3623_/D _3623_/RESET_B VPWR VGND sg13cmos5l_dfrbpq_1
X_3554_ _3554_/Q clkload2/A _3554_/D _3554_/RESET_B VPWR VGND sg13cmos5l_dfrbpq_1
X_3485_ _3485_/Q _3574_/CLK _3485_/D _3485_/RESET_B VPWR VGND sg13cmos5l_dfrbpq_1
X_2505_ _2505_/Y _3741_/Q _3742_/Q _3743_/Q VPWR VGND sg13cmos5l_o21ai_1
X_2436_ _2438_/B _2271_/Y _2439_/B _2435_/Y VPWR VGND sg13cmos5l_o21ai_1
X_2367_ _2411_/A _2385_/B _2367_/B VPWR VGND sg13cmos5l_nand2b_1
X_2298_ _3753_/D _1926_/Y _3458_/A2 _2297_/Y VPWR VGND sg13cmos5l_a21oi_1
XFILLER_38_984 VPWR VGND sg13cmos5l_decap_8
XFILLER_25_656 VPWR VGND sg13cmos5l_fill_1
XFILLER_25_689 VPWR VGND sg13cmos5l_decap_8
XFILLER_24_188 VPWR VGND sg13cmos5l_decap_4
XFILLER_21_862 VPWR VGND sg13cmos5l_decap_8
XFILLER_21_11 VPWR VGND sg13cmos5l_decap_4
XFILLER_0_700 VPWR VGND sg13cmos5l_fill_1
XFILLER_0_755 VPWR VGND sg13cmos5l_decap_8
XFILLER_29_973 VPWR VGND sg13cmos5l_decap_8
XFILLER_44_910 VPWR VGND sg13cmos5l_decap_8
XFILLER_44_987 VPWR VGND sg13cmos5l_decap_8
XFILLER_30_136 VPWR VGND sg13cmos5l_fill_1
XFILLER_30_169 VPWR VGND sg13cmos5l_decap_8
XFILLER_7_332 VPWR VGND sg13cmos5l_decap_8
XFILLER_7_46 VPWR VGND sg13cmos5l_fill_2
XFILLER_8_877 VPWR VGND sg13cmos5l_decap_8
XFILLER_7_365 VPWR VGND sg13cmos5l_decap_8
XFILLER_7_398 VPWR VGND sg13cmos5l_fill_2
X_3270_ _3675_/D _3410_/A _3270_/B VPWR VGND sg13cmos5l_nor2_1
Xheichips26_dna_sequencer_95 uio_out[3] VPWR VGND sg13cmos5l_tielo
X_2221_ _2221_/Y _3732_/Q _2231_/B _2219_/Y _2220_/Y VPWR VGND sg13cmos5l_a22oi_1
XFILLER_39_726 VPWR VGND sg13cmos5l_fill_2
XFILLER_38_203 VPWR VGND sg13cmos5l_fill_2
XFILLER_23_4 VPWR VGND sg13cmos5l_decap_8
XFILLER_38_225 VPWR VGND sg13cmos5l_fill_2
X_2152_ _2154_/A _2152_/A _2152_/B VPWR VGND sg13cmos5l_nor2_1
XFILLER_38_269 VPWR VGND sg13cmos5l_decap_4
XFILLER_38_258 VPWR VGND sg13cmos5l_decap_4
X_2083_ _2083_/Y _2088_/A _2151_/B VPWR VGND sg13cmos5l_nor2_1
X_3604__247 _3604_/RESET_B VPWR VGND sg13cmos5l_tiehi
XFILLER_35_921 VPWR VGND sg13cmos5l_fill_1
XFILLER_35_932 VPWR VGND sg13cmos5l_fill_2
XFILLER_35_965 VPWR VGND sg13cmos5l_decap_8
X_2985_ _2986_/B _2985_/A _2984_/Y VPWR VGND sg13cmos5l_nor2b_1
X_1936_ _1936_/Y _2919_/A VPWR VGND sg13cmos5l_inv_1
Xhold811 hold811/X _2351_/Y VPWR VGND sg13cmos5l_dlygate4sd3_1
Xhold800 _2076_/A _3730_/Q VPWR VGND sg13cmos5l_dlygate4sd3_1
X_3606_ _3606_/Q _3629_/CLK _3606_/D _3606_/RESET_B VPWR VGND sg13cmos5l_dfrbpq_1
Xhold822 _2117_/B _3704_/Q VPWR VGND sg13cmos5l_dlygate4sd3_1
XFILLER_1_508 VPWR VGND sg13cmos5l_decap_4
X_3537_ _3537_/Q clkload6/A _3537_/D _3537_/RESET_B VPWR VGND sg13cmos5l_dfrbpq_1
X_3468_ _3469_/A _2087_/A _2084_/Y _2160_/Y _2162_/Y _3467_/Y VPWR VGND sg13cmos5l_a221oi_1
X_2419_ _2419_/Y _2431_/B _3789_/Q _2428_/B _1959_/Y VPWR VGND sg13cmos5l_a22oi_1
X_3399_ _3399_/Y _3401_/A _3401_/B VPWR VGND sg13cmos5l_nand2_1
XFILLER_44_206 VPWR VGND sg13cmos5l_decap_8
XFILLER_37_291 VPWR VGND sg13cmos5l_fill_1
XFILLER_37_280 VPWR VGND sg13cmos5l_decap_8
XFILLER_26_954 VPWR VGND sg13cmos5l_decap_8
XFILLER_41_935 VPWR VGND sg13cmos5l_decap_8
XFILLER_13_615 VPWR VGND sg13cmos5l_fill_2
XFILLER_40_445 VPWR VGND sg13cmos5l_decap_8
XFILLER_40_456 VPWR VGND sg13cmos5l_fill_1
XFILLER_21_681 VPWR VGND sg13cmos5l_decap_8
XFILLER_21_692 VPWR VGND sg13cmos5l_fill_1
XFILLER_5_803 VPWR VGND sg13cmos5l_decap_8
XFILLER_20_180 VPWR VGND sg13cmos5l_decap_8
XFILLER_4_313 VPWR VGND sg13cmos5l_decap_8
XFILLER_10_1001 VPWR VGND sg13cmos5l_decap_8
XFILLER_4_357 VPWR VGND sg13cmos5l_decap_8
XFILLER_0_541 VPWR VGND sg13cmos5l_fill_2
XFILLER_48_545 VPWR VGND sg13cmos5l_fill_1
XFILLER_36_729 VPWR VGND sg13cmos5l_decap_8
XFILLER_17_921 VPWR VGND sg13cmos5l_decap_8
XFILLER_35_206 VPWR VGND sg13cmos5l_decap_4
XFILLER_44_784 VPWR VGND sg13cmos5l_decap_8
XFILLER_17_976 VPWR VGND sg13cmos5l_decap_8
X_2770_ _3572_/D _2768_/Y _2769_/Y _2772_/A VPWR VGND sg13cmos5l_a21oi_1
XFILLER_7_195 VPWR VGND sg13cmos5l_decap_4
X_3322_ _3322_/Y _2005_/Y _3330_/A _3333_/A _3324_/A VPWR VGND sg13cmos5l_a22oi_1
X_3253_ _3261_/A _3253_/A VPWR VGND sg13cmos5l_inv_1
XFILLER_39_523 VPWR VGND sg13cmos5l_decap_4
X_2204_ _2205_/B _2170_/X _2185_/X _2187_/Y VPWR VGND sg13cmos5l_o21ai_1
X_3184_ _3660_/D _3460_/A _3184_/B VPWR VGND sg13cmos5l_and2_1
X_2135_ _2137_/C _2135_/A _2135_/B _2232_/A VPWR VGND sg13cmos5l_or3_1
XFILLER_27_707 VPWR VGND sg13cmos5l_decap_8
XFILLER_26_217 VPWR VGND sg13cmos5l_decap_8
X_2066_ _2068_/B _3706_/Q _3707_/Q _3705_/Q _3704_/Q VPWR VGND sg13cmos5l_nor4_1
XFILLER_23_913 VPWR VGND sg13cmos5l_fill_2
XFILLER_35_762 VPWR VGND sg13cmos5l_decap_8
XFILLER_35_795 VPWR VGND sg13cmos5l_fill_1
X_2968_ _2970_/B _3136_/B _3133_/C _2946_/Y _1987_/A _2967_/Y VPWR VGND sg13cmos5l_a221oi_1
X_2899_ _2899_/Y _2899_/A _2899_/B VPWR VGND sg13cmos5l_nand2_1
Xhold630 _2911_/A _3587_/Q VPWR VGND sg13cmos5l_dlygate4sd3_1
Xhold641 _2772_/B _2771_/Y VPWR VGND sg13cmos5l_dlygate4sd3_1
Xhold652 hold652/X _2443_/Y VPWR VGND sg13cmos5l_dlygate4sd3_1
XFILLER_2_828 VPWR VGND sg13cmos5l_decap_8
Xhold663 hold663/X _2266_/Y VPWR VGND sg13cmos5l_dlygate4sd3_1
Xhold674 _2769_/A _2766_/Y VPWR VGND sg13cmos5l_dlygate4sd3_1
Xhold696 hold696/X _3682_/Q VPWR VGND sg13cmos5l_dlygate4sd3_1
Xhold685 _3175_/B _3654_/Q VPWR VGND sg13cmos5l_dlygate4sd3_1
X_3661__171 _3661_/RESET_B VPWR VGND sg13cmos5l_tiehi
XFILLER_27_21 VPWR VGND sg13cmos5l_fill_2
XFILLER_27_32 VPWR VGND sg13cmos5l_decap_8
XFILLER_27_76 VPWR VGND sg13cmos5l_fill_2
XFILLER_27_87 VPWR VGND sg13cmos5l_decap_8
XFILLER_41_710 VPWR VGND sg13cmos5l_decap_8
XFILLER_14_924 VPWR VGND sg13cmos5l_fill_1
XFILLER_41_732 VPWR VGND sg13cmos5l_decap_4
XFILLER_25_261 VPWR VGND sg13cmos5l_decap_8
XFILLER_25_272 VPWR VGND sg13cmos5l_fill_2
XFILLER_41_776 VPWR VGND sg13cmos5l_decap_4
XFILLER_40_253 VPWR VGND sg13cmos5l_decap_8
XFILLER_9_405 VPWR VGND sg13cmos5l_fill_2
XFILLER_13_489 VPWR VGND sg13cmos5l_fill_2
XFILLER_40_297 VPWR VGND sg13cmos5l_decap_8
XFILLER_4_198 VPWR VGND sg13cmos5l_fill_1
XFILLER_49_810 VPWR VGND sg13cmos5l_decap_8
XFILLER_1_850 VPWR VGND sg13cmos5l_decap_8
XFILLER_0_382 VPWR VGND sg13cmos5l_decap_8
XFILLER_49_887 VPWR VGND sg13cmos5l_decap_8
XFILLER_16_250 VPWR VGND sg13cmos5l_fill_1
XFILLER_17_1018 VPWR VGND sg13cmos5l_decap_8
XFILLER_31_231 VPWR VGND sg13cmos5l_decap_8
XFILLER_32_776 VPWR VGND sg13cmos5l_decap_4
X_2822_ _2822_/X _3530_/Q _3513_/Q _3496_/Q _3479_/Q _2832_/S0 _2826_/B1 VPWR VGND
+ sg13cmos5l_mux4_1
XFILLER_20_938 VPWR VGND sg13cmos5l_decap_8
XFILLER_31_264 VPWR VGND sg13cmos5l_decap_8
X_2753_ _3569_/D _3477_/A _2754_/B _2756_/A _2753_/D VPWR VGND sg13cmos5l_nor4_1
XFILLER_8_460 VPWR VGND sg13cmos5l_decap_8
XFILLER_9_983 VPWR VGND sg13cmos5l_decap_8
X_2684_ _2755_/B _2754_/A _2754_/B VPWR VGND sg13cmos5l_nand2_1
X_3305_ _3305_/Y _3464_/A _3653_/Q _3652_/Q _3244_/B _3304_/Y VPWR VGND sg13cmos5l_a221oi_1
X_3236_ _3236_/Y _3236_/A _3452_/B VPWR VGND sg13cmos5l_nor2_1
XFILLER_39_386 VPWR VGND sg13cmos5l_fill_1
X_3167_ _3167_/Y _3175_/B _3164_/Y _3175_/A VPWR VGND sg13cmos5l_o21ai_1
X_3098_ _3101_/B _3645_/Q _3098_/B VPWR VGND sg13cmos5l_xnor2_1
X_2118_ _2118_/Y _2118_/A VPWR VGND sg13cmos5l_inv_1
X_2049_ _2058_/A _2049_/A _2048_/Y VPWR VGND sg13cmos5l_nor2b_1
Xfanout46 _2307_/B _2361_/A VPWR VGND sg13cmos5l_buf_1
Xfanout24 _3458_/A2 _3181_/A2 VPWR VGND sg13cmos5l_buf_1
XFILLER_22_231 VPWR VGND sg13cmos5l_decap_8
XFILLER_23_743 VPWR VGND sg13cmos5l_decap_8
XFILLER_23_765 VPWR VGND sg13cmos5l_fill_1
Xfanout35 _3376_/B _3396_/B VPWR VGND sg13cmos5l_buf_1
Xfanout57 _3029_/A hold757/X VPWR VGND sg13cmos5l_buf_1
Xfanout68 _3801_/D _2586_/A VPWR VGND sg13cmos5l_buf_1
XFILLER_22_253 VPWR VGND sg13cmos5l_decap_4
Xfanout79 _2303_/A _2838_/B1 VPWR VGND sg13cmos5l_buf_1
XFILLER_10_448 VPWR VGND sg13cmos5l_decap_8
XFILLER_10_459 VPWR VGND sg13cmos5l_fill_2
XFILLER_1_124 VPWR VGND sg13cmos5l_fill_1
Xhold471 _2908_/B _3582_/Q VPWR VGND sg13cmos5l_dlygate4sd3_1
X_3780__435 _3780_/RESET_B VPWR VGND sg13cmos5l_tiehi
Xhold482 _3460_/B _3692_/Q VPWR VGND sg13cmos5l_dlygate4sd3_1
Xhold493 _2901_/B _3578_/Q VPWR VGND sg13cmos5l_dlygate4sd3_1
XFILLER_38_86 VPWR VGND sg13cmos5l_fill_2
XFILLER_18_504 VPWR VGND sg13cmos5l_decap_4
X_3698__318 _3698_/RESET_B VPWR VGND sg13cmos5l_tiehi
XFILLER_46_846 VPWR VGND sg13cmos5l_decap_8
XFILLER_45_378 VPWR VGND sg13cmos5l_decap_4
XFILLER_9_268 VPWR VGND sg13cmos5l_decap_4
XFILLER_13_297 VPWR VGND sg13cmos5l_fill_1
Xclkload16 clkload16/Y _3664_/CLK VPWR VGND sg13cmos5l_inv_2
XFILLER_6_953 VPWR VGND sg13cmos5l_decap_8
XFILLER_5_496 VPWR VGND sg13cmos5l_decap_4
XFILLER_49_662 VPWR VGND sg13cmos5l_decap_4
X_3779__128 _3779_/D VPWR VGND sg13cmos5l_tielo
X_3021_ _3021_/Y _1934_/A _3454_/A2 _3186_/A VPWR VGND sg13cmos5l_o21ai_1
XFILLER_49_695 VPWR VGND sg13cmos5l_decap_8
XFILLER_20_713 VPWR VGND sg13cmos5l_decap_4
X_2805_ _2805_/Y _2790_/Y _2803_/X _2804_/X _2683_/B _3570_/Q VPWR VGND sg13cmos5l_a221oi_1
XFILLER_32_595 VPWR VGND sg13cmos5l_decap_8
X_3785_ _3785_/Q clkload3/A _3785_/D _3785_/RESET_B VPWR VGND sg13cmos5l_dfrbpq_1
X_2736_ _2736_/Y _2737_/A1 hold499/X _2597_/C VPWR VGND sg13cmos5l_o21ai_1
XFILLER_9_791 VPWR VGND sg13cmos5l_decap_8
X_2667_ _3532_/D input9/X hold599/X _2671_/S VPWR VGND sg13cmos5l_mux2_1
X_2598_ _2606_/S _3560_/Q _3559_/Q _2663_/A VPWR VGND sg13cmos5l_and3_1
X_3219_ _3220_/A _3117_/B _3192_/C _3112_/Y VPWR VGND sg13cmos5l_a21oi_1
XFILLER_43_805 VPWR VGND sg13cmos5l_decap_8
XFILLER_43_849 VPWR VGND sg13cmos5l_fill_2
XFILLER_42_337 VPWR VGND sg13cmos5l_fill_1
XFILLER_24_11 VPWR VGND sg13cmos5l_decap_8
XFILLER_24_55 VPWR VGND sg13cmos5l_decap_8
XFILLER_10_234 VPWR VGND sg13cmos5l_decap_8
XFILLER_7_739 VPWR VGND sg13cmos5l_decap_8
XFILLER_11_768 VPWR VGND sg13cmos5l_decap_8
XFILLER_40_32 VPWR VGND sg13cmos5l_decap_8
XFILLER_40_87 VPWR VGND sg13cmos5l_fill_1
XFILLER_46_1000 VPWR VGND sg13cmos5l_decap_8
XFILLER_3_934 VPWR VGND sg13cmos5l_decap_8
XFILLER_49_30 VPWR VGND sg13cmos5l_decap_8
XFILLER_2_433 VPWR VGND sg13cmos5l_decap_8
XFILLER_46_632 VPWR VGND sg13cmos5l_fill_1
XFILLER_33_326 VPWR VGND sg13cmos5l_decap_4
XFILLER_42_860 VPWR VGND sg13cmos5l_decap_8
X_3570_ _3570_/Q _3809_/CLK _3570_/D _3570_/RESET_B VPWR VGND sg13cmos5l_dfrbpq_1
XFILLER_6_761 VPWR VGND sg13cmos5l_fill_1
X_2521_ _2521_/X _2521_/A _2521_/B _2521_/C VPWR VGND sg13cmos5l_and3_1
XFILLER_5_293 VPWR VGND sg13cmos5l_decap_8
X_2452_ _3776_/D _2558_/A _2452_/B VPWR VGND sg13cmos5l_nor2_1
X_2383_ _2383_/Y _2411_/A _2373_/X _2382_/X VPWR VGND sg13cmos5l_o21ai_1
X_3004_ _3004_/Y _3599_/Q _3004_/B VPWR VGND sg13cmos5l_nor2_1
XFILLER_37_621 VPWR VGND sg13cmos5l_fill_2
Xinput3 input3/X ui_in[1] VPWR VGND sg13cmos5l_buf_1
XFILLER_37_665 VPWR VGND sg13cmos5l_decap_4
XFILLER_36_186 VPWR VGND sg13cmos5l_decap_8
XFILLER_24_337 VPWR VGND sg13cmos5l_decap_8
XFILLER_33_893 VPWR VGND sg13cmos5l_decap_4
X_3768_ _3768_/Q clkload4/A _3768_/D _3768_/RESET_B VPWR VGND sg13cmos5l_dfrbpq_1
XFILLER_20_598 VPWR VGND sg13cmos5l_fill_2
XFILLER_3_208 VPWR VGND sg13cmos5l_decap_8
X_2719_ _2719_/Y _2596_/A _2718_/Y _2457_/A VPWR VGND sg13cmos5l_o21ai_1
X_3699_ _3699_/Q _3731_/CLK _3699_/D _3699_/RESET_B VPWR VGND sg13cmos5l_dfrbpq_1
XFILLER_10_68 VPWR VGND sg13cmos5l_decap_4
XFILLER_0_937 VPWR VGND sg13cmos5l_decap_8
XFILLER_48_908 VPWR VGND sg13cmos5l_decap_8
XFILLER_35_32 VPWR VGND sg13cmos5l_decap_8
XFILLER_42_134 VPWR VGND sg13cmos5l_decap_8
X_3658__176 _3658_/RESET_B VPWR VGND sg13cmos5l_tiehi
XFILLER_7_514 VPWR VGND sg13cmos5l_fill_2
XFILLER_11_543 VPWR VGND sg13cmos5l_fill_1
XFILLER_7_536 VPWR VGND sg13cmos5l_decap_8
XFILLER_11_587 VPWR VGND sg13cmos5l_fill_2
XFILLER_3_742 VPWR VGND sg13cmos5l_decap_8
XFILLER_2_230 VPWR VGND sg13cmos5l_fill_1
XFILLER_19_676 VPWR VGND sg13cmos5l_decap_8
XFILLER_47_996 VPWR VGND sg13cmos5l_decap_8
XFILLER_15_871 VPWR VGND sg13cmos5l_decap_8
XFILLER_21_307 VPWR VGND sg13cmos5l_decap_8
X_1952_ _2434_/A _1952_/A VPWR VGND sg13cmos5l_inv_1
X_3622_ _3622_/Q _3722_/CLK _3622_/D _3622_/RESET_B VPWR VGND sg13cmos5l_dfrbpq_1
X_3553_ _3553_/Q clkload5/A _3553_/D _3553_/RESET_B VPWR VGND sg13cmos5l_dfrbpq_1
X_3484_ _3484_/Q _3574_/CLK _3484_/D _3484_/RESET_B VPWR VGND sg13cmos5l_dfrbpq_1
X_2504_ _2504_/X _2399_/X _2521_/A _2503_/Y VPWR VGND sg13cmos5l_a21o_1
X_2435_ _2435_/Y _1966_/Y _3794_/Q _2439_/B VPWR VGND sg13cmos5l_o21ai_1
X_2366_ _2367_/B _3791_/Q _2428_/B _3792_/Q VPWR VGND sg13cmos5l_o21ai_1
X_2297_ _2297_/Y _1956_/A _3454_/A2 _3461_/A VPWR VGND sg13cmos5l_o21ai_1
X_3620__231 _3620_/RESET_B VPWR VGND sg13cmos5l_tiehi
XFILLER_38_963 VPWR VGND sg13cmos5l_decap_8
XFILLER_12_318 VPWR VGND sg13cmos5l_fill_1
XFILLER_13_819 VPWR VGND sg13cmos5l_decap_8
XFILLER_24_167 VPWR VGND sg13cmos5l_fill_2
XFILLER_40_638 VPWR VGND sg13cmos5l_decap_8
XFILLER_21_45 VPWR VGND sg13cmos5l_decap_8
XFILLER_4_539 VPWR VGND sg13cmos5l_decap_8
XFILLER_21_56 VPWR VGND sg13cmos5l_fill_2
XFILLER_0_712 VPWR VGND sg13cmos5l_decap_8
XFILLER_0_734 VPWR VGND sg13cmos5l_decap_8
XFILLER_43_1025 VPWR VGND sg13cmos5l_decap_4
XFILLER_47_215 VPWR VGND sg13cmos5l_decap_4
XFILLER_46_42 VPWR VGND sg13cmos5l_fill_2
XFILLER_29_952 VPWR VGND sg13cmos5l_decap_8
XFILLER_44_966 VPWR VGND sg13cmos5l_decap_8
XFILLER_15_134 VPWR VGND sg13cmos5l_decap_4
XFILLER_16_646 VPWR VGND sg13cmos5l_fill_2
XFILLER_30_115 VPWR VGND sg13cmos5l_decap_8
XFILLER_11_340 VPWR VGND sg13cmos5l_decap_8
XFILLER_30_148 VPWR VGND sg13cmos5l_decap_8
XFILLER_8_856 VPWR VGND sg13cmos5l_decap_8
XFILLER_7_311 VPWR VGND sg13cmos5l_decap_8
XFILLER_12_896 VPWR VGND sg13cmos5l_decap_8
Xheichips26_dna_sequencer_96 uio_out[4] VPWR VGND sg13cmos5l_tielo
Xheichips26_dna_sequencer_85 uio_oe[1] VPWR VGND sg13cmos5l_tielo
X_2220_ _2220_/Y _3732_/Q _3710_/Q VPWR VGND sg13cmos5l_nand2b_1
XFILLER_39_705 VPWR VGND sg13cmos5l_decap_8
XFILLER_38_237 VPWR VGND sg13cmos5l_decap_8
X_2151_ _2152_/B _2151_/A _2151_/B VPWR VGND sg13cmos5l_xnor2_1
XFILLER_16_4 VPWR VGND sg13cmos5l_decap_4
X_2082_ _2089_/A _2082_/A _2156_/A VPWR VGND sg13cmos5l_nand2_1
XFILLER_47_793 VPWR VGND sg13cmos5l_decap_8
XFILLER_46_270 VPWR VGND sg13cmos5l_decap_8
XFILLER_19_495 VPWR VGND sg13cmos5l_fill_1
XFILLER_34_454 VPWR VGND sg13cmos5l_decap_8
X_2984_ _2984_/Y _2981_/B _2982_/Y _2983_/Y VPWR VGND sg13cmos5l_o21ai_1
XFILLER_22_627 VPWR VGND sg13cmos5l_fill_1
X_1935_ _1935_/Y _1935_/A VPWR VGND sg13cmos5l_inv_1
XFILLER_30_682 VPWR VGND sg13cmos5l_fill_2
Xhold801 _2048_/A _3681_/Q VPWR VGND sg13cmos5l_dlygate4sd3_1
X_3605_ _3605_/Q _3629_/CLK _3605_/D _3605_/RESET_B VPWR VGND sg13cmos5l_dfrbpq_1
Xhold812 _3216_/A _3663_/Q VPWR VGND sg13cmos5l_dlygate4sd3_1
X_3536_ _3536_/Q _3574_/CLK _3536_/D _3536_/RESET_B VPWR VGND sg13cmos5l_dfrbpq_1
Xhold823 _2638_/A _3560_/Q VPWR VGND sg13cmos5l_dlygate4sd3_1
X_3467_ _3467_/Y _3467_/A _3467_/B VPWR VGND sg13cmos5l_nor2_1
X_2418_ _3772_/D _2558_/A _2418_/B VPWR VGND sg13cmos5l_nor2_1
X_3802__205 _3802_/RESET_B VPWR VGND sg13cmos5l_tiehi
X_3398_ _3401_/B _3398_/A _3398_/B VPWR VGND sg13cmos5l_nor2_1
X_2349_ _2350_/B _3761_/Q _2349_/B VPWR VGND sg13cmos5l_xnor2_1
XFILLER_45_719 VPWR VGND sg13cmos5l_decap_8
XFILLER_38_782 VPWR VGND sg13cmos5l_decap_8
XFILLER_26_933 VPWR VGND sg13cmos5l_decap_8
XFILLER_25_432 VPWR VGND sg13cmos5l_decap_8
XFILLER_25_443 VPWR VGND sg13cmos5l_fill_2
XFILLER_41_914 VPWR VGND sg13cmos5l_decap_8
XFILLER_16_67 VPWR VGND sg13cmos5l_decap_8
XFILLER_40_424 VPWR VGND sg13cmos5l_decap_8
XFILLER_16_89 VPWR VGND sg13cmos5l_decap_8
XFILLER_40_468 VPWR VGND sg13cmos5l_decap_8
XFILLER_9_609 VPWR VGND sg13cmos5l_fill_2
XFILLER_12_159 VPWR VGND sg13cmos5l_decap_8
XFILLER_32_11 VPWR VGND sg13cmos5l_fill_2
XFILLER_32_33 VPWR VGND sg13cmos5l_fill_1
XFILLER_32_55 VPWR VGND sg13cmos5l_fill_1
XFILLER_5_859 VPWR VGND sg13cmos5l_decap_8
XFILLER_4_336 VPWR VGND sg13cmos5l_decap_8
XFILLER_0_520 VPWR VGND sg13cmos5l_decap_8
XFILLER_0_586 VPWR VGND sg13cmos5l_decap_8
XFILLER_17_900 VPWR VGND sg13cmos5l_decap_8
XFILLER_16_410 VPWR VGND sg13cmos5l_fill_1
XFILLER_17_955 VPWR VGND sg13cmos5l_decap_8
XFILLER_28_292 VPWR VGND sg13cmos5l_decap_4
XFILLER_43_273 VPWR VGND sg13cmos5l_fill_2
XFILLER_31_457 VPWR VGND sg13cmos5l_decap_4
X_3610__241 _3610_/RESET_B VPWR VGND sg13cmos5l_tiehi
X_3321_ _3333_/A _3655_/Q _3319_/Y _3320_/Y VPWR VGND sg13cmos5l_o21ai_1
XFILLER_4_881 VPWR VGND sg13cmos5l_decap_8
X_3252_ _3253_/A _3252_/A _3265_/A VPWR VGND sg13cmos5l_nor2_1
X_2203_ _2203_/Y _2512_/A VPWR VGND sg13cmos5l_inv_1
X_3183_ _3659_/D _1933_/Y _3344_/A2 _3182_/Y VPWR VGND sg13cmos5l_a21oi_1
XFILLER_39_557 VPWR VGND sg13cmos5l_fill_2
X_2134_ _2137_/B _2135_/A _2135_/B _2118_/Y VPWR VGND sg13cmos5l_o21ai_1
X_2065_ _2115_/A _3706_/Q _3705_/Q _3704_/Q VPWR VGND sg13cmos5l_or3_1
XFILLER_19_292 VPWR VGND sg13cmos5l_decap_8
XFILLER_35_741 VPWR VGND sg13cmos5l_decap_4
XFILLER_34_295 VPWR VGND sg13cmos5l_decap_8
X_2967_ _2967_/Y _2944_/A _2944_/B _2956_/C _2956_/A VPWR VGND sg13cmos5l_a22oi_1
XFILLER_10_619 VPWR VGND sg13cmos5l_decap_8
XFILLER_31_991 VPWR VGND sg13cmos5l_decap_8
XFILLER_33_1013 VPWR VGND sg13cmos5l_decap_8
X_2898_ _2898_/Y _3000_/B _2894_/Y _2897_/Y VPWR VGND sg13cmos5l_a21oi_1
Xhold620 hold620/X _3501_/Q VPWR VGND sg13cmos5l_dlygate4sd3_1
XFILLER_2_807 VPWR VGND sg13cmos5l_decap_8
Xhold653 hold653/X _3563_/Q VPWR VGND sg13cmos5l_dlygate4sd3_1
Xhold642 _2724_/A _3560_/Q VPWR VGND sg13cmos5l_dlygate4sd3_1
Xhold631 _1933_/A _3629_/Q VPWR VGND sg13cmos5l_dlygate4sd3_1
X_3519_ _3519_/Q clkload8/A _3519_/D _3519_/RESET_B VPWR VGND sg13cmos5l_dfrbpq_1
Xhold664 _3746_/D _2267_/Y VPWR VGND sg13cmos5l_dlygate4sd3_1
Xhold675 hold675/X _3714_/Q VPWR VGND sg13cmos5l_dlygate4sd3_1
Xhold697 _3682_/D _3329_/Y VPWR VGND sg13cmos5l_dlygate4sd3_1
Xhold686 hold686/X _3175_/Y VPWR VGND sg13cmos5l_dlygate4sd3_1
XFILLER_40_1028 VPWR VGND sg13cmos5l_fill_1
XFILLER_45_527 VPWR VGND sg13cmos5l_fill_1
XFILLER_45_516 VPWR VGND sg13cmos5l_decap_8
XFILLER_26_785 VPWR VGND sg13cmos5l_decap_4
XFILLER_41_755 VPWR VGND sg13cmos5l_decap_8
XFILLER_40_221 VPWR VGND sg13cmos5l_decap_8
XFILLER_25_295 VPWR VGND sg13cmos5l_fill_2
Xclkbuf_leaf_20_clk clkload3/A clkbuf_leaf_3_clk/A VPWR VGND sg13cmos5l_buf_8
XFILLER_4_122 VPWR VGND sg13cmos5l_decap_8
XFILLER_49_1020 VPWR VGND sg13cmos5l_decap_8
XFILLER_5_667 VPWR VGND sg13cmos5l_decap_8
XFILLER_4_177 VPWR VGND sg13cmos5l_decap_8
XFILLER_4_37 VPWR VGND sg13cmos5l_fill_2
XFILLER_0_372 VPWR VGND sg13cmos5l_decap_4
XFILLER_49_866 VPWR VGND sg13cmos5l_decap_8
XFILLER_36_505 VPWR VGND sg13cmos5l_decap_8
XFILLER_1_1011 VPWR VGND sg13cmos5l_decap_8
X_3679__444 _3679_/RESET_B VPWR VGND sg13cmos5l_tiehi
XFILLER_17_752 VPWR VGND sg13cmos5l_fill_1
XFILLER_32_700 VPWR VGND sg13cmos5l_decap_8
X_2821_ _2821_/X _3570_/Q _2821_/B VPWR VGND sg13cmos5l_and2_1
Xclkbuf_leaf_11_clk _3665_/CLK clkload0/A VPWR VGND sg13cmos5l_buf_8
XFILLER_9_962 VPWR VGND sg13cmos5l_decap_8
X_2752_ _2752_/Y _2682_/B _2751_/A hold667/X VPWR VGND sg13cmos5l_a21oi_1
XFILLER_8_450 VPWR VGND sg13cmos5l_fill_2
X_2683_ _2754_/B _2751_/A _2683_/B VPWR VGND sg13cmos5l_and2_1
X_3304_ _3304_/Y _3463_/A _2008_/Y _3310_/B _3699_/Q VPWR VGND sg13cmos5l_a22oi_1
XFILLER_39_310 VPWR VGND sg13cmos5l_decap_8
X_3235_ _3670_/D _3117_/B hold726/X _3190_/B VPWR VGND sg13cmos5l_a21oi_1
XFILLER_39_321 VPWR VGND sg13cmos5l_fill_2
X_3166_ _3168_/B _3158_/Y _3163_/Y _3165_/Y VPWR VGND sg13cmos5l_o21ai_1
X_3097_ _3111_/B _3087_/Y _3094_/Y _3096_/Y VPWR VGND sg13cmos5l_a21oi_1
X_2117_ _2118_/A _3705_/Q _2117_/B VPWR VGND sg13cmos5l_xor2_1
X_2048_ _2048_/Y _2048_/A _2048_/B VPWR VGND sg13cmos5l_xnor2_1
XFILLER_23_700 VPWR VGND sg13cmos5l_fill_1
XFILLER_22_210 VPWR VGND sg13cmos5l_decap_8
Xfanout47 _2361_/A _2270_/A VPWR VGND sg13cmos5l_buf_1
Xfanout36 _2545_/B _2482_/B VPWR VGND sg13cmos5l_buf_1
Xfanout25 _3344_/A2 _3181_/A2 VPWR VGND sg13cmos5l_buf_1
XFILLER_13_24 VPWR VGND sg13cmos5l_fill_2
Xfanout69 _3477_/A _2586_/A VPWR VGND sg13cmos5l_buf_1
Xfanout58 _2682_/B _3568_/Q VPWR VGND sg13cmos5l_buf_1
XFILLER_2_615 VPWR VGND sg13cmos5l_decap_8
X_3808__222 _3808_/RESET_B VPWR VGND sg13cmos5l_tiehi
Xhold472 _3185_/B _3631_/Q VPWR VGND sg13cmos5l_dlygate4sd3_1
Xhold494 _2693_/A _3561_/Q VPWR VGND sg13cmos5l_dlygate4sd3_1
Xhold483 _1993_/A _3523_/Q VPWR VGND sg13cmos5l_dlygate4sd3_1
XFILLER_38_54 VPWR VGND sg13cmos5l_fill_2
XFILLER_46_825 VPWR VGND sg13cmos5l_decap_8
XFILLER_38_65 VPWR VGND sg13cmos5l_decap_8
XFILLER_45_346 VPWR VGND sg13cmos5l_decap_4
XFILLER_14_722 VPWR VGND sg13cmos5l_decap_4
XFILLER_26_560 VPWR VGND sg13cmos5l_decap_8
XFILLER_14_744 VPWR VGND sg13cmos5l_decap_8
XFILLER_9_225 VPWR VGND sg13cmos5l_decap_8
XFILLER_41_596 VPWR VGND sg13cmos5l_decap_8
Xclkload17 clkload17/Y _3666_/CLK VPWR VGND sg13cmos5l_inv_2
XFILLER_6_932 VPWR VGND sg13cmos5l_decap_8
XFILLER_10_994 VPWR VGND sg13cmos5l_decap_8
XFILLER_5_475 VPWR VGND sg13cmos5l_decap_8
XFILLER_49_641 VPWR VGND sg13cmos5l_decap_8
XFILLER_23_1012 VPWR VGND sg13cmos5l_decap_8
XFILLER_49_674 VPWR VGND sg13cmos5l_decap_8
XFILLER_37_825 VPWR VGND sg13cmos5l_fill_1
XFILLER_37_814 VPWR VGND sg13cmos5l_decap_8
Xclkbuf_leaf_0_clk clkload1/A clkbuf_leaf_3_clk/A VPWR VGND sg13cmos5l_buf_8
X_3020_ _3627_/D _1938_/Y _3020_/A2 _3019_/Y VPWR VGND sg13cmos5l_a21oi_1
XFILLER_37_858 VPWR VGND sg13cmos5l_fill_2
XFILLER_37_847 VPWR VGND sg13cmos5l_decap_8
XFILLER_36_368 VPWR VGND sg13cmos5l_decap_8
X_3499__384 _3499_/RESET_B VPWR VGND sg13cmos5l_tiehi
XFILLER_32_574 VPWR VGND sg13cmos5l_decap_8
X_2804_ _2804_/X _3535_/Q _3518_/Q _3501_/Q _3484_/Q _2832_/S0 _2826_/B1 VPWR VGND
+ sg13cmos5l_mux4_1
X_3784_ _3784_/Q clkload3/A _3784_/D _3784_/RESET_B VPWR VGND sg13cmos5l_dfrbpq_1
X_2735_ _3565_/D _2737_/A1 _1947_/Y _2734_/Y VPWR VGND sg13cmos5l_a21oi_1
X_2666_ _3531_/D input8/X hold567/X _2671_/S VPWR VGND sg13cmos5l_mux2_1
X_2597_ _2663_/A input3/X _2691_/B _2597_/C _2607_/C VPWR VGND sg13cmos5l_and4_1
XFILLER_8_1028 VPWR VGND sg13cmos5l_fill_1
XFILLER_8_1017 VPWR VGND sg13cmos5l_decap_8
XFILLER_39_140 VPWR VGND sg13cmos5l_fill_2
X_3218_ _3218_/Y _3228_/B _3218_/B VPWR VGND sg13cmos5l_nand2b_1
XFILLER_39_162 VPWR VGND sg13cmos5l_decap_8
XFILLER_28_836 VPWR VGND sg13cmos5l_decap_8
X_3149_ _3149_/Y _3144_/Y _3146_/Y _3148_/Y VPWR VGND sg13cmos5l_o21ai_1
XFILLER_42_316 VPWR VGND sg13cmos5l_decap_8
XFILLER_15_519 VPWR VGND sg13cmos5l_decap_8
XFILLER_27_379 VPWR VGND sg13cmos5l_decap_8
XFILLER_42_349 VPWR VGND sg13cmos5l_decap_8
X_3734__202 _3734_/RESET_B VPWR VGND sg13cmos5l_tiehi
XFILLER_35_390 VPWR VGND sg13cmos5l_decap_4
XFILLER_10_202 VPWR VGND sg13cmos5l_decap_4
XFILLER_11_736 VPWR VGND sg13cmos5l_decap_8
XFILLER_11_747 VPWR VGND sg13cmos5l_fill_1
X_3554__323 _3554_/RESET_B VPWR VGND sg13cmos5l_tiehi
XFILLER_24_89 VPWR VGND sg13cmos5l_decap_8
XFILLER_10_279 VPWR VGND sg13cmos5l_fill_2
XFILLER_3_913 VPWR VGND sg13cmos5l_decap_8
XFILLER_2_412 VPWR VGND sg13cmos5l_decap_8
XFILLER_49_64 VPWR VGND sg13cmos5l_decap_8
XFILLER_45_143 VPWR VGND sg13cmos5l_decap_8
XFILLER_18_379 VPWR VGND sg13cmos5l_decap_4
XFILLER_14_541 VPWR VGND sg13cmos5l_decap_8
XFILLER_41_360 VPWR VGND sg13cmos5l_fill_2
XFILLER_14_563 VPWR VGND sg13cmos5l_decap_4
X_2520_ _2520_/Y _2521_/B _2521_/C _2399_/X VPWR VGND sg13cmos5l_a21oi_1
XFILLER_5_261 VPWR VGND sg13cmos5l_fill_2
X_2451_ _2452_/B _2438_/B _1949_/Y _2451_/S VPWR VGND sg13cmos5l_mux2_1
X_2382_ _2382_/X _2376_/A _2376_/B _2406_/A VPWR VGND sg13cmos5l_a21o_1
XFILLER_49_482 VPWR VGND sg13cmos5l_fill_1
XFILLER_49_471 VPWR VGND sg13cmos5l_decap_8
X_3003_ _3003_/Y _3187_/A _3640_/Q VPWR VGND sg13cmos5l_nor2_1
Xinput4 input4/X ui_in[2] VPWR VGND sg13cmos5l_buf_1
XFILLER_24_305 VPWR VGND sg13cmos5l_decap_8
XFILLER_24_316 VPWR VGND sg13cmos5l_fill_1
XFILLER_24_327 VPWR VGND sg13cmos5l_decap_4
Xclkbuf_2_1__f_clk clkbuf_leaf_9_clk/A clkbuf_0_clk/X VPWR VGND sg13cmos5l_buf_8
XFILLER_40_809 VPWR VGND sg13cmos5l_decap_8
XFILLER_33_872 VPWR VGND sg13cmos5l_decap_8
X_3767_ _3767_/Q clkload4/A _3767_/D _3767_/RESET_B VPWR VGND sg13cmos5l_dfrbpq_1
X_2718_ _2718_/Y _2707_/Y _2712_/B _2717_/Y VPWR VGND sg13cmos5l_o21ai_1
XFILLER_10_14 VPWR VGND sg13cmos5l_decap_8
X_3698_ _3698_/Q _3698_/CLK _3698_/D _3698_/RESET_B VPWR VGND sg13cmos5l_dfrbpq_1
X_2649_ _3519_/D input13/X hold559/X _2649_/S VPWR VGND sg13cmos5l_mux2_1
XFILLER_0_916 VPWR VGND sg13cmos5l_decap_8
XFILLER_19_78 VPWR VGND sg13cmos5l_decap_8
XFILLER_16_806 VPWR VGND sg13cmos5l_fill_2
XFILLER_35_22 VPWR VGND sg13cmos5l_fill_1
XFILLER_15_338 VPWR VGND sg13cmos5l_decap_8
XFILLER_24_861 VPWR VGND sg13cmos5l_decap_8
XFILLER_24_872 VPWR VGND sg13cmos5l_fill_1
XFILLER_35_88 VPWR VGND sg13cmos5l_fill_2
XFILLER_11_522 VPWR VGND sg13cmos5l_decap_8
XFILLER_11_577 VPWR VGND sg13cmos5l_fill_2
X_3489__394 _3489_/RESET_B VPWR VGND sg13cmos5l_tiehi
XFILLER_3_787 VPWR VGND sg13cmos5l_decap_8
XFILLER_38_419 VPWR VGND sg13cmos5l_decap_4
XFILLER_47_975 VPWR VGND sg13cmos5l_decap_8
XFILLER_20_1015 VPWR VGND sg13cmos5l_decap_8
XFILLER_18_198 VPWR VGND sg13cmos5l_fill_2
XFILLER_33_168 VPWR VGND sg13cmos5l_decap_8
X_3496__387 _3496_/RESET_B VPWR VGND sg13cmos5l_tiehi
X_1951_ _1951_/Y _1951_/A VPWR VGND sg13cmos5l_inv_1
XFILLER_15_883 VPWR VGND sg13cmos5l_decap_8
XFILLER_14_393 VPWR VGND sg13cmos5l_decap_8
X_3621_ _3621_/Q _3666_/CLK _3621_/D _3621_/RESET_B VPWR VGND sg13cmos5l_dfrbpq_1
XFILLER_30_886 VPWR VGND sg13cmos5l_decap_8
X_3552_ _3552_/Q clkload5/A _3552_/D _3552_/RESET_B VPWR VGND sg13cmos5l_dfrbpq_1
X_2503_ _2503_/Y _2399_/S _2401_/Y _2501_/A _2501_/B _2402_/Y VPWR VGND sg13cmos5l_a221oi_1
X_3483_ _3483_/Q _3574_/CLK _3483_/D _3483_/RESET_B VPWR VGND sg13cmos5l_dfrbpq_1
X_2434_ _2434_/Y _2434_/A _2434_/B _2434_/C VPWR VGND sg13cmos5l_nor3_1
XFILLER_37_0 VPWR VGND sg13cmos5l_decap_4
X_2365_ _2385_/B _3792_/Q _3791_/Q _2428_/B VPWR VGND sg13cmos5l_nor3_1
XFILLER_38_942 VPWR VGND sg13cmos5l_decap_8
X_2296_ _2296_/Y _1928_/Y _3020_/A2 _2295_/Y VPWR VGND sg13cmos5l_a21oi_1
XFILLER_37_452 VPWR VGND sg13cmos5l_fill_2
XFILLER_25_603 VPWR VGND sg13cmos5l_fill_2
XFILLER_40_606 VPWR VGND sg13cmos5l_decap_4
XFILLER_24_146 VPWR VGND sg13cmos5l_fill_2
XFILLER_36_1022 VPWR VGND sg13cmos5l_decap_8
XFILLER_4_518 VPWR VGND sg13cmos5l_decap_8
XFILLER_21_68 VPWR VGND sg13cmos5l_decap_8
XFILLER_43_1004 VPWR VGND sg13cmos5l_decap_8
XFILLER_29_931 VPWR VGND sg13cmos5l_decap_8
XFILLER_16_614 VPWR VGND sg13cmos5l_decap_8
XFILLER_28_463 VPWR VGND sg13cmos5l_decap_8
XFILLER_44_945 VPWR VGND sg13cmos5l_decap_8
XFILLER_43_444 VPWR VGND sg13cmos5l_decap_8
XFILLER_12_831 VPWR VGND sg13cmos5l_decap_8
XFILLER_12_842 VPWR VGND sg13cmos5l_fill_1
XFILLER_8_835 VPWR VGND sg13cmos5l_decap_8
XFILLER_7_15 VPWR VGND sg13cmos5l_decap_8
XFILLER_11_374 VPWR VGND sg13cmos5l_decap_4
XFILLER_12_875 VPWR VGND sg13cmos5l_decap_8
XFILLER_7_48 VPWR VGND sg13cmos5l_fill_1
Xheichips26_dna_sequencer_97 uio_out[5] VPWR VGND sg13cmos5l_tielo
Xheichips26_dna_sequencer_86 uio_oe[2] VPWR VGND sg13cmos5l_tielo
XFILLER_39_728 VPWR VGND sg13cmos5l_fill_1
X_2150_ _2150_/Y _2150_/A _2150_/B VPWR VGND sg13cmos5l_nor2_1
X_2081_ _2156_/A _2155_/B _2155_/C _2155_/A VPWR VGND sg13cmos5l_a21o_1
XFILLER_47_772 VPWR VGND sg13cmos5l_decap_8
X_2983_ _2983_/Y _3592_/Q _2987_/A VPWR VGND sg13cmos5l_nor2_1
XFILLER_21_116 VPWR VGND sg13cmos5l_fill_2
XFILLER_34_488 VPWR VGND sg13cmos5l_fill_1
X_1934_ _1934_/Y _1934_/A VPWR VGND sg13cmos5l_inv_1
Xhold802 _2057_/A _2058_/A VPWR VGND sg13cmos5l_dlygate4sd3_1
X_3604_ _3604_/Q _3629_/CLK _3604_/D _3604_/RESET_B VPWR VGND sg13cmos5l_dfrbpq_1
X_3535_ _3535_/Q _3574_/CLK _3535_/D _3535_/RESET_B VPWR VGND sg13cmos5l_dfrbpq_1
XFILLER_7_890 VPWR VGND sg13cmos5l_decap_8
Xhold813 _2178_/A _3737_/Q VPWR VGND sg13cmos5l_dlygate4sd3_1
X_3466_ _3730_/D _3466_/A _3466_/B VPWR VGND sg13cmos5l_nor2_1
X_3648__187 _3648_/RESET_B VPWR VGND sg13cmos5l_tiehi
X_2417_ _2549_/A _2387_/Y _2396_/A _2393_/Y VPWR VGND sg13cmos5l_o21ai_1
X_3397_ _3398_/B _3397_/A _3397_/B VPWR VGND sg13cmos5l_xnor2_1
X_2348_ _2348_/Y _2348_/A VPWR VGND sg13cmos5l_inv_1
X_2279_ _2279_/Y _2278_/Y _2287_/A VPWR VGND sg13cmos5l_nand2b_1
XFILLER_38_761 VPWR VGND sg13cmos5l_fill_1
XFILLER_16_13 VPWR VGND sg13cmos5l_decap_8
XFILLER_26_989 VPWR VGND sg13cmos5l_decap_8
XFILLER_12_116 VPWR VGND sg13cmos5l_decap_8
XFILLER_32_89 VPWR VGND sg13cmos5l_decap_4
XFILLER_5_838 VPWR VGND sg13cmos5l_decap_8
XFILLER_0_554 VPWR VGND sg13cmos5l_decap_8
X_3486__397 _3486_/RESET_B VPWR VGND sg13cmos5l_tiehi
XFILLER_36_709 VPWR VGND sg13cmos5l_decap_4
XFILLER_29_772 VPWR VGND sg13cmos5l_decap_4
XFILLER_16_433 VPWR VGND sg13cmos5l_decap_8
XFILLER_31_436 VPWR VGND sg13cmos5l_decap_8
XFILLER_31_447 VPWR VGND sg13cmos5l_fill_2
XFILLER_12_661 VPWR VGND sg13cmos5l_decap_8
XFILLER_8_654 VPWR VGND sg13cmos5l_decap_8
XFILLER_12_683 VPWR VGND sg13cmos5l_decap_8
XFILLER_7_164 VPWR VGND sg13cmos5l_decap_8
XFILLER_4_860 VPWR VGND sg13cmos5l_decap_8
X_3320_ _3320_/Y _3320_/A _3466_/A _3320_/C VPWR VGND sg13cmos5l_nand3_1
X_3251_ _3251_/Y hold803/X _3265_/A VPWR VGND sg13cmos5l_nand2b_1
XFILLER_26_1010 VPWR VGND sg13cmos5l_decap_8
X_2202_ _2512_/A _2202_/A _2202_/B VPWR VGND sg13cmos5l_nor2_1
X_3182_ _3182_/Y _3203_/A _3344_/A2 _3186_/A VPWR VGND sg13cmos5l_o21ai_1
X_2133_ _2232_/A _2305_/A _2228_/B VPWR VGND sg13cmos5l_nand2_1
X_2064_ _2064_/X _2214_/A _2228_/B VPWR VGND sg13cmos5l_and2_1
XFILLER_19_271 VPWR VGND sg13cmos5l_decap_8
XFILLER_23_915 VPWR VGND sg13cmos5l_fill_1
XFILLER_34_252 VPWR VGND sg13cmos5l_fill_2
XFILLER_22_403 VPWR VGND sg13cmos5l_fill_1
XFILLER_34_274 VPWR VGND sg13cmos5l_decap_8
XFILLER_22_436 VPWR VGND sg13cmos5l_decap_8
X_2966_ _3615_/D _3030_/B _2966_/B VPWR VGND sg13cmos5l_and2_1
XFILLER_31_970 VPWR VGND sg13cmos5l_decap_8
X_2897_ _2897_/Y _2891_/B _2894_/Y _2911_/B VPWR VGND sg13cmos5l_o21ai_1
Xhold610 _3510_/D _2636_/X VPWR VGND sg13cmos5l_dlygate4sd3_1
Xhold621 _2455_/B _3778_/Q VPWR VGND sg13cmos5l_dlygate4sd3_1
Xhold654 hold654/X _2699_/Y VPWR VGND sg13cmos5l_dlygate4sd3_1
Xhold632 _2587_/A _3799_/Q VPWR VGND sg13cmos5l_dlygate4sd3_1
Xhold643 _2725_/B _2724_/Y VPWR VGND sg13cmos5l_dlygate4sd3_1
X_3518_ _3518_/Q _3574_/CLK _3518_/D _3518_/RESET_B VPWR VGND sg13cmos5l_dfrbpq_1
Xhold676 _3714_/D _3446_/Y VPWR VGND sg13cmos5l_dlygate4sd3_1
Xhold687 _3654_/D _3176_/Y VPWR VGND sg13cmos5l_dlygate4sd3_1
Xhold665 _2009_/A _3651_/Q VPWR VGND sg13cmos5l_dlygate4sd3_1
X_3449_ _3449_/X _2256_/B _3439_/Y _3449_/S VPWR VGND sg13cmos5l_mux2_1
Xhold698 _2027_/C _3795_/Q VPWR VGND sg13cmos5l_dlygate4sd3_1
XFILLER_40_1007 VPWR VGND sg13cmos5l_decap_8
XFILLER_38_580 VPWR VGND sg13cmos5l_decap_8
XFILLER_27_78 VPWR VGND sg13cmos5l_fill_1
XFILLER_14_915 VPWR VGND sg13cmos5l_decap_8
XFILLER_26_764 VPWR VGND sg13cmos5l_decap_8
XFILLER_40_200 VPWR VGND sg13cmos5l_decap_8
XFILLER_13_414 VPWR VGND sg13cmos5l_fill_2
XFILLER_9_407 VPWR VGND sg13cmos5l_fill_1
XFILLER_13_436 VPWR VGND sg13cmos5l_fill_1
XFILLER_13_447 VPWR VGND sg13cmos5l_decap_4
XFILLER_14_959 VPWR VGND sg13cmos5l_decap_8
XFILLER_9_418 VPWR VGND sg13cmos5l_decap_8
XFILLER_22_981 VPWR VGND sg13cmos5l_decap_8
XFILLER_5_613 VPWR VGND sg13cmos5l_decap_8
XFILLER_4_134 VPWR VGND sg13cmos5l_decap_8
X_3564__303 _3564_/RESET_B VPWR VGND sg13cmos5l_tiehi
XFILLER_0_351 VPWR VGND sg13cmos5l_decap_8
XFILLER_1_885 VPWR VGND sg13cmos5l_decap_8
XFILLER_49_845 VPWR VGND sg13cmos5l_decap_8
XFILLER_36_517 VPWR VGND sg13cmos5l_decap_8
XFILLER_44_561 VPWR VGND sg13cmos5l_decap_8
XFILLER_16_285 VPWR VGND sg13cmos5l_decap_8
XFILLER_32_745 VPWR VGND sg13cmos5l_decap_4
X_3638__197 _3638_/RESET_B VPWR VGND sg13cmos5l_tiehi
X_2820_ _2821_/B _2683_/B _2818_/X _2819_/X _2790_/Y VPWR VGND sg13cmos5l_a22oi_1
XFILLER_13_981 VPWR VGND sg13cmos5l_decap_8
XFILLER_9_941 VPWR VGND sg13cmos5l_decap_8
X_2751_ _2756_/A _2751_/A _2751_/B VPWR VGND sg13cmos5l_nor2_1
XFILLER_31_299 VPWR VGND sg13cmos5l_decap_8
X_2682_ _2683_/B _3569_/Q _2682_/B VPWR VGND sg13cmos5l_and2_1
X_3645__113 _3645_/D VPWR VGND sg13cmos5l_tielo
X_3303_ _3680_/D _3303_/A _3353_/B VPWR VGND sg13cmos5l_nor2_1
X_3234_ _3669_/D _3223_/A _3227_/Y _3233_/Y VPWR VGND sg13cmos5l_a21oi_1
X_3165_ _3165_/Y _3653_/Q _3162_/Y _3164_/Y _3175_/B VPWR VGND sg13cmos5l_a22oi_1
X_2116_ _2116_/Y _3705_/Q _3704_/Q VPWR VGND sg13cmos5l_nor2b_1
X_3096_ _3096_/Y _3114_/A _3093_/A _3287_/A VPWR VGND sg13cmos5l_o21ai_1
X_2047_ _2049_/A _3680_/Q _2104_/A VPWR VGND sg13cmos5l_xor2_1
XFILLER_23_712 VPWR VGND sg13cmos5l_decap_8
XFILLER_23_723 VPWR VGND sg13cmos5l_fill_1
Xfanout37 _2561_/A _2558_/A VPWR VGND sg13cmos5l_buf_1
Xfanout26 _3181_/A2 _2293_/X VPWR VGND sg13cmos5l_buf_1
Xfanout48 _3466_/B _3471_/A VPWR VGND sg13cmos5l_buf_1
Xfanout59 _2790_/A _3568_/Q VPWR VGND sg13cmos5l_buf_1
X_2949_ _2949_/Y _3614_/Q _2949_/B VPWR VGND sg13cmos5l_xnor2_1
XFILLER_10_439 VPWR VGND sg13cmos5l_decap_4
XFILLER_2_638 VPWR VGND sg13cmos5l_decap_8
XFILLER_2_649 VPWR VGND sg13cmos5l_fill_1
Xhold495 _3548_/D _2695_/Y VPWR VGND sg13cmos5l_dlygate4sd3_1
Xhold473 _1929_/A _3688_/Q VPWR VGND sg13cmos5l_dlygate4sd3_1
Xhold484 _1990_/A _3522_/Q VPWR VGND sg13cmos5l_dlygate4sd3_1
XFILLER_1_159 VPWR VGND sg13cmos5l_decap_8
XFILLER_46_804 VPWR VGND sg13cmos5l_decap_8
XFILLER_45_325 VPWR VGND sg13cmos5l_decap_8
XFILLER_38_99 VPWR VGND sg13cmos5l_decap_8
XFILLER_18_539 VPWR VGND sg13cmos5l_decap_8
XFILLER_33_509 VPWR VGND sg13cmos5l_decap_8
XFILLER_13_222 VPWR VGND sg13cmos5l_fill_2
XFILLER_41_564 VPWR VGND sg13cmos5l_decap_4
XFILLER_9_204 VPWR VGND sg13cmos5l_decap_8
XFILLER_6_911 VPWR VGND sg13cmos5l_decap_8
XFILLER_10_973 VPWR VGND sg13cmos5l_decap_8
XFILLER_6_988 VPWR VGND sg13cmos5l_decap_8
XFILLER_5_454 VPWR VGND sg13cmos5l_fill_2
XFILLER_1_693 VPWR VGND sg13cmos5l_fill_2
XFILLER_0_192 VPWR VGND sg13cmos5l_decap_8
XFILLER_48_185 VPWR VGND sg13cmos5l_fill_2
XFILLER_36_336 VPWR VGND sg13cmos5l_fill_1
X_3675__139 _3675_/RESET_B VPWR VGND sg13cmos5l_tiehi
XFILLER_17_583 VPWR VGND sg13cmos5l_fill_1
X_2803_ _2803_/X _3533_/Q _3516_/Q _3499_/Q _3482_/Q _2826_/A1 _2826_/B1 VPWR VGND
+ sg13cmos5l_mux4_1
X_3783_ _3783_/Q _3783_/CLK _3783_/D _3783_/RESET_B VPWR VGND sg13cmos5l_dfrbpq_1
XFILLER_30_1017 VPWR VGND sg13cmos5l_decap_8
X_2734_ _2734_/Y _2737_/A1 hold501/X _2597_/C VPWR VGND sg13cmos5l_o21ai_1
XFILLER_30_1028 VPWR VGND sg13cmos5l_fill_1
X_2665_ _3530_/D input7/X hold608/X _2671_/S VPWR VGND sg13cmos5l_mux2_1
X_2596_ _2607_/C _2596_/A _2717_/C VPWR VGND sg13cmos5l_nand2_1
XFILLER_28_815 VPWR VGND sg13cmos5l_decap_8
X_3217_ _3218_/B _3222_/B _3217_/B _3221_/B VPWR VGND sg13cmos5l_nand3b_1
X_3148_ _3148_/Y _3624_/Q _3350_/A _3671_/Q _3147_/Y VPWR VGND sg13cmos5l_a22oi_1
X_3697__320 _3697_/RESET_B VPWR VGND sg13cmos5l_tiehi
XFILLER_27_336 VPWR VGND sg13cmos5l_decap_8
XFILLER_27_358 VPWR VGND sg13cmos5l_decap_8
XFILLER_42_306 VPWR VGND sg13cmos5l_fill_1
X_3079_ _3092_/B _3643_/Q _3641_/Q _3642_/Q VPWR VGND sg13cmos5l_or3_1
XFILLER_24_46 VPWR VGND sg13cmos5l_decap_4
XFILLER_40_78 VPWR VGND sg13cmos5l_decap_8
XFILLER_6_4 VPWR VGND sg13cmos5l_fill_1
XFILLER_3_969 VPWR VGND sg13cmos5l_decap_8
XFILLER_2_468 VPWR VGND sg13cmos5l_decap_8
XFILLER_1_28 VPWR VGND sg13cmos5l_decap_8
XFILLER_45_111 VPWR VGND sg13cmos5l_decap_8
XFILLER_1_39 VPWR VGND sg13cmos5l_fill_1
XFILLER_18_347 VPWR VGND sg13cmos5l_decap_8
XFILLER_18_358 VPWR VGND sg13cmos5l_decap_8
XFILLER_46_689 VPWR VGND sg13cmos5l_decap_8
XFILLER_45_177 VPWR VGND sg13cmos5l_fill_1
X_3739__158 _3739_/RESET_B VPWR VGND sg13cmos5l_tiehi
XFILLER_45_199 VPWR VGND sg13cmos5l_decap_8
XFILLER_42_895 VPWR VGND sg13cmos5l_decap_8
XFILLER_41_372 VPWR VGND sg13cmos5l_fill_1
XFILLER_14_597 VPWR VGND sg13cmos5l_decap_4
XFILLER_6_730 VPWR VGND sg13cmos5l_fill_1
XFILLER_6_752 VPWR VGND sg13cmos5l_decap_8
XFILLER_6_741 VPWR VGND sg13cmos5l_fill_1
XFILLER_5_240 VPWR VGND sg13cmos5l_decap_4
XFILLER_5_273 VPWR VGND sg13cmos5l_decap_8
X_2450_ _3775_/D _2558_/A _2450_/B VPWR VGND sg13cmos5l_nor2_1
XFILLER_39_4 VPWR VGND sg13cmos5l_decap_8
X_2381_ _2381_/Y _2406_/A _2376_/X _2379_/X _1967_/Y _2380_/Y VPWR VGND sg13cmos5l_a221oi_1
X_3002_ _3002_/Y _3623_/Q _3002_/B VPWR VGND sg13cmos5l_nor2_1
Xinput5 input5/X ui_in[3] VPWR VGND sg13cmos5l_buf_1
XFILLER_36_144 VPWR VGND sg13cmos5l_decap_8
XFILLER_25_829 VPWR VGND sg13cmos5l_fill_2
XFILLER_36_166 VPWR VGND sg13cmos5l_decap_4
XFILLER_17_380 VPWR VGND sg13cmos5l_decap_4
XFILLER_18_892 VPWR VGND sg13cmos5l_decap_8
XFILLER_32_361 VPWR VGND sg13cmos5l_decap_8
XFILLER_32_372 VPWR VGND sg13cmos5l_fill_1
X_3766_ _3766_/Q _3766_/CLK _3766_/D _3766_/RESET_B VPWR VGND sg13cmos5l_dfrbpq_1
X_2717_ _2717_/Y _2708_/A _2717_/B _2717_/C VPWR VGND sg13cmos5l_nand3b_1
X_3697_ _3697_/Q _3698_/CLK _3697_/D _3697_/RESET_B VPWR VGND sg13cmos5l_dfrbpq_1
X_2648_ _3518_/D input12/X hold636/X _2648_/S VPWR VGND sg13cmos5l_mux2_1
X_2579_ _2592_/A _2579_/A _2579_/B _2579_/C VPWR VGND sg13cmos5l_or3_1
XFILLER_19_35 VPWR VGND sg13cmos5l_fill_1
XFILLER_43_615 VPWR VGND sg13cmos5l_decap_8
XFILLER_24_840 VPWR VGND sg13cmos5l_decap_8
XFILLER_27_199 VPWR VGND sg13cmos5l_fill_2
XFILLER_30_309 VPWR VGND sg13cmos5l_decap_8
XFILLER_11_501 VPWR VGND sg13cmos5l_decap_8
XFILLER_7_516 VPWR VGND sg13cmos5l_fill_1
XFILLER_13_1023 VPWR VGND sg13cmos5l_decap_4
XFILLER_3_711 VPWR VGND sg13cmos5l_decap_8
XFILLER_2_243 VPWR VGND sg13cmos5l_decap_8
XFILLER_2_276 VPWR VGND sg13cmos5l_fill_2
XFILLER_47_954 VPWR VGND sg13cmos5l_decap_8
XFILLER_46_420 VPWR VGND sg13cmos5l_decap_8
XFILLER_18_133 VPWR VGND sg13cmos5l_decap_8
XFILLER_19_645 VPWR VGND sg13cmos5l_decap_4
XFILLER_46_486 VPWR VGND sg13cmos5l_decap_8
XFILLER_46_464 VPWR VGND sg13cmos5l_decap_4
XFILLER_34_615 VPWR VGND sg13cmos5l_decap_8
XFILLER_14_361 VPWR VGND sg13cmos5l_decap_8
XFILLER_14_372 VPWR VGND sg13cmos5l_fill_1
X_1950_ _1950_/Y _1950_/A VPWR VGND sg13cmos5l_inv_1
X_3717__275 _3717_/RESET_B VPWR VGND sg13cmos5l_tiehi
XFILLER_30_843 VPWR VGND sg13cmos5l_decap_4
XFILLER_30_865 VPWR VGND sg13cmos5l_decap_8
X_3620_ _3620_/Q _3665_/CLK _3620_/D _3620_/RESET_B VPWR VGND sg13cmos5l_dfrbpq_1
XFILLER_30_898 VPWR VGND sg13cmos5l_decap_8
X_3551_ _3551_/Q clkload5/A _3551_/D _3551_/RESET_B VPWR VGND sg13cmos5l_dfrbpq_1
X_2502_ _2502_/Y _2527_/A VPWR VGND sg13cmos5l_inv_1
X_3482_ _3482_/Q _3574_/CLK _3482_/D _3482_/RESET_B VPWR VGND sg13cmos5l_dfrbpq_1
X_2433_ _2434_/C _2431_/Y _2433_/B VPWR VGND sg13cmos5l_nand2b_1
X_2364_ _2468_/B _2364_/A _2597_/C VPWR VGND sg13cmos5l_nand2_1
XFILLER_2_71 VPWR VGND sg13cmos5l_fill_1
X_2295_ _2295_/Y _3752_/Q _3020_/A2 _3459_/A VPWR VGND sg13cmos5l_o21ai_1
XFILLER_38_998 VPWR VGND sg13cmos5l_decap_8
XFILLER_37_475 VPWR VGND sg13cmos5l_fill_1
XFILLER_37_464 VPWR VGND sg13cmos5l_fill_2
XFILLER_24_103 VPWR VGND sg13cmos5l_decap_8
XFILLER_36_1001 VPWR VGND sg13cmos5l_decap_8
XFILLER_21_832 VPWR VGND sg13cmos5l_fill_2
XFILLER_21_898 VPWR VGND sg13cmos5l_decap_8
X_3749_ _3749_/Q clkload1/A _3749_/D _3749_/RESET_B VPWR VGND sg13cmos5l_dfrbpq_1
XFILLER_0_769 VPWR VGND sg13cmos5l_decap_8
X_3703__308 _3703_/RESET_B VPWR VGND sg13cmos5l_tiehi
XFILLER_47_228 VPWR VGND sg13cmos5l_decap_8
XFILLER_28_420 VPWR VGND sg13cmos5l_fill_1
XFILLER_44_924 VPWR VGND sg13cmos5l_decap_8
XFILLER_16_604 VPWR VGND sg13cmos5l_decap_8
XFILLER_29_987 VPWR VGND sg13cmos5l_decap_8
XFILLER_43_423 VPWR VGND sg13cmos5l_decap_8
XFILLER_16_648 VPWR VGND sg13cmos5l_fill_1
XFILLER_16_659 VPWR VGND sg13cmos5l_decap_8
XFILLER_43_456 VPWR VGND sg13cmos5l_decap_8
XFILLER_24_692 VPWR VGND sg13cmos5l_decap_4
XFILLER_7_346 VPWR VGND sg13cmos5l_decap_8
XFILLER_11_397 VPWR VGND sg13cmos5l_decap_8
XFILLER_7_379 VPWR VGND sg13cmos5l_decap_8
XFILLER_3_563 VPWR VGND sg13cmos5l_fill_2
XFILLER_3_541 VPWR VGND sg13cmos5l_fill_1
Xheichips26_dna_sequencer_98 uio_out[6] VPWR VGND sg13cmos5l_tielo
Xheichips26_dna_sequencer_87 uio_oe[3] VPWR VGND sg13cmos5l_tielo
XFILLER_47_751 VPWR VGND sg13cmos5l_decap_8
XFILLER_4_1021 VPWR VGND sg13cmos5l_decap_8
X_2080_ _2155_/C _3722_/Q _3693_/Q _3727_/Q VPWR VGND sg13cmos5l_nand3_1
XFILLER_19_453 VPWR VGND sg13cmos5l_fill_2
XFILLER_34_434 VPWR VGND sg13cmos5l_decap_8
XFILLER_22_607 VPWR VGND sg13cmos5l_decap_8
XFILLER_35_979 VPWR VGND sg13cmos5l_decap_8
X_2982_ _2982_/Y _2982_/A _2987_/A VPWR VGND sg13cmos5l_nor2_1
XFILLER_43_990 VPWR VGND sg13cmos5l_decap_8
XFILLER_22_618 VPWR VGND sg13cmos5l_fill_1
XFILLER_21_128 VPWR VGND sg13cmos5l_decap_8
XFILLER_30_640 VPWR VGND sg13cmos5l_fill_2
X_1933_ _1933_/Y _1933_/A VPWR VGND sg13cmos5l_inv_1
X_3603_ _3603_/Q _3629_/CLK _3603_/D _3603_/RESET_B VPWR VGND sg13cmos5l_dfrbpq_1
Xhold803 hold803/X _3672_/Q VPWR VGND sg13cmos5l_dlygate4sd3_1
X_3534_ _3534_/Q clkload8/A _3534_/D _3534_/RESET_B VPWR VGND sg13cmos5l_dfrbpq_1
Xhold814 _2388_/A _3772_/Q VPWR VGND sg13cmos5l_dlygate4sd3_1
X_3465_ _3729_/D _3465_/A _3466_/B VPWR VGND sg13cmos5l_nor2_1
X_2416_ _2418_/B _2393_/A _2411_/B _2396_/Y _2388_/X VPWR VGND sg13cmos5l_a22oi_1
X_3396_ _3397_/B _3396_/A _3396_/B VPWR VGND sg13cmos5l_xor2_1
X_2347_ _2348_/A _2347_/A _2347_/B VPWR VGND sg13cmos5l_nand2_1
X_2278_ _2278_/Y _2577_/B _2745_/A VPWR VGND sg13cmos5l_nor2_1
XFILLER_25_401 VPWR VGND sg13cmos5l_decap_8
XFILLER_25_412 VPWR VGND sg13cmos5l_fill_1
XFILLER_26_968 VPWR VGND sg13cmos5l_decap_8
XFILLER_41_949 VPWR VGND sg13cmos5l_decap_8
XFILLER_13_629 VPWR VGND sg13cmos5l_fill_2
XFILLER_32_24 VPWR VGND sg13cmos5l_decap_8
XFILLER_5_817 VPWR VGND sg13cmos5l_decap_8
XFILLER_10_1015 VPWR VGND sg13cmos5l_decap_8
X_3703__105 _3703_/D VPWR VGND sg13cmos5l_tielo
XFILLER_28_250 VPWR VGND sg13cmos5l_fill_1
XFILLER_29_795 VPWR VGND sg13cmos5l_fill_1
XFILLER_44_765 VPWR VGND sg13cmos5l_decap_8
XFILLER_43_220 VPWR VGND sg13cmos5l_decap_8
XFILLER_16_456 VPWR VGND sg13cmos5l_fill_2
XFILLER_32_905 VPWR VGND sg13cmos5l_fill_2
XFILLER_44_798 VPWR VGND sg13cmos5l_decap_8
XFILLER_43_275 VPWR VGND sg13cmos5l_fill_1
XFILLER_31_404 VPWR VGND sg13cmos5l_fill_2
XFILLER_40_993 VPWR VGND sg13cmos5l_decap_8
XFILLER_11_172 VPWR VGND sg13cmos5l_decap_8
XFILLER_7_143 VPWR VGND sg13cmos5l_decap_8
XFILLER_11_194 VPWR VGND sg13cmos5l_decap_8
XFILLER_3_371 VPWR VGND sg13cmos5l_decap_8
X_3250_ _3250_/Y _2056_/A _3248_/Y _3249_/Y VPWR VGND sg13cmos5l_o21ai_1
X_2201_ _3738_/D _2307_/B _2201_/B VPWR VGND sg13cmos5l_nor2_1
XFILLER_21_4 VPWR VGND sg13cmos5l_decap_8
X_3181_ _3658_/D _1934_/Y _3181_/A2 _3180_/Y VPWR VGND sg13cmos5l_a21oi_1
X_2132_ _2132_/Y _3417_/B _2132_/B _2132_/C VPWR VGND sg13cmos5l_nand3b_1
X_2063_ _2228_/B _3735_/Q _2063_/B VPWR VGND sg13cmos5l_xnor2_1
XFILLER_34_231 VPWR VGND sg13cmos5l_decap_8
XFILLER_23_949 VPWR VGND sg13cmos5l_decap_8
XFILLER_35_776 VPWR VGND sg13cmos5l_decap_4
X_2965_ _2966_/B _2949_/Y _2959_/X _2964_/Y VPWR VGND sg13cmos5l_a21o_1
X_2896_ _2896_/Y _3004_/B _2894_/Y _2895_/Y VPWR VGND sg13cmos5l_a21oi_1
X_3654__181 _3654_/RESET_B VPWR VGND sg13cmos5l_tiehi
Xhold600 hold600/X _3500_/Q VPWR VGND sg13cmos5l_dlygate4sd3_1
Xhold611 hold611/X _3540_/Q VPWR VGND sg13cmos5l_dlygate4sd3_1
X_3517_ _3517_/Q clkload8/A _3517_/D _3517_/RESET_B VPWR VGND sg13cmos5l_dfrbpq_1
Xhold644 _2014_/C _3798_/Q VPWR VGND sg13cmos5l_dlygate4sd3_1
Xhold633 _2591_/B _2590_/Y VPWR VGND sg13cmos5l_dlygate4sd3_1
Xhold622 _2919_/A _3603_/Q VPWR VGND sg13cmos5l_dlygate4sd3_1
Xhold688 _2775_/B _3576_/Q VPWR VGND sg13cmos5l_dlygate4sd3_1
XFILLER_1_308 VPWR VGND sg13cmos5l_fill_2
Xhold655 _3550_/D _2700_/Y VPWR VGND sg13cmos5l_dlygate4sd3_1
Xhold666 _3651_/D _3170_/Y VPWR VGND sg13cmos5l_dlygate4sd3_1
Xhold677 _3160_/C _3669_/Q VPWR VGND sg13cmos5l_dlygate4sd3_1
Xhold699 _2570_/B _2569_/Y VPWR VGND sg13cmos5l_dlygate4sd3_1
X_3448_ _3715_/D _3471_/A _3448_/B VPWR VGND sg13cmos5l_nor2_1
X_3379_ _3380_/B _3694_/Q _3376_/B _3364_/Y VPWR VGND sg13cmos5l_a21oi_1
XFILLER_17_209 VPWR VGND sg13cmos5l_decap_8
XFILLER_38_570 VPWR VGND sg13cmos5l_fill_1
XFILLER_27_46 VPWR VGND sg13cmos5l_decap_4
XFILLER_26_743 VPWR VGND sg13cmos5l_decap_8
XFILLER_41_724 VPWR VGND sg13cmos5l_fill_2
XFILLER_22_960 VPWR VGND sg13cmos5l_decap_8
X_3492__391 _3492_/RESET_B VPWR VGND sg13cmos5l_tiehi
XFILLER_5_603 VPWR VGND sg13cmos5l_decap_4
XFILLER_4_157 VPWR VGND sg13cmos5l_decap_4
XFILLER_4_39 VPWR VGND sg13cmos5l_fill_1
XFILLER_49_824 VPWR VGND sg13cmos5l_decap_8
XFILLER_0_341 VPWR VGND sg13cmos5l_decap_4
XFILLER_1_864 VPWR VGND sg13cmos5l_decap_8
XFILLER_0_396 VPWR VGND sg13cmos5l_decap_8
XFILLER_17_743 VPWR VGND sg13cmos5l_decap_8
XFILLER_17_787 VPWR VGND sg13cmos5l_decap_8
XFILLER_32_724 VPWR VGND sg13cmos5l_decap_8
XFILLER_20_908 VPWR VGND sg13cmos5l_fill_2
XFILLER_9_920 VPWR VGND sg13cmos5l_decap_8
XFILLER_13_960 VPWR VGND sg13cmos5l_decap_8
X_2750_ _2750_/Y _2682_/B _2751_/A _2749_/Y VPWR VGND sg13cmos5l_a21oi_1
XFILLER_31_278 VPWR VGND sg13cmos5l_decap_8
XFILLER_9_997 VPWR VGND sg13cmos5l_decap_8
X_2681_ _3545_/D input5/X hold562/X _2681_/S VPWR VGND sg13cmos5l_mux2_1
XFILLER_4_680 VPWR VGND sg13cmos5l_fill_2
X_3302_ _3353_/B _3395_/B VPWR VGND sg13cmos5l_inv_1
X_3233_ _3233_/Y _3220_/Y _3227_/Y _3108_/A VPWR VGND sg13cmos5l_o21ai_1
XFILLER_27_518 VPWR VGND sg13cmos5l_decap_8
X_3164_ _3164_/Y _3671_/Q _3670_/Q VPWR VGND sg13cmos5l_nand2b_1
X_2115_ _2115_/Y _2115_/A _2115_/B _2217_/A VPWR VGND sg13cmos5l_nand3_1
X_3095_ _3287_/A _3671_/Q _3095_/B VPWR VGND sg13cmos5l_xnor2_1
X_2046_ _2048_/B _3680_/Q _2104_/A VPWR VGND sg13cmos5l_nor2_1
Xfanout27 _2399_/S _2397_/X VPWR VGND sg13cmos5l_buf_1
Xfanout38 _2558_/A _2468_/B VPWR VGND sg13cmos5l_buf_1
XFILLER_11_919 VPWR VGND sg13cmos5l_decap_8
Xfanout49 _3471_/A _2044_/Y VPWR VGND sg13cmos5l_buf_1
XFILLER_22_245 VPWR VGND sg13cmos5l_fill_2
XFILLER_23_779 VPWR VGND sg13cmos5l_decap_4
X_2948_ _2964_/B _3190_/A _3133_/C VPWR VGND sg13cmos5l_xnor2_1
X_2879_ _2880_/B _1944_/Y _3029_/A _3610_/Q VPWR VGND sg13cmos5l_o21ai_1
Xhold485 _1992_/A _3515_/Q VPWR VGND sg13cmos5l_dlygate4sd3_1
Xhold496 _2301_/B _3723_/Q VPWR VGND sg13cmos5l_dlygate4sd3_1
Xhold474 _3720_/D _3454_/Y VPWR VGND sg13cmos5l_dlygate4sd3_1
XFILLER_45_359 VPWR VGND sg13cmos5l_decap_8
XFILLER_41_554 VPWR VGND sg13cmos5l_fill_1
XFILLER_10_930 VPWR VGND sg13cmos5l_decap_8
XFILLER_10_952 VPWR VGND sg13cmos5l_decap_8
XFILLER_6_967 VPWR VGND sg13cmos5l_decap_8
XFILLER_1_661 VPWR VGND sg13cmos5l_fill_1
X_3644__191 _3644_/RESET_B VPWR VGND sg13cmos5l_tiehi
XFILLER_48_197 VPWR VGND sg13cmos5l_decap_4
XFILLER_45_882 VPWR VGND sg13cmos5l_decap_8
XFILLER_17_573 VPWR VGND sg13cmos5l_fill_2
XFILLER_44_381 VPWR VGND sg13cmos5l_fill_1
XFILLER_32_532 VPWR VGND sg13cmos5l_decap_4
X_3575__285 _3575_/RESET_B VPWR VGND sg13cmos5l_tiehi
X_3782_ _3782_/Q _3783_/CLK _3782_/D _3782_/RESET_B VPWR VGND sg13cmos5l_dfrbpq_1
XFILLER_20_749 VPWR VGND sg13cmos5l_fill_2
X_2802_ _2802_/Y _2790_/A _2794_/X _2801_/Y VPWR VGND sg13cmos5l_o21ai_1
X_2733_ _3564_/D _2737_/A1 _2442_/A _2732_/Y VPWR VGND sg13cmos5l_a21oi_1
XFILLER_9_761 VPWR VGND sg13cmos5l_decap_4
X_3651__184 _3651_/RESET_B VPWR VGND sg13cmos5l_tiehi
XFILLER_8_293 VPWR VGND sg13cmos5l_fill_2
X_2664_ _3529_/D input6/X hold617/X _2671_/S VPWR VGND sg13cmos5l_mux2_1
X_2595_ _2595_/Y _2592_/X hold542/X _3075_/A VPWR VGND sg13cmos5l_a21oi_1
XFILLER_5_71 VPWR VGND sg13cmos5l_fill_2
X_3216_ _3217_/B _3216_/A _3216_/B VPWR VGND sg13cmos5l_or2_1
X_3147_ _3147_/Y _3625_/Q _3670_/Q VPWR VGND sg13cmos5l_nand2_1
XFILLER_43_819 VPWR VGND sg13cmos5l_fill_2
X_3078_ _3109_/A _3088_/A _3669_/Q VPWR VGND sg13cmos5l_xnor2_1
XFILLER_36_893 VPWR VGND sg13cmos5l_decap_8
X_2029_ _2286_/B _2277_/A _2029_/B VPWR VGND sg13cmos5l_nor2_1
XFILLER_23_565 VPWR VGND sg13cmos5l_fill_1
XFILLER_24_25 VPWR VGND sg13cmos5l_decap_8
XFILLER_24_69 VPWR VGND sg13cmos5l_decap_8
XFILLER_10_248 VPWR VGND sg13cmos5l_decap_8
XFILLER_6_219 VPWR VGND sg13cmos5l_decap_8
XFILLER_40_46 VPWR VGND sg13cmos5l_decap_8
XFILLER_49_11 VPWR VGND sg13cmos5l_fill_1
XFILLER_46_1014 VPWR VGND sg13cmos5l_decap_8
XFILLER_3_948 VPWR VGND sg13cmos5l_decap_8
XFILLER_2_447 VPWR VGND sg13cmos5l_decap_8
XFILLER_49_44 VPWR VGND sg13cmos5l_fill_2
XFILLER_2_458 VPWR VGND sg13cmos5l_fill_2
XFILLER_49_88 VPWR VGND sg13cmos5l_fill_2
XFILLER_49_99 VPWR VGND sg13cmos5l_decap_4
XFILLER_27_893 VPWR VGND sg13cmos5l_decap_8
XFILLER_42_874 VPWR VGND sg13cmos5l_decap_8
XFILLER_41_384 VPWR VGND sg13cmos5l_fill_2
XFILLER_41_362 VPWR VGND sg13cmos5l_fill_1
XFILLER_14_576 VPWR VGND sg13cmos5l_decap_8
XFILLER_10_782 VPWR VGND sg13cmos5l_decap_8
X_2380_ _2380_/Y _2428_/B _3769_/Q _2377_/Y VPWR VGND sg13cmos5l_a21oi_1
XFILLER_49_451 VPWR VGND sg13cmos5l_fill_1
XFILLER_49_440 VPWR VGND sg13cmos5l_decap_8
X_3001_ _3002_/B _2946_/Y _2998_/Y _2999_/Y _3000_/Y VPWR VGND sg13cmos5l_a22oi_1
Xinput6 input6/X uio_in[0] VPWR VGND sg13cmos5l_buf_1
XFILLER_36_123 VPWR VGND sg13cmos5l_fill_2
XFILLER_33_852 VPWR VGND sg13cmos5l_decap_8
XFILLER_20_535 VPWR VGND sg13cmos5l_fill_2
X_3765_ _3765_/Q clkload3/A _3765_/D _3765_/RESET_B VPWR VGND sg13cmos5l_dfrbpq_1
X_2716_ _3555_/D _2716_/A _2714_/Y VPWR VGND sg13cmos5l_nor2b_1
X_3696_ _3696_/Q _3698_/CLK _3696_/D _3696_/RESET_B VPWR VGND sg13cmos5l_dfrbpq_1
X_2647_ _3517_/D input11/X hold564/X _2649_/S VPWR VGND sg13cmos5l_mux2_1
X_2578_ _2579_/C _3803_/Q _3801_/Q _2578_/C VPWR VGND sg13cmos5l_nor3_1
XFILLER_19_25 VPWR VGND sg13cmos5l_decap_4
XFILLER_19_47 VPWR VGND sg13cmos5l_decap_8
XFILLER_19_58 VPWR VGND sg13cmos5l_fill_2
XFILLER_16_808 VPWR VGND sg13cmos5l_fill_1
XFILLER_27_156 VPWR VGND sg13cmos5l_decap_8
XFILLER_35_46 VPWR VGND sg13cmos5l_decap_8
XFILLER_13_1002 VPWR VGND sg13cmos5l_decap_8
XFILLER_3_767 VPWR VGND sg13cmos5l_fill_2
XFILLER_3_756 VPWR VGND sg13cmos5l_decap_8
X_3745__152 _3745_/RESET_B VPWR VGND sg13cmos5l_tiehi
XFILLER_47_933 VPWR VGND sg13cmos5l_decap_8
X_3641__194 _3641_/RESET_B VPWR VGND sg13cmos5l_tiehi
XFILLER_33_115 VPWR VGND sg13cmos5l_decap_8
XFILLER_42_671 VPWR VGND sg13cmos5l_decap_8
XFILLER_41_192 VPWR VGND sg13cmos5l_fill_2
XFILLER_41_181 VPWR VGND sg13cmos5l_decap_8
X_3572__288 _3572_/RESET_B VPWR VGND sg13cmos5l_tiehi
X_3550_ _3550_/Q clkload1/A _3550_/D _3550_/RESET_B VPWR VGND sg13cmos5l_dfrbpq_1
XFILLER_6_572 VPWR VGND sg13cmos5l_decap_8
X_2501_ _2527_/A _2501_/A _2501_/B VPWR VGND sg13cmos5l_and2_1
XFILLER_6_583 VPWR VGND sg13cmos5l_fill_1
X_3481_ _3481_/Q _3629_/CLK _3481_/D _3481_/RESET_B VPWR VGND sg13cmos5l_dfrbpq_1
X_2432_ _2433_/B _3794_/Q _2439_/B _3789_/Q VPWR VGND sg13cmos5l_nand3b_1
X_2363_ _2465_/B _2363_/A _3801_/D VPWR VGND sg13cmos5l_nor2_1
XFILLER_38_900 VPWR VGND sg13cmos5l_fill_1
X_2294_ _2835_/A _2742_/A _2294_/B VPWR VGND sg13cmos5l_nand2_1
XFILLER_37_410 VPWR VGND sg13cmos5l_decap_8
XFILLER_38_977 VPWR VGND sg13cmos5l_decap_8
XFILLER_37_454 VPWR VGND sg13cmos5l_fill_1
XFILLER_37_498 VPWR VGND sg13cmos5l_decap_4
XFILLER_24_148 VPWR VGND sg13cmos5l_fill_1
XFILLER_33_682 VPWR VGND sg13cmos5l_decap_8
XFILLER_32_181 VPWR VGND sg13cmos5l_fill_1
X_3748_ _3748_/Q clkload1/A _3748_/D _3748_/RESET_B VPWR VGND sg13cmos5l_dfrbpq_1
XFILLER_20_398 VPWR VGND sg13cmos5l_decap_8
XFILLER_21_15 VPWR VGND sg13cmos5l_fill_1
X_3679_ _3679_/Q _3712_/CLK _3679_/D _3679_/RESET_B VPWR VGND sg13cmos5l_dfrbpq_1
XFILLER_0_726 VPWR VGND sg13cmos5l_decap_4
XFILLER_0_748 VPWR VGND sg13cmos5l_decap_8
XFILLER_48_719 VPWR VGND sg13cmos5l_fill_1
XFILLER_29_966 VPWR VGND sg13cmos5l_decap_8
XFILLER_44_903 VPWR VGND sg13cmos5l_decap_8
XFILLER_24_671 VPWR VGND sg13cmos5l_decap_8
XFILLER_11_310 VPWR VGND sg13cmos5l_decap_4
XFILLER_23_192 VPWR VGND sg13cmos5l_decap_8
XFILLER_30_129 VPWR VGND sg13cmos5l_decap_8
XFILLER_7_28 VPWR VGND sg13cmos5l_decap_4
XFILLER_11_354 VPWR VGND sg13cmos5l_fill_2
XFILLER_7_325 VPWR VGND sg13cmos5l_decap_8
XFILLER_7_39 VPWR VGND sg13cmos5l_decap_8
XFILLER_7_358 VPWR VGND sg13cmos5l_decap_8
XFILLER_3_553 VPWR VGND sg13cmos5l_fill_1
Xheichips26_dna_sequencer_99 uio_out[7] VPWR VGND sg13cmos5l_tielo
Xheichips26_dna_sequencer_88 uio_oe[4] VPWR VGND sg13cmos5l_tielo
XFILLER_39_719 VPWR VGND sg13cmos5l_decap_8
XFILLER_4_1000 VPWR VGND sg13cmos5l_decap_8
XFILLER_19_432 VPWR VGND sg13cmos5l_decap_8
XFILLER_34_424 VPWR VGND sg13cmos5l_decap_4
XFILLER_46_295 VPWR VGND sg13cmos5l_fill_1
X_2981_ _2985_/A _2981_/A _2981_/B VPWR VGND sg13cmos5l_nor2_1
XFILLER_21_118 VPWR VGND sg13cmos5l_fill_1
X_1932_ _1932_/Y _1932_/A VPWR VGND sg13cmos5l_inv_1
X_3602_ _3602_/Q _3629_/CLK _3602_/D _3602_/RESET_B VPWR VGND sg13cmos5l_dfrbpq_1
X_3533_ _3533_/Q _3574_/CLK _3533_/D _3533_/RESET_B VPWR VGND sg13cmos5l_dfrbpq_1
Xhold815 _2088_/A _3729_/Q VPWR VGND sg13cmos5l_dlygate4sd3_1
Xhold804 hold804/X _3803_/Q VPWR VGND sg13cmos5l_dlygate4sd3_1
XFILLER_6_391 VPWR VGND sg13cmos5l_decap_4
X_3464_ _3728_/D _3464_/A _3466_/B VPWR VGND sg13cmos5l_nor2_1
X_2415_ _3771_/D _2558_/A _2415_/B VPWR VGND sg13cmos5l_nor2_1
X_3395_ _3401_/A _3395_/A _3395_/B VPWR VGND sg13cmos5l_nor2_1
X_2346_ _2346_/Y _2342_/X _2346_/B VPWR VGND sg13cmos5l_nand2b_1
X_2277_ _2287_/A _2277_/A _2284_/A VPWR VGND sg13cmos5l_and2_1
XFILLER_38_796 VPWR VGND sg13cmos5l_decap_8
XFILLER_37_273 VPWR VGND sg13cmos5l_decap_8
X_3776__443 _3776_/RESET_B VPWR VGND sg13cmos5l_tiehi
XFILLER_26_947 VPWR VGND sg13cmos5l_decap_8
XFILLER_41_928 VPWR VGND sg13cmos5l_decap_8
XFILLER_40_438 VPWR VGND sg13cmos5l_decap_8
X_3735__162 _3735_/RESET_B VPWR VGND sg13cmos5l_tiehi
XFILLER_20_140 VPWR VGND sg13cmos5l_decap_4
XFILLER_20_173 VPWR VGND sg13cmos5l_decap_8
XFILLER_32_69 VPWR VGND sg13cmos5l_fill_1
XFILLER_4_306 VPWR VGND sg13cmos5l_decap_8
XFILLER_0_534 VPWR VGND sg13cmos5l_decap_8
XFILLER_48_516 VPWR VGND sg13cmos5l_fill_2
X_3742__155 _3742_/RESET_B VPWR VGND sg13cmos5l_tiehi
XFILLER_17_914 VPWR VGND sg13cmos5l_fill_2
XFILLER_17_969 VPWR VGND sg13cmos5l_decap_8
XFILLER_44_777 VPWR VGND sg13cmos5l_decap_8
XFILLER_25_980 VPWR VGND sg13cmos5l_decap_8
XFILLER_31_416 VPWR VGND sg13cmos5l_decap_8
XFILLER_40_972 VPWR VGND sg13cmos5l_decap_8
XFILLER_8_645 VPWR VGND sg13cmos5l_decap_4
XFILLER_7_199 VPWR VGND sg13cmos5l_fill_1
XFILLER_7_188 VPWR VGND sg13cmos5l_decap_8
XFILLER_22_80 VPWR VGND sg13cmos5l_decap_8
XFILLER_4_895 VPWR VGND sg13cmos5l_decap_8
XFILLER_3_350 VPWR VGND sg13cmos5l_fill_1
X_2200_ _2201_/B _2200_/A VPWR VGND sg13cmos5l_inv_1
XFILLER_3_394 VPWR VGND sg13cmos5l_decap_8
XFILLER_39_516 VPWR VGND sg13cmos5l_decap_8
X_3180_ _3180_/Y _1931_/A _3458_/A2 _3186_/A VPWR VGND sg13cmos5l_o21ai_1
XFILLER_39_527 VPWR VGND sg13cmos5l_fill_1
X_2131_ _3417_/B hold772/X _2130_/Y _2138_/B VPWR VGND sg13cmos5l_mux2_1
XFILLER_14_4 VPWR VGND sg13cmos5l_decap_4
X_3721__228 _3721_/RESET_B VPWR VGND sg13cmos5l_tiehi
X_2062_ _2211_/A _3437_/B _2063_/B VPWR VGND sg13cmos5l_xnor2_1
XFILLER_47_593 VPWR VGND sg13cmos5l_decap_8
XFILLER_47_582 VPWR VGND sg13cmos5l_fill_2
XFILLER_47_571 VPWR VGND sg13cmos5l_decap_8
XFILLER_19_262 VPWR VGND sg13cmos5l_decap_4
XFILLER_35_722 VPWR VGND sg13cmos5l_fill_1
XFILLER_34_210 VPWR VGND sg13cmos5l_decap_8
XFILLER_16_980 VPWR VGND sg13cmos5l_decap_8
XFILLER_34_254 VPWR VGND sg13cmos5l_fill_1
X_2964_ _2964_/Y _3638_/Q _2964_/B _2964_/C VPWR VGND sg13cmos5l_nor3_1
XFILLER_15_490 VPWR VGND sg13cmos5l_decap_8
Xclkbuf_leaf_14_clk _3722_/CLK clkload0/A VPWR VGND sg13cmos5l_buf_8
X_2895_ _2895_/Y _2890_/B _2894_/Y _2911_/B VPWR VGND sg13cmos5l_o21ai_1
XFILLER_33_1027 VPWR VGND sg13cmos5l_fill_2
XFILLER_8_82 VPWR VGND sg13cmos5l_fill_1
XFILLER_8_71 VPWR VGND sg13cmos5l_decap_8
Xhold601 hold601/X _3511_/Q VPWR VGND sg13cmos5l_dlygate4sd3_1
Xhold612 hold612/X _3503_/Q VPWR VGND sg13cmos5l_dlygate4sd3_1
X_3516_ _3516_/Q _3574_/CLK _3516_/D _3516_/RESET_B VPWR VGND sg13cmos5l_dfrbpq_1
Xhold645 _2586_/B _2585_/Y VPWR VGND sg13cmos5l_dlygate4sd3_1
Xhold634 _2303_/B _3725_/Q VPWR VGND sg13cmos5l_dlygate4sd3_1
Xhold623 _3629_/D _3024_/Y VPWR VGND sg13cmos5l_dlygate4sd3_1
Xhold678 _2261_/B _3717_/Q VPWR VGND sg13cmos5l_dlygate4sd3_1
Xhold656 _2027_/B _3796_/Q VPWR VGND sg13cmos5l_dlygate4sd3_1
Xhold667 hold667/X _3569_/Q VPWR VGND sg13cmos5l_dlygate4sd3_1
Xhold689 hold689/X _2775_/Y VPWR VGND sg13cmos5l_dlygate4sd3_1
X_3447_ _3447_/X _2251_/B _3434_/Y _3449_/S VPWR VGND sg13cmos5l_mux2_1
X_3378_ _3398_/A _3378_/A _3378_/B VPWR VGND sg13cmos5l_nor2_1
X_2329_ _2329_/Y _2329_/A VPWR VGND sg13cmos5l_inv_1
XFILLER_27_69 VPWR VGND sg13cmos5l_decap_8
XFILLER_41_703 VPWR VGND sg13cmos5l_decap_8
XFILLER_13_416 VPWR VGND sg13cmos5l_fill_1
XFILLER_25_254 VPWR VGND sg13cmos5l_decap_8
XFILLER_41_769 VPWR VGND sg13cmos5l_decap_8
XFILLER_40_246 VPWR VGND sg13cmos5l_decap_8
X_3633__211 _3633_/RESET_B VPWR VGND sg13cmos5l_tiehi
XFILLER_0_320 VPWR VGND sg13cmos5l_decap_8
XFILLER_1_843 VPWR VGND sg13cmos5l_decap_8
XFILLER_49_803 VPWR VGND sg13cmos5l_decap_8
XFILLER_48_324 VPWR VGND sg13cmos5l_fill_2
XFILLER_1_1025 VPWR VGND sg13cmos5l_decap_4
XFILLER_17_711 VPWR VGND sg13cmos5l_decap_4
X_3720__250 _3720_/RESET_B VPWR VGND sg13cmos5l_tiehi
XFILLER_44_530 VPWR VGND sg13cmos5l_fill_2
XFILLER_31_224 VPWR VGND sg13cmos5l_decap_8
XFILLER_31_257 VPWR VGND sg13cmos5l_decap_8
XFILLER_12_471 VPWR VGND sg13cmos5l_decap_8
X_2680_ _2680_/X input13/X hold568/X _2680_/S VPWR VGND sg13cmos5l_mux2_1
XFILLER_9_976 VPWR VGND sg13cmos5l_decap_8
X_3686__429 _3686_/RESET_B VPWR VGND sg13cmos5l_tiehi
X_3301_ _3395_/B _3283_/B _3294_/B _3114_/X VPWR VGND sg13cmos5l_a21o_1
Xclkbuf_leaf_3_clk _3809_/CLK clkbuf_leaf_3_clk/A VPWR VGND sg13cmos5l_buf_8
X_3232_ _3668_/D _3215_/A _3227_/Y _3231_/Y VPWR VGND sg13cmos5l_a21oi_1
X_3163_ _3163_/Y _3653_/Q _3162_/Y _3159_/X VPWR VGND sg13cmos5l_o21ai_1
X_2114_ _2217_/A _3732_/Q _3733_/Q VPWR VGND sg13cmos5l_xnor2_1
XFILLER_48_880 VPWR VGND sg13cmos5l_decap_8
X_3094_ _3094_/Y _3109_/A _3111_/A _3114_/A _3093_/A VPWR VGND sg13cmos5l_a22oi_1
XFILLER_47_390 VPWR VGND sg13cmos5l_decap_8
X_2045_ _2104_/A _3679_/Q _3678_/Q _3677_/Q VPWR VGND sg13cmos5l_or3_1
XFILLER_23_736 VPWR VGND sg13cmos5l_decap_8
Xfanout28 _2681_/S _2680_/S VPWR VGND sg13cmos5l_buf_1
XFILLER_35_596 VPWR VGND sg13cmos5l_decap_8
Xfanout39 _2337_/B _2349_/B VPWR VGND sg13cmos5l_buf_1
XFILLER_22_257 VPWR VGND sg13cmos5l_fill_1
X_2947_ _3120_/A _3640_/Q _3133_/C VPWR VGND sg13cmos5l_nor2_1
X_2878_ _3592_/D _2912_/B _3607_/D VPWR VGND sg13cmos5l_and2_1
XFILLER_1_117 VPWR VGND sg13cmos5l_decap_8
Xhold486 _3461_/B _3693_/Q VPWR VGND sg13cmos5l_dlygate4sd3_1
Xhold475 _3025_/B _3604_/Q VPWR VGND sg13cmos5l_dlygate4sd3_1
Xhold497 _2751_/A _3571_/Q VPWR VGND sg13cmos5l_dlygate4sd3_1
XFILLER_38_35 VPWR VGND sg13cmos5l_fill_2
XFILLER_38_79 VPWR VGND sg13cmos5l_decap_8
XFILLER_18_508 VPWR VGND sg13cmos5l_fill_2
XFILLER_46_839 VPWR VGND sg13cmos5l_decap_8
XFILLER_39_891 VPWR VGND sg13cmos5l_decap_8
XFILLER_26_530 VPWR VGND sg13cmos5l_fill_1
X_3600__254 _3600_/RESET_B VPWR VGND sg13cmos5l_tiehi
XFILLER_41_511 VPWR VGND sg13cmos5l_decap_8
XFILLER_41_544 VPWR VGND sg13cmos5l_fill_1
XFILLER_14_758 VPWR VGND sg13cmos5l_fill_1
XFILLER_16_1022 VPWR VGND sg13cmos5l_decap_8
XFILLER_21_290 VPWR VGND sg13cmos5l_decap_8
XFILLER_6_946 VPWR VGND sg13cmos5l_decap_8
XFILLER_5_412 VPWR VGND sg13cmos5l_decap_8
XFILLER_5_456 VPWR VGND sg13cmos5l_fill_1
XFILLER_5_489 VPWR VGND sg13cmos5l_decap_8
XFILLER_49_633 VPWR VGND sg13cmos5l_decap_4
XFILLER_49_611 VPWR VGND sg13cmos5l_decap_4
XFILLER_1_695 VPWR VGND sg13cmos5l_fill_1
XFILLER_49_666 VPWR VGND sg13cmos5l_fill_1
XFILLER_49_655 VPWR VGND sg13cmos5l_decap_8
XFILLER_23_1026 VPWR VGND sg13cmos5l_fill_2
XFILLER_49_688 VPWR VGND sg13cmos5l_decap_8
XFILLER_48_187 VPWR VGND sg13cmos5l_fill_1
XFILLER_45_861 VPWR VGND sg13cmos5l_decap_8
XFILLER_20_706 VPWR VGND sg13cmos5l_decap_8
X_3781_ _3781_/Q _3806_/CLK _3781_/D _3781_/RESET_B VPWR VGND sg13cmos5l_dfrbpq_1
X_2801_ _2801_/Y _2796_/Y _2800_/Y _3569_/Q VPWR VGND sg13cmos5l_a21oi_1
XFILLER_32_588 VPWR VGND sg13cmos5l_decap_8
X_2732_ _2732_/Y _2737_/A1 hold522/X _2597_/C VPWR VGND sg13cmos5l_o21ai_1
XFILLER_13_791 VPWR VGND sg13cmos5l_decap_8
XFILLER_8_261 VPWR VGND sg13cmos5l_fill_1
XFILLER_9_784 VPWR VGND sg13cmos5l_decap_8
X_2663_ _2671_/S _2663_/A _2672_/C VPWR VGND sg13cmos5l_nand2_1
X_2594_ _2594_/Y _2581_/X _2593_/Y _2014_/A VPWR VGND sg13cmos5l_o21ai_1
X_3215_ _3215_/Y _3215_/A _3215_/B VPWR VGND sg13cmos5l_nor2_1
X_3146_ _3146_/Y _3623_/Q _3349_/A _3145_/Y VPWR VGND sg13cmos5l_a21oi_1
X_3077_ _3090_/B _3088_/A _3669_/Q VPWR VGND sg13cmos5l_nor2_1
XFILLER_36_872 VPWR VGND sg13cmos5l_decap_8
XFILLER_36_850 VPWR VGND sg13cmos5l_fill_2
X_2028_ _2029_/B _2284_/B VPWR VGND sg13cmos5l_inv_1
X_3478__405 _3478_/RESET_B VPWR VGND sg13cmos5l_tiehi
XFILLER_39_1022 VPWR VGND sg13cmos5l_decap_8
XFILLER_23_500 VPWR VGND sg13cmos5l_decap_8
XFILLER_23_555 VPWR VGND sg13cmos5l_decap_4
XFILLER_6_209 VPWR VGND sg13cmos5l_decap_4
X_3630__214 _3630_/RESET_B VPWR VGND sg13cmos5l_tiehi
X_3587__124 _3587_/D VPWR VGND sg13cmos5l_tielo
XFILLER_3_927 VPWR VGND sg13cmos5l_decap_8
XFILLER_2_426 VPWR VGND sg13cmos5l_decap_8
XFILLER_49_23 VPWR VGND sg13cmos5l_decap_8
XFILLER_49_78 VPWR VGND sg13cmos5l_fill_2
XFILLER_46_625 VPWR VGND sg13cmos5l_decap_8
XFILLER_18_305 VPWR VGND sg13cmos5l_decap_4
XFILLER_27_861 VPWR VGND sg13cmos5l_decap_4
XFILLER_42_831 VPWR VGND sg13cmos5l_decap_8
XFILLER_33_319 VPWR VGND sg13cmos5l_decap_8
XFILLER_2_982 VPWR VGND sg13cmos5l_decap_8
X_3000_ _3000_/Y _3599_/Q _3000_/B VPWR VGND sg13cmos5l_nor2_1
Xinput7 input7/X uio_in[1] VPWR VGND sg13cmos5l_buf_1
XFILLER_37_614 VPWR VGND sg13cmos5l_decap_8
XFILLER_37_669 VPWR VGND sg13cmos5l_fill_2
XFILLER_36_179 VPWR VGND sg13cmos5l_decap_8
XFILLER_44_190 VPWR VGND sg13cmos5l_fill_1
XFILLER_33_886 VPWR VGND sg13cmos5l_decap_8
XFILLER_33_897 VPWR VGND sg13cmos5l_fill_2
X_3764_ _3764_/Q _3766_/CLK _3764_/D _3764_/RESET_B VPWR VGND sg13cmos5l_dfrbpq_1
XFILLER_9_581 VPWR VGND sg13cmos5l_fill_2
X_2715_ _2716_/A _2711_/A _2708_/X _2672_/A VPWR VGND sg13cmos5l_o21ai_1
X_3695_ _3695_/Q _3698_/CLK _3695_/D _3695_/RESET_B VPWR VGND sg13cmos5l_dfrbpq_1
X_2646_ _3516_/D input10/X hold624/X _2648_/S VPWR VGND sg13cmos5l_mux2_1
X_2577_ _2578_/C _3806_/Q _2577_/B VPWR VGND sg13cmos5l_nand2b_1
XFILLER_27_113 VPWR VGND sg13cmos5l_fill_2
X_3129_ _3129_/Y _3120_/A _3120_/B _3126_/X _2964_/B VPWR VGND sg13cmos5l_a22oi_1
XFILLER_11_536 VPWR VGND sg13cmos5l_decap_8
XFILLER_7_529 VPWR VGND sg13cmos5l_decap_8
XFILLER_7_507 VPWR VGND sg13cmos5l_decap_8
XFILLER_3_735 VPWR VGND sg13cmos5l_decap_8
XFILLER_2_278 VPWR VGND sg13cmos5l_fill_1
XFILLER_47_912 VPWR VGND sg13cmos5l_decap_8
XFILLER_18_102 VPWR VGND sg13cmos5l_decap_8
XFILLER_18_113 VPWR VGND sg13cmos5l_fill_2
XFILLER_47_989 VPWR VGND sg13cmos5l_decap_8
XFILLER_19_669 VPWR VGND sg13cmos5l_decap_8
XFILLER_15_864 VPWR VGND sg13cmos5l_decap_8
XFILLER_27_691 VPWR VGND sg13cmos5l_decap_4
XFILLER_15_897 VPWR VGND sg13cmos5l_decap_8
XFILLER_30_812 VPWR VGND sg13cmos5l_fill_1
XFILLER_30_823 VPWR VGND sg13cmos5l_decap_4
XFILLER_14_385 VPWR VGND sg13cmos5l_decap_4
XFILLER_6_540 VPWR VGND sg13cmos5l_decap_8
X_2500_ _2501_/B _2507_/A _2507_/B _2500_/C VPWR VGND sg13cmos5l_or3_1
X_3480_ _3480_/Q _3809_/CLK _3480_/D _3480_/RESET_B VPWR VGND sg13cmos5l_dfrbpq_1
X_2431_ _2431_/Y _3750_/Q _2431_/B _2439_/B VPWR VGND sg13cmos5l_nor3_1
XFILLER_44_4 VPWR VGND sg13cmos5l_decap_8
X_2362_ _3766_/D _2348_/Y hold811/X _2307_/B VPWR VGND sg13cmos5l_a21oi_1
X_2293_ _2293_/X _2740_/A _2294_/B VPWR VGND sg13cmos5l_and2_1
XFILLER_38_956 VPWR VGND sg13cmos5l_decap_8
XFILLER_21_834 VPWR VGND sg13cmos5l_fill_1
X_3551__329 _3551_/RESET_B VPWR VGND sg13cmos5l_tiehi
X_3747_ _3747_/Q clkload2/A _3747_/D _3747_/RESET_B VPWR VGND sg13cmos5l_dfrbpq_1
XFILLER_21_27 VPWR VGND sg13cmos5l_fill_1
XFILLER_21_38 VPWR VGND sg13cmos5l_decap_8
X_3678_ _3678_/Q _3731_/CLK _3678_/D _3678_/RESET_B VPWR VGND sg13cmos5l_dfrbpq_1
XFILLER_0_705 VPWR VGND sg13cmos5l_decap_8
X_2629_ _3503_/D input6/X hold612/X _2637_/S VPWR VGND sg13cmos5l_mux2_1
XFILLER_43_1018 VPWR VGND sg13cmos5l_decap_8
XFILLER_28_433 VPWR VGND sg13cmos5l_decap_4
XFILLER_29_945 VPWR VGND sg13cmos5l_decap_8
XFILLER_46_35 VPWR VGND sg13cmos5l_decap_8
XFILLER_28_444 VPWR VGND sg13cmos5l_fill_2
XFILLER_44_959 VPWR VGND sg13cmos5l_decap_8
XFILLER_16_628 VPWR VGND sg13cmos5l_fill_1
XFILLER_15_127 VPWR VGND sg13cmos5l_decap_8
XFILLER_15_149 VPWR VGND sg13cmos5l_decap_4
XFILLER_24_650 VPWR VGND sg13cmos5l_decap_8
XFILLER_30_108 VPWR VGND sg13cmos5l_decap_8
XFILLER_7_304 VPWR VGND sg13cmos5l_decap_8
XFILLER_11_333 VPWR VGND sg13cmos5l_decap_8
XFILLER_12_889 VPWR VGND sg13cmos5l_decap_8
XFILLER_8_849 VPWR VGND sg13cmos5l_decap_8
XFILLER_3_532 VPWR VGND sg13cmos5l_decap_8
Xheichips26_dna_sequencer_89 uio_oe[5] VPWR VGND sg13cmos5l_tielo
XFILLER_16_8 VPWR VGND sg13cmos5l_fill_1
XFILLER_19_411 VPWR VGND sg13cmos5l_decap_8
XFILLER_19_455 VPWR VGND sg13cmos5l_fill_1
XFILLER_47_786 VPWR VGND sg13cmos5l_decap_8
XFILLER_19_488 VPWR VGND sg13cmos5l_decap_8
X_2980_ _2981_/B _2973_/X _2977_/Y _2987_/A _2982_/A _2979_/X VPWR VGND sg13cmos5l_a221oi_1
X_1931_ _1931_/Y _1931_/A VPWR VGND sg13cmos5l_inv_1
XFILLER_30_631 VPWR VGND sg13cmos5l_fill_1
XFILLER_30_642 VPWR VGND sg13cmos5l_fill_1
Xinput10 input10/X uio_in[4] VPWR VGND sg13cmos5l_buf_1
X_3601_ _3601_/Q _3806_/CLK _3601_/D _3601_/RESET_B VPWR VGND sg13cmos5l_dfrbpq_1
Xhold816 hold816/X _3616_/Q VPWR VGND sg13cmos5l_dlygate4sd3_1
X_3532_ _3532_/Q _3574_/CLK _3532_/D _3532_/RESET_B VPWR VGND sg13cmos5l_dfrbpq_1
Xhold805 hold805/X _3764_/Q VPWR VGND sg13cmos5l_dlygate4sd3_1
X_3463_ _3727_/D _3463_/A _3463_/B VPWR VGND sg13cmos5l_and2_1
X_2414_ _2414_/X _2399_/S _2411_/X _2412_/Y VPWR VGND sg13cmos5l_a21o_1
X_3394_ _3394_/Y _3385_/Y _3388_/Y _3390_/X _3409_/A _3393_/Y VPWR VGND sg13cmos5l_a221oi_1
XFILLER_35_0 VPWR VGND sg13cmos5l_decap_8
X_2345_ _2345_/Y _2345_/A _2345_/B _2345_/C VPWR VGND sg13cmos5l_nor3_1
X_2276_ _3751_/D _3452_/A _2276_/B VPWR VGND sg13cmos5l_and2_1
X_3702__310 _3702_/RESET_B VPWR VGND sg13cmos5l_tiehi
XFILLER_38_775 VPWR VGND sg13cmos5l_decap_8
XFILLER_38_742 VPWR VGND sg13cmos5l_decap_4
XFILLER_25_425 VPWR VGND sg13cmos5l_decap_8
XFILLER_26_926 VPWR VGND sg13cmos5l_decap_8
XFILLER_41_907 VPWR VGND sg13cmos5l_decap_8
XFILLER_37_296 VPWR VGND sg13cmos5l_decap_8
XFILLER_16_27 VPWR VGND sg13cmos5l_fill_2
XFILLER_40_417 VPWR VGND sg13cmos5l_decap_8
XFILLER_21_642 VPWR VGND sg13cmos5l_decap_8
XFILLER_21_653 VPWR VGND sg13cmos5l_fill_1
XFILLER_21_697 VPWR VGND sg13cmos5l_fill_1
XFILLER_0_513 VPWR VGND sg13cmos5l_decap_8
XFILLER_0_568 VPWR VGND sg13cmos5l_decap_8
XFILLER_0_579 VPWR VGND sg13cmos5l_decap_8
XFILLER_29_731 VPWR VGND sg13cmos5l_decap_8
XFILLER_44_734 VPWR VGND sg13cmos5l_decap_4
XFILLER_28_285 VPWR VGND sg13cmos5l_decap_8
XFILLER_43_266 VPWR VGND sg13cmos5l_decap_8
XFILLER_43_255 VPWR VGND sg13cmos5l_fill_2
XFILLER_12_620 VPWR VGND sg13cmos5l_fill_2
XFILLER_24_480 VPWR VGND sg13cmos5l_decap_8
XFILLER_40_951 VPWR VGND sg13cmos5l_decap_8
XFILLER_8_613 VPWR VGND sg13cmos5l_fill_2
XFILLER_11_130 VPWR VGND sg13cmos5l_decap_8
XFILLER_7_101 VPWR VGND sg13cmos5l_decap_4
XFILLER_12_697 VPWR VGND sg13cmos5l_decap_8
XFILLER_8_668 VPWR VGND sg13cmos5l_decap_4
XFILLER_4_874 VPWR VGND sg13cmos5l_decap_8
XFILLER_26_1024 VPWR VGND sg13cmos5l_decap_4
X_2130_ _2130_/Y _3462_/A _2130_/B VPWR VGND sg13cmos5l_nand2_1
X_2061_ _2214_/A _2063_/B _2061_/B VPWR VGND sg13cmos5l_nand2b_1
XFILLER_19_241 VPWR VGND sg13cmos5l_decap_8
XFILLER_23_907 VPWR VGND sg13cmos5l_fill_2
XFILLER_35_734 VPWR VGND sg13cmos5l_decap_8
X_3574__126 _3574_/D VPWR VGND sg13cmos5l_tielo
X_2963_ _3614_/D _3054_/B _3072_/A VPWR VGND sg13cmos5l_nor2_1
XFILLER_34_288 VPWR VGND sg13cmos5l_decap_8
XFILLER_33_1006 VPWR VGND sg13cmos5l_decap_8
X_2894_ _2894_/Y _2894_/A _2894_/B VPWR VGND sg13cmos5l_nor2_1
XFILLER_30_472 VPWR VGND sg13cmos5l_decap_8
XFILLER_31_984 VPWR VGND sg13cmos5l_decap_8
Xhold602 hold602/X _3525_/Q VPWR VGND sg13cmos5l_dlygate4sd3_1
Xhold624 hold624/X _3516_/Q VPWR VGND sg13cmos5l_dlygate4sd3_1
Xhold635 _2876_/A _3586_/Q VPWR VGND sg13cmos5l_dlygate4sd3_1
X_3515_ _3515_/Q _3629_/CLK _3515_/D _3515_/RESET_B VPWR VGND sg13cmos5l_dfrbpq_1
Xhold613 _3338_/B _3656_/Q VPWR VGND sg13cmos5l_dlygate4sd3_1
Xhold646 _2912_/A _3585_/Q VPWR VGND sg13cmos5l_dlygate4sd3_1
Xhold679 hold679/X _2261_/Y VPWR VGND sg13cmos5l_dlygate4sd3_1
Xhold657 _3796_/D _2574_/Y VPWR VGND sg13cmos5l_dlygate4sd3_1
Xhold668 _2753_/D _2752_/Y VPWR VGND sg13cmos5l_dlygate4sd3_1
X_3446_ _3446_/Y _3430_/Y _3449_/S _3445_/Y VPWR VGND sg13cmos5l_a21oi_1
X_3377_ _3378_/B _3698_/Q _3376_/B _3375_/A _3376_/Y VPWR VGND sg13cmos5l_a22oi_1
X_2328_ _2329_/A _3761_/Q _2337_/B _2350_/A VPWR VGND sg13cmos5l_o21ai_1
XFILLER_45_509 VPWR VGND sg13cmos5l_decap_8
X_2259_ _2259_/Y _2259_/A VPWR VGND sg13cmos5l_inv_1
XFILLER_26_701 VPWR VGND sg13cmos5l_fill_1
XFILLER_25_233 VPWR VGND sg13cmos5l_decap_8
XFILLER_26_778 VPWR VGND sg13cmos5l_decap_8
XFILLER_26_789 VPWR VGND sg13cmos5l_fill_1
XFILLER_41_748 VPWR VGND sg13cmos5l_decap_8
XFILLER_41_726 VPWR VGND sg13cmos5l_fill_1
XFILLER_40_214 VPWR VGND sg13cmos5l_decap_8
XFILLER_25_288 VPWR VGND sg13cmos5l_decap_8
XFILLER_22_995 VPWR VGND sg13cmos5l_decap_8
XFILLER_49_1013 VPWR VGND sg13cmos5l_decap_8
XFILLER_5_649 VPWR VGND sg13cmos5l_decap_4
XFILLER_4_148 VPWR VGND sg13cmos5l_fill_2
XFILLER_1_822 VPWR VGND sg13cmos5l_decap_8
XFILLER_49_859 VPWR VGND sg13cmos5l_decap_8
XFILLER_0_365 VPWR VGND sg13cmos5l_decap_8
XFILLER_0_376 VPWR VGND sg13cmos5l_fill_2
XFILLER_1_899 VPWR VGND sg13cmos5l_decap_8
XFILLER_1_1004 VPWR VGND sg13cmos5l_decap_8
XFILLER_17_723 VPWR VGND sg13cmos5l_decap_4
XFILLER_29_550 VPWR VGND sg13cmos5l_decap_8
XFILLER_29_561 VPWR VGND sg13cmos5l_fill_1
XFILLER_16_200 VPWR VGND sg13cmos5l_fill_2
XFILLER_16_222 VPWR VGND sg13cmos5l_decap_8
XFILLER_16_233 VPWR VGND sg13cmos5l_fill_2
XFILLER_16_255 VPWR VGND sg13cmos5l_decap_8
XFILLER_16_266 VPWR VGND sg13cmos5l_decap_4
XFILLER_16_299 VPWR VGND sg13cmos5l_decap_8
XFILLER_13_995 VPWR VGND sg13cmos5l_decap_8
XFILLER_8_443 VPWR VGND sg13cmos5l_decap_8
XFILLER_9_955 VPWR VGND sg13cmos5l_decap_8
X_3300_ _3679_/D _3352_/B _3391_/A VPWR VGND sg13cmos5l_and2_1
XFILLER_4_682 VPWR VGND sg13cmos5l_fill_1
XFILLER_3_181 VPWR VGND sg13cmos5l_decap_8
X_3231_ _3231_/Y _3215_/B _3227_/Y _3108_/A VPWR VGND sg13cmos5l_o21ai_1
XFILLER_39_303 VPWR VGND sg13cmos5l_decap_8
X_3162_ _3162_/Y _3162_/A VPWR VGND sg13cmos5l_inv_1
X_2113_ _2113_/Y _2115_/A _2115_/B VPWR VGND sg13cmos5l_nand2_1
X_3093_ _3093_/Y _3093_/A VPWR VGND sg13cmos5l_inv_1
X_2044_ _2044_/Y _2276_/B _2303_/A VPWR VGND sg13cmos5l_nand2b_1
XFILLER_35_542 VPWR VGND sg13cmos5l_decap_8
Xfanout29 _2725_/A _2650_/Y VPWR VGND sg13cmos5l_buf_1
XFILLER_22_247 VPWR VGND sg13cmos5l_fill_1
X_2946_ _2946_/Y _3188_/A _3640_/Q VPWR VGND sg13cmos5l_nor2_1
XFILLER_10_409 VPWR VGND sg13cmos5l_decap_4
XFILLER_13_17 VPWR VGND sg13cmos5l_decap_8
X_2877_ _3607_/D _2912_/A _2911_/B VPWR VGND sg13cmos5l_and2_1
XFILLER_2_608 VPWR VGND sg13cmos5l_decap_8
Xhold487 _2302_/B _3724_/Q VPWR VGND sg13cmos5l_dlygate4sd3_1
Xhold476 _3026_/B _3605_/Q VPWR VGND sg13cmos5l_dlygate4sd3_1
X_3429_ _3429_/Y _3735_/Q _3731_/Q VPWR VGND sg13cmos5l_nor2b_1
Xhold498 _3568_/D _2750_/Y VPWR VGND sg13cmos5l_dlygate4sd3_1
XFILLER_46_818 VPWR VGND sg13cmos5l_decap_8
XFILLER_45_339 VPWR VGND sg13cmos5l_decap_8
XFILLER_14_715 VPWR VGND sg13cmos5l_decap_8
XFILLER_26_553 VPWR VGND sg13cmos5l_decap_8
XFILLER_14_726 VPWR VGND sg13cmos5l_fill_1
XFILLER_16_1001 VPWR VGND sg13cmos5l_decap_8
XFILLER_9_218 VPWR VGND sg13cmos5l_decap_8
XFILLER_6_925 VPWR VGND sg13cmos5l_decap_8
XFILLER_10_987 VPWR VGND sg13cmos5l_decap_8
XFILLER_1_630 VPWR VGND sg13cmos5l_decap_4
XFILLER_23_1005 VPWR VGND sg13cmos5l_decap_8
XFILLER_45_840 VPWR VGND sg13cmos5l_decap_8
XFILLER_44_394 VPWR VGND sg13cmos5l_decap_8
XFILLER_32_567 VPWR VGND sg13cmos5l_fill_2
X_3780_ _3780_/Q clkload1/A _3780_/D _3780_/RESET_B VPWR VGND sg13cmos5l_dfrbpq_1
X_2800_ _2800_/Y _2800_/A VPWR VGND sg13cmos5l_inv_1
X_2731_ _2731_/Y _2737_/A1 _1949_/Y _2730_/Y VPWR VGND sg13cmos5l_a21oi_1
XFILLER_12_280 VPWR VGND sg13cmos5l_decap_8
XFILLER_12_291 VPWR VGND sg13cmos5l_fill_1
X_2662_ _2672_/C _3560_/Q _3559_/Q VPWR VGND sg13cmos5l_nor2_1
X_2593_ _2593_/Y _2593_/A _3806_/Q VPWR VGND sg13cmos5l_nor2b_1
XFILLER_5_51 VPWR VGND sg13cmos5l_fill_1
X_3214_ _3215_/B _3138_/Y _3108_/B _3214_/S VPWR VGND sg13cmos5l_mux2_1
XFILLER_39_122 VPWR VGND sg13cmos5l_fill_1
XFILLER_39_155 VPWR VGND sg13cmos5l_decap_8
XFILLER_28_829 VPWR VGND sg13cmos5l_decap_8
X_3145_ _3145_/Y _3152_/B _3088_/A _3667_/Q _3155_/B VPWR VGND sg13cmos5l_a22oi_1
X_3076_ _3076_/Y _3338_/B _3347_/A VPWR VGND sg13cmos5l_nand2b_1
XFILLER_39_1001 VPWR VGND sg13cmos5l_decap_8
X_2027_ _2284_/B _2027_/A _2027_/B _2027_/C VPWR VGND sg13cmos5l_nor3_1
XFILLER_35_383 VPWR VGND sg13cmos5l_decap_8
XFILLER_35_394 VPWR VGND sg13cmos5l_fill_2
XFILLER_10_206 VPWR VGND sg13cmos5l_fill_1
XFILLER_11_729 VPWR VGND sg13cmos5l_decap_8
X_2929_ _2929_/Y _2929_/A _2929_/B VPWR VGND sg13cmos5l_nor2_1
XFILLER_3_906 VPWR VGND sg13cmos5l_decap_8
X_3710__294 _3710_/RESET_B VPWR VGND sg13cmos5l_tiehi
XFILLER_49_57 VPWR VGND sg13cmos5l_decap_8
X_3561__309 _3561_/RESET_B VPWR VGND sg13cmos5l_tiehi
XFILLER_45_136 VPWR VGND sg13cmos5l_decap_8
XFILLER_42_821 VPWR VGND sg13cmos5l_decap_4
XFILLER_14_501 VPWR VGND sg13cmos5l_decap_8
XFILLER_26_361 VPWR VGND sg13cmos5l_fill_1
XFILLER_14_556 VPWR VGND sg13cmos5l_decap_8
X_3674__142 _3674_/RESET_B VPWR VGND sg13cmos5l_tiehi
XFILLER_14_567 VPWR VGND sg13cmos5l_fill_1
XFILLER_14_82 VPWR VGND sg13cmos5l_fill_2
XFILLER_2_961 VPWR VGND sg13cmos5l_decap_8
XFILLER_1_482 VPWR VGND sg13cmos5l_decap_4
XFILLER_49_464 VPWR VGND sg13cmos5l_decap_8
Xinput8 input8/X uio_in[2] VPWR VGND sg13cmos5l_buf_1
XFILLER_36_114 VPWR VGND sg13cmos5l_decap_4
XFILLER_36_125 VPWR VGND sg13cmos5l_fill_1
XFILLER_45_681 VPWR VGND sg13cmos5l_fill_1
XFILLER_33_865 VPWR VGND sg13cmos5l_decap_8
XFILLER_32_353 VPWR VGND sg13cmos5l_fill_2
X_3763_ _3763_/Q _3766_/CLK _3763_/D _3763_/RESET_B VPWR VGND sg13cmos5l_dfrbpq_1
XFILLER_9_560 VPWR VGND sg13cmos5l_decap_8
X_2714_ _2714_/Y _2717_/B _2712_/Y _2713_/Y VPWR VGND sg13cmos5l_o21ai_1
X_3694_ _3694_/Q _3698_/CLK _3694_/D _3694_/RESET_B VPWR VGND sg13cmos5l_dfrbpq_1
X_2645_ _3515_/D _1992_/Y _2649_/S _2644_/Y VPWR VGND sg13cmos5l_a21oi_1
XFILLER_0_909 VPWR VGND sg13cmos5l_decap_8
X_2576_ _3797_/D _2586_/A _2576_/B VPWR VGND sg13cmos5l_nor2_1
X_3128_ _3128_/Y _2964_/B _3126_/X _3127_/X VPWR VGND sg13cmos5l_o21ai_1
XFILLER_43_607 VPWR VGND sg13cmos5l_fill_2
XFILLER_43_629 VPWR VGND sg13cmos5l_fill_2
X_3059_ _3059_/X _3059_/A _3059_/B VPWR VGND sg13cmos5l_or2_1
XFILLER_15_309 VPWR VGND sg13cmos5l_decap_8
XFILLER_24_854 VPWR VGND sg13cmos5l_decap_8
XFILLER_11_515 VPWR VGND sg13cmos5l_decap_8
XFILLER_24_898 VPWR VGND sg13cmos5l_fill_2
X_3745__132 _3745_/D VPWR VGND sg13cmos5l_tielo
XFILLER_46_434 VPWR VGND sg13cmos5l_decap_4
XFILLER_19_637 VPWR VGND sg13cmos5l_fill_2
XFILLER_20_1008 VPWR VGND sg13cmos5l_decap_8
XFILLER_47_968 VPWR VGND sg13cmos5l_decap_8
XFILLER_34_607 VPWR VGND sg13cmos5l_decap_4
XFILLER_34_629 VPWR VGND sg13cmos5l_decap_4
XFILLER_14_320 VPWR VGND sg13cmos5l_fill_2
XFILLER_15_832 VPWR VGND sg13cmos5l_decap_8
XFILLER_42_651 VPWR VGND sg13cmos5l_fill_1
XFILLER_41_150 VPWR VGND sg13cmos5l_decap_8
XFILLER_30_879 VPWR VGND sg13cmos5l_decap_8
XFILLER_10_570 VPWR VGND sg13cmos5l_decap_8
X_2430_ _2434_/B _3775_/Q _2430_/B VPWR VGND sg13cmos5l_nor2_1
XFILLER_29_1022 VPWR VGND sg13cmos5l_decap_8
XFILLER_37_4 VPWR VGND sg13cmos5l_fill_2
X_2361_ _3765_/D _2361_/A _2361_/B VPWR VGND sg13cmos5l_nor2_1
X_2292_ _2294_/B _2292_/A _2741_/A VPWR VGND sg13cmos5l_nor2b_1
XFILLER_2_30 VPWR VGND sg13cmos5l_fill_1
XFILLER_49_283 VPWR VGND sg13cmos5l_fill_1
XFILLER_38_935 VPWR VGND sg13cmos5l_decap_8
XFILLER_37_445 VPWR VGND sg13cmos5l_decap_8
XFILLER_24_117 VPWR VGND sg13cmos5l_fill_2
X_3694__326 _3694_/RESET_B VPWR VGND sg13cmos5l_tiehi
XFILLER_36_1015 VPWR VGND sg13cmos5l_decap_8
XFILLER_32_150 VPWR VGND sg13cmos5l_decap_8
XFILLER_32_161 VPWR VGND sg13cmos5l_fill_2
X_3746_ _3746_/Q clkload2/A _3746_/D _3746_/RESET_B VPWR VGND sg13cmos5l_dfrbpq_1
X_3677_ _3677_/Q _3731_/CLK _3677_/D _3677_/RESET_B VPWR VGND sg13cmos5l_dfrbpq_1
X_2628_ _2636_/S _2672_/A _2708_/A _2628_/C VPWR VGND sg13cmos5l_nand3_1
X_2559_ _2561_/B _2560_/B _2560_/C _2544_/A VPWR VGND sg13cmos5l_a21oi_1
XFILLER_29_924 VPWR VGND sg13cmos5l_decap_8
XFILLER_44_938 VPWR VGND sg13cmos5l_decap_8
XFILLER_43_437 VPWR VGND sg13cmos5l_decap_8
XFILLER_12_802 VPWR VGND sg13cmos5l_fill_2
XFILLER_12_824 VPWR VGND sg13cmos5l_decap_8
XFILLER_23_183 VPWR VGND sg13cmos5l_decap_4
XFILLER_8_828 VPWR VGND sg13cmos5l_decap_8
XFILLER_12_868 VPWR VGND sg13cmos5l_decap_8
XFILLER_11_367 VPWR VGND sg13cmos5l_decap_8
XFILLER_11_378 VPWR VGND sg13cmos5l_fill_1
XFILLER_3_511 VPWR VGND sg13cmos5l_decap_4
XFILLER_11_94 VPWR VGND sg13cmos5l_fill_2
XFILLER_3_599 VPWR VGND sg13cmos5l_fill_1
XFILLER_47_721 VPWR VGND sg13cmos5l_decap_8
XFILLER_47_765 VPWR VGND sg13cmos5l_decap_8
XFILLER_28_990 VPWR VGND sg13cmos5l_decap_8
XFILLER_34_448 VPWR VGND sg13cmos5l_fill_2
XFILLER_15_662 VPWR VGND sg13cmos5l_decap_4
XFILLER_21_109 VPWR VGND sg13cmos5l_decap_8
XFILLER_14_161 VPWR VGND sg13cmos5l_fill_2
X_1930_ _1930_/Y _3203_/A VPWR VGND sg13cmos5l_inv_1
Xinput11 input11/X uio_in[5] VPWR VGND sg13cmos5l_buf_1
X_3600_ _3600_/Q _3806_/CLK _3600_/D _3600_/RESET_B VPWR VGND sg13cmos5l_dfrbpq_1
X_3531_ _3531_/Q _3809_/CLK _3531_/D _3531_/RESET_B VPWR VGND sg13cmos5l_dfrbpq_1
XFILLER_7_883 VPWR VGND sg13cmos5l_decap_8
X_3769__452 _3769_/RESET_B VPWR VGND sg13cmos5l_tiehi
Xhold806 _2333_/A _3759_/Q VPWR VGND sg13cmos5l_dlygate4sd3_1
Xhold817 hold817/X _3668_/Q VPWR VGND sg13cmos5l_dlygate4sd3_1
X_3462_ _3726_/D _3462_/A _3463_/B VPWR VGND sg13cmos5l_and2_1
X_2413_ _2415_/B _2399_/S _2411_/X _2412_/Y VPWR VGND sg13cmos5l_a21oi_1
X_3393_ _3393_/Y _3385_/B _3385_/C _3385_/A VPWR VGND sg13cmos5l_a21oi_1
X_2344_ _2345_/C _2346_/B _2342_/X VPWR VGND sg13cmos5l_nor2b_1
X_3481__402 _3481_/RESET_B VPWR VGND sg13cmos5l_tiehi
X_2275_ _3749_/D _2264_/B hold701/X _2270_/A VPWR VGND sg13cmos5l_a21oi_1
XFILLER_37_253 VPWR VGND sg13cmos5l_fill_2
XFILLER_12_109 VPWR VGND sg13cmos5l_fill_2
XFILLER_34_982 VPWR VGND sg13cmos5l_decap_8
X_3729_ _3729_/Q _3731_/CLK _3729_/D _3729_/RESET_B VPWR VGND sg13cmos5l_dfrbpq_1
XFILLER_0_547 VPWR VGND sg13cmos5l_decap_8
XFILLER_29_765 VPWR VGND sg13cmos5l_decap_8
XFILLER_17_916 VPWR VGND sg13cmos5l_fill_1
XFILLER_43_234 VPWR VGND sg13cmos5l_fill_2
XFILLER_16_426 VPWR VGND sg13cmos5l_decap_8
XFILLER_40_930 VPWR VGND sg13cmos5l_decap_8
XFILLER_12_610 VPWR VGND sg13cmos5l_fill_1
XFILLER_12_632 VPWR VGND sg13cmos5l_decap_8
XFILLER_12_643 VPWR VGND sg13cmos5l_fill_2
XFILLER_12_654 VPWR VGND sg13cmos5l_decap_8
XFILLER_12_676 VPWR VGND sg13cmos5l_decap_8
XFILLER_7_157 VPWR VGND sg13cmos5l_decap_8
XFILLER_4_853 VPWR VGND sg13cmos5l_decap_8
XFILLER_3_385 VPWR VGND sg13cmos5l_fill_1
XFILLER_26_1003 VPWR VGND sg13cmos5l_decap_8
X_2060_ _2061_/B _3732_/Q _3733_/Q _3734_/Q VPWR VGND sg13cmos5l_o21ai_1
XFILLER_34_245 VPWR VGND sg13cmos5l_decap_8
XFILLER_34_267 VPWR VGND sg13cmos5l_decap_8
XFILLER_15_470 VPWR VGND sg13cmos5l_fill_2
XFILLER_22_429 VPWR VGND sg13cmos5l_decap_8
X_2962_ _3015_/A _3177_/B _3186_/A VPWR VGND sg13cmos5l_nand2b_1
XFILLER_30_440 VPWR VGND sg13cmos5l_decap_4
XFILLER_31_963 VPWR VGND sg13cmos5l_decap_8
X_2893_ _2894_/B _2899_/B _2863_/Y _2899_/A VPWR VGND sg13cmos5l_o21ai_1
XFILLER_30_462 VPWR VGND sg13cmos5l_decap_4
XFILLER_30_495 VPWR VGND sg13cmos5l_fill_2
Xhold603 hold603/X _3513_/Q VPWR VGND sg13cmos5l_dlygate4sd3_1
XFILLER_8_95 VPWR VGND sg13cmos5l_fill_2
Xhold636 hold636/X _3518_/Q VPWR VGND sg13cmos5l_dlygate4sd3_1
Xhold614 hold614/X _3485_/Q VPWR VGND sg13cmos5l_dlygate4sd3_1
XFILLER_7_691 VPWR VGND sg13cmos5l_decap_8
Xhold625 _1948_/A _3777_/Q VPWR VGND sg13cmos5l_dlygate4sd3_1
X_3514_ _3514_/Q _3809_/CLK _3514_/D _3514_/RESET_B VPWR VGND sg13cmos5l_dfrbpq_1
Xhold658 _1996_/A _3596_/Q VPWR VGND sg13cmos5l_dlygate4sd3_1
Xhold647 _3028_/A _3610_/Q VPWR VGND sg13cmos5l_dlygate4sd3_1
X_3445_ _3445_/Y hold675/X _3449_/S _3463_/B VPWR VGND sg13cmos5l_o21ai_1
Xhold669 _3320_/A _3701_/Q VPWR VGND sg13cmos5l_dlygate4sd3_1
X_3376_ _3376_/Y _3697_/Q _3376_/B VPWR VGND sg13cmos5l_nand2_1
X_2327_ _2350_/A _3760_/Q _2337_/B _2342_/A VPWR VGND sg13cmos5l_a21o_1
XFILLER_38_540 VPWR VGND sg13cmos5l_decap_8
X_2258_ _2259_/A _2256_/C _2257_/Y _2256_/Y VPWR VGND sg13cmos5l_a21o_1
XFILLER_27_16 VPWR VGND sg13cmos5l_fill_1
XFILLER_26_713 VPWR VGND sg13cmos5l_fill_2
X_2189_ _2198_/B _3767_/Q _2189_/B VPWR VGND sg13cmos5l_xnor2_1
XFILLER_26_724 VPWR VGND sg13cmos5l_fill_1
XFILLER_26_757 VPWR VGND sg13cmos5l_decap_8
XFILLER_13_407 VPWR VGND sg13cmos5l_decap_8
XFILLER_14_908 VPWR VGND sg13cmos5l_decap_8
XFILLER_13_429 VPWR VGND sg13cmos5l_decap_8
XFILLER_21_440 VPWR VGND sg13cmos5l_decap_8
XFILLER_21_451 VPWR VGND sg13cmos5l_fill_1
XFILLER_22_974 VPWR VGND sg13cmos5l_decap_8
XFILLER_21_484 VPWR VGND sg13cmos5l_decap_4
XFILLER_1_801 VPWR VGND sg13cmos5l_decap_8
XFILLER_1_878 VPWR VGND sg13cmos5l_decap_8
XFILLER_49_838 VPWR VGND sg13cmos5l_decap_8
XFILLER_48_326 VPWR VGND sg13cmos5l_fill_1
XFILLER_17_702 VPWR VGND sg13cmos5l_fill_2
X_3759__462 _3759_/RESET_B VPWR VGND sg13cmos5l_tiehi
XFILLER_44_554 VPWR VGND sg13cmos5l_decap_8
XFILLER_17_71 VPWR VGND sg13cmos5l_fill_1
XFILLER_16_278 VPWR VGND sg13cmos5l_decap_8
XFILLER_32_738 VPWR VGND sg13cmos5l_decap_8
XFILLER_25_790 VPWR VGND sg13cmos5l_decap_8
XFILLER_40_771 VPWR VGND sg13cmos5l_decap_4
XFILLER_9_934 VPWR VGND sg13cmos5l_decap_8
XFILLER_12_451 VPWR VGND sg13cmos5l_fill_2
XFILLER_13_974 VPWR VGND sg13cmos5l_decap_8
X_3766__455 _3766_/RESET_B VPWR VGND sg13cmos5l_tiehi
XFILLER_4_650 VPWR VGND sg13cmos5l_fill_1
X_3230_ _3667_/D _3230_/A _3230_/B VPWR VGND sg13cmos5l_and2_1
X_3161_ _3162_/A hold714/X _3160_/B _3160_/Y VPWR VGND sg13cmos5l_o21ai_1
X_2112_ _2115_/B _3705_/Q _3704_/Q _3706_/Q VPWR VGND sg13cmos5l_o21ai_1
X_3092_ _3093_/A _3644_/Q _3092_/B VPWR VGND sg13cmos5l_xor2_1
X_2043_ _3463_/B _3075_/A _2276_/B VPWR VGND sg13cmos5l_nor2_1
XFILLER_23_705 VPWR VGND sg13cmos5l_decap_8
X_3773__448 _3773_/RESET_B VPWR VGND sg13cmos5l_tiehi
X_2945_ _3133_/C _3638_/Q _3639_/Q VPWR VGND sg13cmos5l_nor2_1
X_2876_ _3608_/D _2876_/A _2911_/B VPWR VGND sg13cmos5l_and2_1
Xhold477 _3347_/B _3662_/Q VPWR VGND sg13cmos5l_dlygate4sd3_1
Xhold499 hold499/X _3566_/Q VPWR VGND sg13cmos5l_dlygate4sd3_1
X_3428_ _3437_/C _3735_/Q _3336_/A _3436_/B VPWR VGND sg13cmos5l_o21ai_1
Xhold488 _2844_/A _3579_/Q VPWR VGND sg13cmos5l_dlygate4sd3_1
X_3359_ _3391_/C _3357_/A _3357_/B _3358_/Y VPWR VGND sg13cmos5l_o21ai_1
XFILLER_38_48 VPWR VGND sg13cmos5l_fill_2
XFILLER_38_37 VPWR VGND sg13cmos5l_fill_1
XFILLER_45_318 VPWR VGND sg13cmos5l_decap_8
XFILLER_13_204 VPWR VGND sg13cmos5l_fill_2
XFILLER_41_568 VPWR VGND sg13cmos5l_fill_1
XFILLER_13_259 VPWR VGND sg13cmos5l_decap_4
XFILLER_6_904 VPWR VGND sg13cmos5l_decap_8
XFILLER_10_966 VPWR VGND sg13cmos5l_decap_8
XFILLER_5_447 VPWR VGND sg13cmos5l_decap_8
X_3685__431 _3685_/RESET_B VPWR VGND sg13cmos5l_tiehi
XFILLER_0_152 VPWR VGND sg13cmos5l_decap_8
X_3568__295 _3568_/RESET_B VPWR VGND sg13cmos5l_tiehi
XFILLER_0_185 VPWR VGND sg13cmos5l_decap_8
XFILLER_23_1028 VPWR VGND sg13cmos5l_fill_1
X_3796__415 _3796_/RESET_B VPWR VGND sg13cmos5l_tiehi
XFILLER_28_70 VPWR VGND sg13cmos5l_fill_2
XFILLER_29_381 VPWR VGND sg13cmos5l_decap_8
XFILLER_45_896 VPWR VGND sg13cmos5l_decap_8
XFILLER_13_771 VPWR VGND sg13cmos5l_fill_2
X_2730_ _2730_/Y _2737_/A1 _3563_/Q _2597_/C VPWR VGND sg13cmos5l_o21ai_1
XFILLER_8_252 VPWR VGND sg13cmos5l_decap_8
X_2661_ _3528_/D input5/X hold554/X _2725_/A VPWR VGND sg13cmos5l_mux2_1
X_2592_ _2592_/X _2592_/A _2592_/B VPWR VGND sg13cmos5l_or2_1
XFILLER_5_992 VPWR VGND sg13cmos5l_decap_8
X_3213_ _3215_/A _3222_/B _3213_/B VPWR VGND sg13cmos5l_or2_1
X_3144_ _3144_/Y _3624_/Q _3350_/A VPWR VGND sg13cmos5l_nor2_1
X_3075_ _3108_/A _3075_/A _3338_/B VPWR VGND sg13cmos5l_nor2_1
XFILLER_36_852 VPWR VGND sg13cmos5l_fill_1
X_2026_ _2564_/A _2026_/A _3804_/Q VPWR VGND sg13cmos5l_or2_1
XFILLER_24_39 VPWR VGND sg13cmos5l_decap_8
X_2928_ _2928_/Y _2928_/A _2928_/B VPWR VGND sg13cmos5l_xnor2_1
XFILLER_40_16 VPWR VGND sg13cmos5l_decap_8
X_2859_ _2860_/C _3029_/A _3589_/Q VPWR VGND sg13cmos5l_nand2_1
XFILLER_46_1028 VPWR VGND sg13cmos5l_fill_1
XFILLER_42_800 VPWR VGND sg13cmos5l_fill_2
X_3756__465 _3756_/RESET_B VPWR VGND sg13cmos5l_tiehi
XFILLER_42_888 VPWR VGND sg13cmos5l_decap_8
XFILLER_10_752 VPWR VGND sg13cmos5l_decap_8
XFILLER_6_745 VPWR VGND sg13cmos5l_decap_8
XFILLER_6_723 VPWR VGND sg13cmos5l_decap_8
XFILLER_6_767 VPWR VGND sg13cmos5l_fill_2
XFILLER_5_244 VPWR VGND sg13cmos5l_fill_1
XFILLER_5_233 VPWR VGND sg13cmos5l_decap_8
XFILLER_2_940 VPWR VGND sg13cmos5l_decap_8
X_3763__458 _3763_/RESET_B VPWR VGND sg13cmos5l_tiehi
XFILLER_49_421 VPWR VGND sg13cmos5l_fill_1
XFILLER_49_498 VPWR VGND sg13cmos5l_decap_8
Xinput9 input9/X uio_in[3] VPWR VGND sg13cmos5l_buf_1
XFILLER_37_627 VPWR VGND sg13cmos5l_decap_8
XFILLER_36_137 VPWR VGND sg13cmos5l_decap_8
XFILLER_18_885 VPWR VGND sg13cmos5l_decap_8
XFILLER_17_384 VPWR VGND sg13cmos5l_fill_2
XFILLER_32_343 VPWR VGND sg13cmos5l_fill_1
X_3762_ _3762_/Q _3766_/CLK _3762_/D _3762_/RESET_B VPWR VGND sg13cmos5l_dfrbpq_1
XFILLER_9_550 VPWR VGND sg13cmos5l_decap_4
XFILLER_13_590 VPWR VGND sg13cmos5l_decap_8
XFILLER_9_583 VPWR VGND sg13cmos5l_fill_1
X_2713_ _2713_/Y _2708_/A _2712_/Y _2707_/Y VPWR VGND sg13cmos5l_o21ai_1
X_3693_ _3693_/Q _3722_/CLK _3693_/D _3693_/RESET_B VPWR VGND sg13cmos5l_dfrbpq_1
X_2644_ _2644_/Y input9/X _2649_/S VPWR VGND sg13cmos5l_nor2_1
X_2575_ _2575_/Y _2035_/X _2567_/A _2573_/Y _2027_/A VPWR VGND sg13cmos5l_a22oi_1
X_3805__208 _3805_/RESET_B VPWR VGND sg13cmos5l_tiehi
X_3127_ _3127_/X _3126_/B _3140_/B _2956_/B VPWR VGND sg13cmos5l_a21o_1
XFILLER_27_115 VPWR VGND sg13cmos5l_fill_1
X_3058_ _3059_/B _2986_/B _3054_/B _3063_/S VPWR VGND sg13cmos5l_mux2_1
XFILLER_23_310 VPWR VGND sg13cmos5l_decap_8
XFILLER_23_332 VPWR VGND sg13cmos5l_decap_8
X_2009_ _3310_/B _2009_/A VPWR VGND sg13cmos5l_inv_1
XFILLER_24_833 VPWR VGND sg13cmos5l_decap_8
XFILLER_35_192 VPWR VGND sg13cmos5l_decap_8
XFILLER_23_343 VPWR VGND sg13cmos5l_fill_2
XFILLER_13_1016 VPWR VGND sg13cmos5l_decap_8
XFILLER_13_1027 VPWR VGND sg13cmos5l_fill_2
XFILLER_3_704 VPWR VGND sg13cmos5l_decap_8
XFILLER_2_236 VPWR VGND sg13cmos5l_decap_8
XFILLER_2_269 VPWR VGND sg13cmos5l_decap_8
XFILLER_47_947 VPWR VGND sg13cmos5l_decap_8
XFILLER_46_413 VPWR VGND sg13cmos5l_decap_8
XFILLER_18_126 VPWR VGND sg13cmos5l_decap_8
XFILLER_15_811 VPWR VGND sg13cmos5l_fill_1
XFILLER_33_129 VPWR VGND sg13cmos5l_fill_2
XFILLER_14_343 VPWR VGND sg13cmos5l_decap_8
XFILLER_14_354 VPWR VGND sg13cmos5l_decap_8
XFILLER_42_685 VPWR VGND sg13cmos5l_decap_4
XFILLER_41_173 VPWR VGND sg13cmos5l_fill_2
XFILLER_30_836 VPWR VGND sg13cmos5l_decap_8
XFILLER_30_858 VPWR VGND sg13cmos5l_decap_8
XFILLER_41_81 VPWR VGND sg13cmos5l_decap_8
XFILLER_6_597 VPWR VGND sg13cmos5l_decap_8
XFILLER_29_1001 VPWR VGND sg13cmos5l_decap_8
X_2360_ _2361_/B _2342_/X _2346_/B _2360_/S VPWR VGND sg13cmos5l_mux2_1
X_3724__217 _3724_/RESET_B VPWR VGND sg13cmos5l_tiehi
X_2291_ _2741_/A _2291_/A _2579_/A _2291_/C VPWR VGND sg13cmos5l_nor3_1
XFILLER_1_280 VPWR VGND sg13cmos5l_fill_1
XFILLER_49_262 VPWR VGND sg13cmos5l_decap_8
XFILLER_37_424 VPWR VGND sg13cmos5l_decap_4
XFILLER_49_295 VPWR VGND sg13cmos5l_decap_8
X_3577__125 _3577_/D VPWR VGND sg13cmos5l_tielo
XFILLER_21_825 VPWR VGND sg13cmos5l_decap_8
X_3745_ _3745_/Q clkload4/A _3745_/D _3745_/RESET_B VPWR VGND sg13cmos5l_dfrbpq_1
X_3676_ _3676_/Q _3712_/CLK _3676_/D _3676_/RESET_B VPWR VGND sg13cmos5l_dfrbpq_1
X_2627_ _3502_/D input13/X hold578/X _2627_/S VPWR VGND sg13cmos5l_mux2_1
X_2558_ _3791_/D _2558_/A _2558_/B _2558_/C VPWR VGND sg13cmos5l_nor3_1
X_2489_ _2489_/Y _3766_/Q _2511_/A _2484_/B _3765_/Q VPWR VGND sg13cmos5l_a22oi_1
X_3625__115 _3625_/D VPWR VGND sg13cmos5l_tielo
XFILLER_28_413 VPWR VGND sg13cmos5l_decap_8
XFILLER_28_446 VPWR VGND sg13cmos5l_fill_1
XFILLER_44_917 VPWR VGND sg13cmos5l_decap_8
XFILLER_23_162 VPWR VGND sg13cmos5l_decap_8
XFILLER_24_685 VPWR VGND sg13cmos5l_decap_8
XFILLER_7_339 VPWR VGND sg13cmos5l_decap_8
XFILLER_4_1014 VPWR VGND sg13cmos5l_decap_8
XFILLER_47_744 VPWR VGND sg13cmos5l_decap_8
XFILLER_19_446 VPWR VGND sg13cmos5l_decap_8
XFILLER_35_906 VPWR VGND sg13cmos5l_fill_2
XFILLER_35_928 VPWR VGND sg13cmos5l_decap_4
XFILLER_15_641 VPWR VGND sg13cmos5l_decap_8
XFILLER_36_92 VPWR VGND sg13cmos5l_decap_4
XFILLER_43_983 VPWR VGND sg13cmos5l_decap_8
XFILLER_42_482 VPWR VGND sg13cmos5l_decap_4
Xinput12 input12/X uio_in[6] VPWR VGND sg13cmos5l_buf_1
XFILLER_30_699 VPWR VGND sg13cmos5l_decap_8
X_3550__331 _3550_/RESET_B VPWR VGND sg13cmos5l_tiehi
X_3530_ _3530_/Q clkload7/A _3530_/D _3530_/RESET_B VPWR VGND sg13cmos5l_dfrbpq_1
XFILLER_7_862 VPWR VGND sg13cmos5l_decap_8
Xhold807 _3248_/A _3675_/Q VPWR VGND sg13cmos5l_dlygate4sd3_1
Xhold818 _2524_/A _3785_/Q VPWR VGND sg13cmos5l_dlygate4sd3_1
X_3461_ _3725_/D _3461_/A _3461_/B VPWR VGND sg13cmos5l_and2_1
X_2412_ _2412_/Y _2386_/B _2372_/Y _2390_/Y _2394_/Y _2396_/A VPWR VGND sg13cmos5l_a221oi_1
X_3392_ _3409_/A _3267_/B _3360_/X _3391_/Y VPWR VGND sg13cmos5l_o21ai_1
X_2343_ _2346_/B _2238_/B _2201_/B _2343_/S VPWR VGND sg13cmos5l_mux2_1
XFILLER_38_700 VPWR VGND sg13cmos5l_fill_1
X_2274_ _2274_/Y _3750_/Q _2274_/B VPWR VGND sg13cmos5l_nand2b_1
XFILLER_37_232 VPWR VGND sg13cmos5l_decap_8
XFILLER_37_287 VPWR VGND sg13cmos5l_decap_4
XFILLER_19_991 VPWR VGND sg13cmos5l_decap_8
XFILLER_25_449 VPWR VGND sg13cmos5l_fill_1
Xclkbuf_leaf_17_clk _3712_/CLK clkbuf_leaf_2_clk/A VPWR VGND sg13cmos5l_buf_8
XFILLER_18_490 VPWR VGND sg13cmos5l_decap_8
XFILLER_34_961 VPWR VGND sg13cmos5l_decap_8
XFILLER_21_622 VPWR VGND sg13cmos5l_fill_1
XFILLER_32_17 VPWR VGND sg13cmos5l_decap_8
XFILLER_21_688 VPWR VGND sg13cmos5l_decap_4
X_1989_ _1989_/Y _1989_/A VPWR VGND sg13cmos5l_inv_1
XFILLER_10_1008 VPWR VGND sg13cmos5l_decap_8
X_3728_ _3728_/Q _3728_/CLK _3728_/D _3728_/RESET_B VPWR VGND sg13cmos5l_dfrbpq_1
X_3659_ _3659_/Q _3664_/CLK _3659_/D _3659_/RESET_B VPWR VGND sg13cmos5l_dfrbpq_1
XFILLER_29_711 VPWR VGND sg13cmos5l_decap_4
XFILLER_28_232 VPWR VGND sg13cmos5l_decap_8
XFILLER_29_799 VPWR VGND sg13cmos5l_decap_8
XFILLER_44_758 VPWR VGND sg13cmos5l_decap_8
XFILLER_43_213 VPWR VGND sg13cmos5l_decap_8
XFILLER_16_416 VPWR VGND sg13cmos5l_fill_2
XFILLER_25_994 VPWR VGND sg13cmos5l_decap_8
XFILLER_40_986 VPWR VGND sg13cmos5l_decap_8
XFILLER_11_165 VPWR VGND sg13cmos5l_decap_8
XFILLER_22_94 VPWR VGND sg13cmos5l_decap_4
XFILLER_4_832 VPWR VGND sg13cmos5l_decap_8
XFILLER_47_91 VPWR VGND sg13cmos5l_decap_4
XFILLER_34_224 VPWR VGND sg13cmos5l_decap_8
XFILLER_35_769 VPWR VGND sg13cmos5l_decap_8
XFILLER_16_994 VPWR VGND sg13cmos5l_decap_8
X_2961_ _3030_/B _3075_/A _3177_/B VPWR VGND sg13cmos5l_nor2_1
XFILLER_42_290 VPWR VGND sg13cmos5l_fill_1
XFILLER_31_942 VPWR VGND sg13cmos5l_decap_8
X_2892_ _2894_/A _3598_/Q _2863_/Y _2886_/Y _2890_/Y _2891_/Y VPWR VGND sg13cmos5l_a221oi_1
XFILLER_7_670 VPWR VGND sg13cmos5l_decap_8
Xhold604 hold604/X _3508_/Q VPWR VGND sg13cmos5l_dlygate4sd3_1
Xhold615 hold615/X _3484_/Q VPWR VGND sg13cmos5l_dlygate4sd3_1
X_3513_ _3513_/Q clkload7/A _3513_/D _3513_/RESET_B VPWR VGND sg13cmos5l_dfrbpq_1
Xhold626 _3777_/D _2454_/Y VPWR VGND sg13cmos5l_dlygate4sd3_1
Xclkbuf_leaf_6_clk clkload8/A clkbuf_leaf_9_clk/A VPWR VGND sg13cmos5l_buf_8
Xhold659 _3596_/D _2896_/Y VPWR VGND sg13cmos5l_dlygate4sd3_1
Xhold648 _1970_/A _3734_/Q VPWR VGND sg13cmos5l_dlygate4sd3_1
X_3444_ _3449_/S _3444_/A _3444_/B VPWR VGND sg13cmos5l_or2_1
Xhold637 _2072_/A _3722_/Q VPWR VGND sg13cmos5l_dlygate4sd3_1
X_3375_ _3375_/Y _3375_/A VPWR VGND sg13cmos5l_inv_1
X_3626__221 _3626_/RESET_B VPWR VGND sg13cmos5l_tiehi
X_2326_ _2342_/A _2341_/A _2341_/B _2341_/C VPWR VGND sg13cmos5l_a21oi_1
X_2257_ _2257_/Y _2466_/A _2257_/B VPWR VGND sg13cmos5l_nor2_1
XFILLER_38_563 VPWR VGND sg13cmos5l_fill_1
XFILLER_27_39 VPWR VGND sg13cmos5l_decap_8
X_2188_ _2498_/B _2257_/B _2189_/B VPWR VGND sg13cmos5l_nor2_1
XFILLER_25_224 VPWR VGND sg13cmos5l_decap_4
XFILLER_26_736 VPWR VGND sg13cmos5l_decap_8
XFILLER_41_717 VPWR VGND sg13cmos5l_fill_1
XFILLER_25_268 VPWR VGND sg13cmos5l_decap_4
XFILLER_21_496 VPWR VGND sg13cmos5l_decap_8
XFILLER_5_629 VPWR VGND sg13cmos5l_fill_2
XFILLER_5_607 VPWR VGND sg13cmos5l_fill_2
XFILLER_4_106 VPWR VGND sg13cmos5l_fill_2
XFILLER_0_312 VPWR VGND sg13cmos5l_decap_4
XFILLER_0_334 VPWR VGND sg13cmos5l_decap_8
XFILLER_0_345 VPWR VGND sg13cmos5l_fill_2
XFILLER_1_857 VPWR VGND sg13cmos5l_decap_8
XFILLER_49_817 VPWR VGND sg13cmos5l_decap_8
XFILLER_0_389 VPWR VGND sg13cmos5l_decap_8
XFILLER_17_736 VPWR VGND sg13cmos5l_decap_8
XFILLER_16_246 VPWR VGND sg13cmos5l_decap_4
XFILLER_44_588 VPWR VGND sg13cmos5l_fill_1
XFILLER_32_717 VPWR VGND sg13cmos5l_decap_8
XFILLER_13_942 VPWR VGND sg13cmos5l_fill_2
XFILLER_31_238 VPWR VGND sg13cmos5l_fill_2
XFILLER_40_750 VPWR VGND sg13cmos5l_decap_8
XFILLER_8_412 VPWR VGND sg13cmos5l_decap_4
XFILLER_9_913 VPWR VGND sg13cmos5l_decap_8
XFILLER_12_485 VPWR VGND sg13cmos5l_decap_8
XFILLER_33_93 VPWR VGND sg13cmos5l_decap_8
XFILLER_8_467 VPWR VGND sg13cmos5l_fill_2
XFILLER_4_673 VPWR VGND sg13cmos5l_decap_8
X_3160_ _3160_/Y _3352_/A _3160_/B _3160_/C VPWR VGND sg13cmos5l_nand3b_1
X_3091_ _3098_/B _3644_/Q _3092_/B VPWR VGND sg13cmos5l_nor2_1
X_2111_ _2135_/A _2214_/A _2111_/B VPWR VGND sg13cmos5l_nor2_1
XFILLER_12_4 VPWR VGND sg13cmos5l_decap_8
X_2042_ _3807_/D _3805_/D _3806_/D _3804_/D VPWR VGND sg13cmos5l_or3_1
XFILLER_48_894 VPWR VGND sg13cmos5l_decap_8
XFILLER_22_238 VPWR VGND sg13cmos5l_decap_8
X_2944_ _2944_/Y _2944_/A _2944_/B VPWR VGND sg13cmos5l_nand2_1
XFILLER_31_772 VPWR VGND sg13cmos5l_decap_8
X_2875_ _3590_/D _2939_/A _2921_/A VPWR VGND sg13cmos5l_nor2_1
Xhold467 _3346_/B _3661_/Q VPWR VGND sg13cmos5l_dlygate4sd3_1
Xhold478 _3203_/B _3632_/Q VPWR VGND sg13cmos5l_dlygate4sd3_1
X_3427_ _3427_/X _3682_/Q _3436_/B VPWR VGND sg13cmos5l_and2_1
Xhold489 _3601_/D _2903_/Y VPWR VGND sg13cmos5l_dlygate4sd3_1
X_3358_ _3358_/Y _3267_/B _3391_/A _3395_/B _3270_/B VPWR VGND sg13cmos5l_a22oi_1
X_2309_ _2309_/Y _2512_/A _2205_/B _2347_/B VPWR VGND sg13cmos5l_o21ai_1
XFILLER_39_850 VPWR VGND sg13cmos5l_decap_8
X_3289_ _3289_/Y _3646_/Q _3298_/B VPWR VGND sg13cmos5l_nor2_1
XFILLER_10_901 VPWR VGND sg13cmos5l_fill_2
XFILLER_10_945 VPWR VGND sg13cmos5l_decap_8
X_3789__423 _3789_/RESET_B VPWR VGND sg13cmos5l_tiehi
XFILLER_5_426 VPWR VGND sg13cmos5l_decap_4
XFILLER_0_120 VPWR VGND sg13cmos5l_decap_8
XFILLER_48_102 VPWR VGND sg13cmos5l_fill_2
XFILLER_28_82 VPWR VGND sg13cmos5l_decap_8
XFILLER_45_875 VPWR VGND sg13cmos5l_decap_8
XFILLER_32_558 VPWR VGND sg13cmos5l_decap_4
XFILLER_44_92 VPWR VGND sg13cmos5l_fill_1
XFILLER_9_754 VPWR VGND sg13cmos5l_decap_8
X_2660_ _3527_/D input13/X hold592/X _2660_/S VPWR VGND sg13cmos5l_mux2_1
XFILLER_40_591 VPWR VGND sg13cmos5l_decap_4
XFILLER_9_765 VPWR VGND sg13cmos5l_fill_2
XFILLER_8_286 VPWR VGND sg13cmos5l_decap_8
XFILLER_9_798 VPWR VGND sg13cmos5l_decap_8
X_2591_ _3799_/D _3075_/A _2591_/B VPWR VGND sg13cmos5l_nor2_1
XFILLER_5_971 VPWR VGND sg13cmos5l_decap_8
XFILLER_4_481 VPWR VGND sg13cmos5l_decap_8
X_3547__336 _3547_/RESET_B VPWR VGND sg13cmos5l_tiehi
X_3212_ _3212_/Y _3212_/A _3212_/B VPWR VGND sg13cmos5l_xnor2_1
X_3143_ _3648_/D _3143_/A _3143_/B VPWR VGND sg13cmos5l_nor2_1
X_3074_ _3639_/D _3051_/B _3073_/X _3072_/A VPWR VGND sg13cmos5l_a21oi_1
XFILLER_48_691 VPWR VGND sg13cmos5l_fill_2
X_2025_ _2577_/B _3805_/Q _3804_/Q VPWR VGND sg13cmos5l_nor2_1
XFILLER_35_330 VPWR VGND sg13cmos5l_fill_1
XFILLER_36_886 VPWR VGND sg13cmos5l_decap_8
XFILLER_35_352 VPWR VGND sg13cmos5l_decap_8
XFILLER_24_18 VPWR VGND sg13cmos5l_decap_8
X_2927_ _2928_/B _2927_/A _2927_/B VPWR VGND sg13cmos5l_nor2_1
XFILLER_31_591 VPWR VGND sg13cmos5l_fill_1
X_2858_ _2858_/Y _3588_/Q _3589_/Q VPWR VGND sg13cmos5l_xnor2_1
XFILLER_40_39 VPWR VGND sg13cmos5l_decap_8
X_2789_ _2789_/X _3543_/Q _3526_/Q _3509_/Q _3492_/Q _2810_/A1 _2810_/B1 VPWR VGND
+ sg13cmos5l_mux4_1
XFILLER_49_37 VPWR VGND sg13cmos5l_decap_8
XFILLER_46_1007 VPWR VGND sg13cmos5l_decap_8
XFILLER_6_9 VPWR VGND sg13cmos5l_decap_8
XFILLER_27_820 VPWR VGND sg13cmos5l_decap_8
XFILLER_39_691 VPWR VGND sg13cmos5l_decap_8
X_3598__256 _3598_/RESET_B VPWR VGND sg13cmos5l_tiehi
XFILLER_26_341 VPWR VGND sg13cmos5l_decap_8
XFILLER_42_845 VPWR VGND sg13cmos5l_decap_8
XFILLER_42_867 VPWR VGND sg13cmos5l_decap_8
XFILLER_41_377 VPWR VGND sg13cmos5l_decap_8
XFILLER_22_580 VPWR VGND sg13cmos5l_decap_8
XFILLER_6_702 VPWR VGND sg13cmos5l_decap_8
XFILLER_10_731 VPWR VGND sg13cmos5l_decap_8
XFILLER_14_73 VPWR VGND sg13cmos5l_fill_1
XFILLER_5_212 VPWR VGND sg13cmos5l_decap_8
XFILLER_5_223 VPWR VGND sg13cmos5l_fill_1
XFILLER_30_94 VPWR VGND sg13cmos5l_decap_8
XFILLER_49_433 VPWR VGND sg13cmos5l_decap_8
XFILLER_7_1023 VPWR VGND sg13cmos5l_decap_4
XFILLER_2_996 VPWR VGND sg13cmos5l_decap_8
XFILLER_45_661 VPWR VGND sg13cmos5l_fill_2
XFILLER_45_650 VPWR VGND sg13cmos5l_decap_8
XFILLER_33_812 VPWR VGND sg13cmos5l_decap_8
XFILLER_44_160 VPWR VGND sg13cmos5l_decap_4
XFILLER_32_355 VPWR VGND sg13cmos5l_fill_1
X_3761_ _3761_/Q _3766_/CLK _3761_/D _3761_/RESET_B VPWR VGND sg13cmos5l_dfrbpq_1
X_2712_ _2712_/Y _2717_/C _2712_/B VPWR VGND sg13cmos5l_nand2b_1
XFILLER_9_595 VPWR VGND sg13cmos5l_decap_8
X_3692_ _3692_/Q _3728_/CLK _3692_/D _3692_/RESET_B VPWR VGND sg13cmos5l_dfrbpq_1
X_2643_ _3514_/D _1989_/Y _2649_/S _2642_/Y VPWR VGND sg13cmos5l_a21oi_1
X_2574_ _2574_/Y _2567_/Y _2571_/Y _2573_/Y _1954_/Y _2586_/A VPWR VGND sg13cmos5l_a221oi_1
XFILLER_5_790 VPWR VGND sg13cmos5l_fill_2
XFILLER_19_29 VPWR VGND sg13cmos5l_fill_2
X_3560__311 _3560_/RESET_B VPWR VGND sg13cmos5l_tiehi
X_3126_ _3126_/X _3621_/Q _3126_/B VPWR VGND sg13cmos5l_xor2_1
X_3057_ _3063_/S _2970_/B _3050_/B _3056_/Y VPWR VGND sg13cmos5l_a21oi_1
XFILLER_43_609 VPWR VGND sg13cmos5l_fill_1
XFILLER_35_39 VPWR VGND sg13cmos5l_decap_8
X_2008_ _2008_/Y _3652_/Q VPWR VGND sg13cmos5l_inv_1
X_3786__426 _3786_/RESET_B VPWR VGND sg13cmos5l_tiehi
XFILLER_2_204 VPWR VGND sg13cmos5l_decap_8
XFILLER_3_749 VPWR VGND sg13cmos5l_decap_8
XFILLER_47_926 VPWR VGND sg13cmos5l_decap_8
XFILLER_19_639 VPWR VGND sg13cmos5l_fill_1
X_3793__419 _3793_/RESET_B VPWR VGND sg13cmos5l_tiehi
XFILLER_42_664 VPWR VGND sg13cmos5l_decap_8
XFILLER_42_642 VPWR VGND sg13cmos5l_decap_8
XFILLER_15_878 VPWR VGND sg13cmos5l_fill_2
XFILLER_25_50 VPWR VGND sg13cmos5l_decap_8
XFILLER_41_163 VPWR VGND sg13cmos5l_fill_1
X_3537__346 _3537_/RESET_B VPWR VGND sg13cmos5l_tiehi
XFILLER_6_554 VPWR VGND sg13cmos5l_decap_4
XFILLER_6_565 VPWR VGND sg13cmos5l_decap_8
XFILLER_2_793 VPWR VGND sg13cmos5l_decap_8
X_2290_ _2291_/C _2290_/A _3809_/Q VPWR VGND sg13cmos5l_nor2b_1
X_3544__339 _3544_/RESET_B VPWR VGND sg13cmos5l_tiehi
XFILLER_2_21 VPWR VGND sg13cmos5l_decap_8
XFILLER_37_403 VPWR VGND sg13cmos5l_decap_8
XFILLER_17_193 VPWR VGND sg13cmos5l_decap_8
XFILLER_32_130 VPWR VGND sg13cmos5l_decap_8
XFILLER_33_675 VPWR VGND sg13cmos5l_decap_8
XFILLER_20_347 VPWR VGND sg13cmos5l_fill_2
X_3744_ _3744_/Q clkload3/A _3744_/D _3744_/RESET_B VPWR VGND sg13cmos5l_dfrbpq_1
X_3675_ _3675_/Q _3712_/CLK _3675_/D _3675_/RESET_B VPWR VGND sg13cmos5l_dfrbpq_1
X_2626_ _3501_/D input12/X hold620/X _2627_/S VPWR VGND sg13cmos5l_mux2_1
X_3588__266 _3588_/RESET_B VPWR VGND sg13cmos5l_tiehi
XFILLER_0_719 VPWR VGND sg13cmos5l_decap_8
X_2557_ _2558_/C _2557_/A _2560_/B _2560_/C VPWR VGND sg13cmos5l_and3_1
X_2488_ _2488_/Y _2486_/Y _2487_/Y _2485_/Y VPWR VGND sg13cmos5l_a21oi_1
XFILLER_29_959 VPWR VGND sg13cmos5l_decap_8
X_3109_ _3109_/X _3109_/A _3287_/A VPWR VGND sg13cmos5l_and2_1
X_3595__259 _3595_/RESET_B VPWR VGND sg13cmos5l_tiehi
XFILLER_24_642 VPWR VGND sg13cmos5l_decap_4
XFILLER_24_664 VPWR VGND sg13cmos5l_fill_2
XFILLER_36_491 VPWR VGND sg13cmos5l_decap_8
XFILLER_11_303 VPWR VGND sg13cmos5l_decap_8
XFILLER_11_314 VPWR VGND sg13cmos5l_fill_2
XFILLER_23_141 VPWR VGND sg13cmos5l_decap_8
XFILLER_11_347 VPWR VGND sg13cmos5l_decap_8
XFILLER_7_318 VPWR VGND sg13cmos5l_decap_8
XFILLER_20_870 VPWR VGND sg13cmos5l_fill_2
XFILLER_20_892 VPWR VGND sg13cmos5l_decap_4
XFILLER_3_546 VPWR VGND sg13cmos5l_decap_8
XFILLER_19_425 VPWR VGND sg13cmos5l_decap_8
XFILLER_46_288 VPWR VGND sg13cmos5l_decap_8
XFILLER_46_277 VPWR VGND sg13cmos5l_fill_1
XFILLER_34_417 VPWR VGND sg13cmos5l_decap_8
XFILLER_34_428 VPWR VGND sg13cmos5l_fill_2
XFILLER_43_962 VPWR VGND sg13cmos5l_decap_8
XFILLER_14_163 VPWR VGND sg13cmos5l_fill_1
Xinput13 input13/X uio_in[7] VPWR VGND sg13cmos5l_buf_1
XFILLER_7_841 VPWR VGND sg13cmos5l_decap_8
XFILLER_6_362 VPWR VGND sg13cmos5l_decap_8
Xhold808 _2202_/A _3767_/Q VPWR VGND sg13cmos5l_dlygate4sd3_1
Xhold819 _3052_/A _3636_/Q VPWR VGND sg13cmos5l_dlygate4sd3_1
XFILLER_6_384 VPWR VGND sg13cmos5l_decap_8
X_3460_ _3724_/D _3460_/A _3460_/B VPWR VGND sg13cmos5l_and2_1
XFILLER_42_4 VPWR VGND sg13cmos5l_fill_2
X_2411_ _2411_/X _2411_/A _2411_/B VPWR VGND sg13cmos5l_and2_1
X_3391_ _3391_/Y _3391_/A _3391_/B _3391_/C VPWR VGND sg13cmos5l_nand3_1
X_2342_ _2342_/X _2342_/A _2342_/B _2342_/C VPWR VGND sg13cmos5l_or3_1
X_3728__173 _3728_/RESET_B VPWR VGND sg13cmos5l_tiehi
XFILLER_42_1021 VPWR VGND sg13cmos5l_decap_8
X_2273_ _2273_/Y _2259_/Y hold746/X _2272_/Y VPWR VGND sg13cmos5l_a21oi_1
XFILLER_38_789 VPWR VGND sg13cmos5l_decap_8
XFILLER_38_767 VPWR VGND sg13cmos5l_fill_2
XFILLER_37_266 VPWR VGND sg13cmos5l_decap_8
XFILLER_37_255 VPWR VGND sg13cmos5l_fill_1
XFILLER_19_970 VPWR VGND sg13cmos5l_decap_8
XFILLER_25_439 VPWR VGND sg13cmos5l_decap_4
XFILLER_40_409 VPWR VGND sg13cmos5l_fill_2
XFILLER_20_133 VPWR VGND sg13cmos5l_decap_8
XFILLER_20_166 VPWR VGND sg13cmos5l_decap_8
X_3727_ _3727_/Q _3728_/CLK _3727_/D _3727_/RESET_B VPWR VGND sg13cmos5l_dfrbpq_1
X_1988_ _3236_/A _3347_/A VPWR VGND sg13cmos5l_inv_1
X_3658_ _3658_/Q _3664_/CLK _3658_/D _3658_/RESET_B VPWR VGND sg13cmos5l_dfrbpq_1
X_3589_ _3589_/Q clkload9/A _3589_/D _3589_/RESET_B VPWR VGND sg13cmos5l_dfrbpq_1
X_2609_ _3486_/D input6/X hold549/X _2617_/S VPWR VGND sg13cmos5l_mux2_1
XFILLER_0_527 VPWR VGND sg13cmos5l_decap_8
XFILLER_48_509 VPWR VGND sg13cmos5l_decap_8
X_3527__356 _3527_/RESET_B VPWR VGND sg13cmos5l_tiehi
XFILLER_28_211 VPWR VGND sg13cmos5l_decap_8
XFILLER_44_704 VPWR VGND sg13cmos5l_decap_4
Xclkbuf_2_2__f_clk clkbuf_leaf_2_clk/A clkbuf_0_clk/X VPWR VGND sg13cmos5l_buf_8
XFILLER_17_907 VPWR VGND sg13cmos5l_decap_8
XFILLER_28_299 VPWR VGND sg13cmos5l_fill_1
XFILLER_43_247 VPWR VGND sg13cmos5l_decap_4
XFILLER_43_236 VPWR VGND sg13cmos5l_fill_1
XFILLER_12_601 VPWR VGND sg13cmos5l_decap_8
XFILLER_19_1012 VPWR VGND sg13cmos5l_decap_8
XFILLER_25_973 VPWR VGND sg13cmos5l_decap_8
XFILLER_11_111 VPWR VGND sg13cmos5l_decap_8
XFILLER_24_494 VPWR VGND sg13cmos5l_fill_2
XFILLER_40_965 VPWR VGND sg13cmos5l_decap_8
XFILLER_8_638 VPWR VGND sg13cmos5l_decap_8
XFILLER_11_144 VPWR VGND sg13cmos5l_decap_4
X_3534__349 _3534_/RESET_B VPWR VGND sg13cmos5l_tiehi
XFILLER_8_649 VPWR VGND sg13cmos5l_fill_1
XFILLER_22_73 VPWR VGND sg13cmos5l_decap_8
XFILLER_4_888 VPWR VGND sg13cmos5l_decap_8
XFILLER_0_0 VPWR VGND sg13cmos5l_decap_8
XFILLER_47_520 VPWR VGND sg13cmos5l_decap_8
XFILLER_47_70 VPWR VGND sg13cmos5l_decap_4
XFILLER_19_255 VPWR VGND sg13cmos5l_decap_8
XFILLER_35_715 VPWR VGND sg13cmos5l_fill_2
XFILLER_19_266 VPWR VGND sg13cmos5l_fill_1
XFILLER_19_299 VPWR VGND sg13cmos5l_decap_4
X_2960_ _3054_/B _1963_/A _2958_/Y _2959_/X _1961_/Y VPWR VGND sg13cmos5l_a22oi_1
XFILLER_16_973 VPWR VGND sg13cmos5l_decap_8
X_2891_ _2891_/Y _3000_/B _2891_/B VPWR VGND sg13cmos5l_nor2_1
XFILLER_15_483 VPWR VGND sg13cmos5l_decap_8
XFILLER_8_42 VPWR VGND sg13cmos5l_fill_2
XFILLER_30_453 VPWR VGND sg13cmos5l_fill_1
XFILLER_30_486 VPWR VGND sg13cmos5l_decap_4
XFILLER_31_998 VPWR VGND sg13cmos5l_decap_8
XFILLER_8_97 VPWR VGND sg13cmos5l_fill_1
Xhold605 hold605/X _3482_/Q VPWR VGND sg13cmos5l_dlygate4sd3_1
Xhold627 _1951_/A _3775_/Q VPWR VGND sg13cmos5l_dlygate4sd3_1
Xhold616 _3177_/B _3626_/Q VPWR VGND sg13cmos5l_dlygate4sd3_1
X_3512_ _3512_/Q clkload7/A _3512_/D _3512_/RESET_B VPWR VGND sg13cmos5l_dfrbpq_1
XFILLER_6_181 VPWR VGND sg13cmos5l_decap_8
X_3443_ _3444_/B _3717_/Q _3441_/Y _2261_/A VPWR VGND sg13cmos5l_o21ai_1
Xhold649 _1955_/A _3754_/Q VPWR VGND sg13cmos5l_dlygate4sd3_1
Xhold638 _3754_/D _2300_/Y VPWR VGND sg13cmos5l_dlygate4sd3_1
X_3585__269 _3585_/RESET_B VPWR VGND sg13cmos5l_tiehi
X_3374_ _3375_/A _3697_/Q _3376_/B _3397_/A VPWR VGND sg13cmos5l_o21ai_1
XFILLER_33_0 VPWR VGND sg13cmos5l_decap_4
X_2325_ _2341_/C _3760_/Q _2337_/B VPWR VGND sg13cmos5l_xnor2_1
X_2256_ _2256_/Y _3718_/Q _2256_/B _2256_/C VPWR VGND sg13cmos5l_nor3_1
X_2187_ _2187_/Y _2257_/B _2189_/B VPWR VGND sg13cmos5l_nand2_1
XFILLER_25_247 VPWR VGND sg13cmos5l_decap_8
XFILLER_40_239 VPWR VGND sg13cmos5l_decap_8
XFILLER_40_228 VPWR VGND sg13cmos5l_decap_8
XFILLER_4_129 VPWR VGND sg13cmos5l_fill_1
XFILLER_49_1027 VPWR VGND sg13cmos5l_fill_2
XFILLER_1_836 VPWR VGND sg13cmos5l_decap_8
XFILLER_29_531 VPWR VGND sg13cmos5l_fill_1
XFILLER_29_542 VPWR VGND sg13cmos5l_decap_4
XFILLER_44_512 VPWR VGND sg13cmos5l_decap_8
XFILLER_1_1018 VPWR VGND sg13cmos5l_decap_8
XFILLER_32_707 VPWR VGND sg13cmos5l_fill_1
XFILLER_25_781 VPWR VGND sg13cmos5l_decap_4
XFILLER_12_453 VPWR VGND sg13cmos5l_fill_1
XFILLER_12_464 VPWR VGND sg13cmos5l_fill_2
XFILLER_9_969 VPWR VGND sg13cmos5l_decap_8
XFILLER_12_497 VPWR VGND sg13cmos5l_decap_8
XFILLER_33_72 VPWR VGND sg13cmos5l_decap_8
XFILLER_39_317 VPWR VGND sg13cmos5l_decap_4
X_2110_ _2110_/Y _3420_/B _3416_/B VPWR VGND sg13cmos5l_nand2_1
X_3090_ _3114_/A _3670_/Q _3090_/B VPWR VGND sg13cmos5l_xor2_1
XFILLER_48_873 VPWR VGND sg13cmos5l_decap_8
X_2041_ _3804_/D _2755_/A _2041_/B VPWR VGND sg13cmos5l_and2_1
XFILLER_47_383 VPWR VGND sg13cmos5l_decap_8
XFILLER_35_589 VPWR VGND sg13cmos5l_decap_8
X_2943_ _2944_/B _2943_/A _2956_/A VPWR VGND sg13cmos5l_or2_1
XFILLER_22_217 VPWR VGND sg13cmos5l_decap_8
XFILLER_15_291 VPWR VGND sg13cmos5l_decap_8
XFILLER_31_740 VPWR VGND sg13cmos5l_decap_8
X_2874_ _2921_/A _2852_/Y _2857_/Y _2982_/A _2979_/A VPWR VGND sg13cmos5l_a22oi_1
XFILLER_31_795 VPWR VGND sg13cmos5l_decap_8
X_3517__366 _3517_/RESET_B VPWR VGND sg13cmos5l_tiehi
Xhold468 _3345_/B _3660_/Q VPWR VGND sg13cmos5l_dlygate4sd3_1
X_3426_ _3436_/B _3422_/Y _3424_/Y _3425_/Y VPWR VGND sg13cmos5l_o21ai_1
Xhold479 _2909_/B _3583_/Q VPWR VGND sg13cmos5l_dlygate4sd3_1
X_3357_ _3357_/X _3357_/A _3357_/B VPWR VGND sg13cmos5l_or2_1
X_2308_ _3762_/D _3437_/B _2361_/A VPWR VGND sg13cmos5l_nor2_1
XFILLER_39_862 VPWR VGND sg13cmos5l_decap_8
X_3288_ _3299_/S _3288_/A _3288_/B VPWR VGND sg13cmos5l_nor2_1
X_3524__359 _3524_/RESET_B VPWR VGND sg13cmos5l_tiehi
XFILLER_39_884 VPWR VGND sg13cmos5l_decap_8
XFILLER_38_372 VPWR VGND sg13cmos5l_decap_8
X_2239_ _2347_/B _2231_/A _2213_/Y _2064_/X VPWR VGND sg13cmos5l_a21oi_1
XFILLER_26_512 VPWR VGND sg13cmos5l_decap_8
XFILLER_26_567 VPWR VGND sg13cmos5l_fill_1
XFILLER_41_537 VPWR VGND sg13cmos5l_fill_2
XFILLER_16_1015 VPWR VGND sg13cmos5l_decap_8
XFILLER_22_740 VPWR VGND sg13cmos5l_decap_8
XFILLER_22_795 VPWR VGND sg13cmos5l_fill_2
XFILLER_21_283 VPWR VGND sg13cmos5l_decap_8
XFILLER_6_939 VPWR VGND sg13cmos5l_decap_8
XFILLER_5_438 VPWR VGND sg13cmos5l_fill_1
XFILLER_49_604 VPWR VGND sg13cmos5l_decap_8
XFILLER_49_648 VPWR VGND sg13cmos5l_decap_8
XFILLER_49_626 VPWR VGND sg13cmos5l_decap_8
XFILLER_23_1019 VPWR VGND sg13cmos5l_decap_8
XFILLER_29_361 VPWR VGND sg13cmos5l_fill_2
XFILLER_45_854 VPWR VGND sg13cmos5l_decap_8
XFILLER_44_342 VPWR VGND sg13cmos5l_fill_1
XFILLER_32_504 VPWR VGND sg13cmos5l_decap_4
XFILLER_44_71 VPWR VGND sg13cmos5l_decap_8
XFILLER_13_740 VPWR VGND sg13cmos5l_fill_1
XFILLER_40_570 VPWR VGND sg13cmos5l_decap_8
XFILLER_8_210 VPWR VGND sg13cmos5l_decap_4
XFILLER_13_784 VPWR VGND sg13cmos5l_decap_8
XFILLER_9_777 VPWR VGND sg13cmos5l_fill_2
XFILLER_5_950 VPWR VGND sg13cmos5l_decap_8
X_2590_ _2590_/Y _2587_/A _2581_/X _2589_/Y VPWR VGND sg13cmos5l_a21oi_1
X_3211_ _3212_/B _3663_/Q _3216_/B _3197_/Y VPWR VGND sg13cmos5l_a21oi_1
X_3142_ _3192_/C _3639_/Q _2946_/Y _3140_/Y VPWR VGND sg13cmos5l_a21o_1
XFILLER_39_136 VPWR VGND sg13cmos5l_decap_4
XFILLER_39_169 VPWR VGND sg13cmos5l_decap_8
X_3073_ _3073_/X _3073_/A _3073_/B _3073_/C VPWR VGND sg13cmos5l_or3_1
XFILLER_36_843 VPWR VGND sg13cmos5l_fill_2
X_2024_ _2582_/A _2698_/A _2024_/B VPWR VGND sg13cmos5l_nor2_1
XFILLER_39_1015 VPWR VGND sg13cmos5l_decap_8
XFILLER_23_548 VPWR VGND sg13cmos5l_decap_8
XFILLER_23_559 VPWR VGND sg13cmos5l_fill_1
X_2926_ _2926_/Y _2927_/B _2929_/A _2926_/C VPWR VGND sg13cmos5l_nor3_1
XFILLER_31_570 VPWR VGND sg13cmos5l_decap_8
X_2857_ _2857_/Y _2857_/A VPWR VGND sg13cmos5l_inv_1
X_2788_ _2788_/Y _2682_/B _2780_/X _2787_/Y VPWR VGND sg13cmos5l_o21ai_1
XFILLER_2_419 VPWR VGND sg13cmos5l_fill_2
XFILLER_49_16 VPWR VGND sg13cmos5l_decap_8
X_3409_ _3410_/C _3409_/A _3408_/A VPWR VGND sg13cmos5l_nor2b_1
XFILLER_39_670 VPWR VGND sg13cmos5l_decap_4
XFILLER_27_854 VPWR VGND sg13cmos5l_decap_8
XFILLER_42_802 VPWR VGND sg13cmos5l_fill_1
XFILLER_27_865 VPWR VGND sg13cmos5l_fill_1
XFILLER_14_515 VPWR VGND sg13cmos5l_decap_4
XFILLER_14_548 VPWR VGND sg13cmos5l_fill_1
XFILLER_10_710 VPWR VGND sg13cmos5l_decap_8
XFILLER_14_41 VPWR VGND sg13cmos5l_fill_1
XFILLER_6_769 VPWR VGND sg13cmos5l_fill_1
XFILLER_5_257 VPWR VGND sg13cmos5l_decap_4
XFILLER_2_975 VPWR VGND sg13cmos5l_decap_8
XFILLER_49_412 VPWR VGND sg13cmos5l_decap_8
XFILLER_7_1002 VPWR VGND sg13cmos5l_decap_8
XFILLER_39_71 VPWR VGND sg13cmos5l_fill_2
XFILLER_49_478 VPWR VGND sg13cmos5l_decap_4
X_3507__376 _3507_/RESET_B VPWR VGND sg13cmos5l_tiehi
XFILLER_33_879 VPWR VGND sg13cmos5l_decap_8
X_3760_ _3760_/Q _3783_/CLK _3760_/D _3760_/RESET_B VPWR VGND sg13cmos5l_dfrbpq_1
X_2711_ _2712_/B _2711_/A _2711_/B VPWR VGND sg13cmos5l_nand2_1
XFILLER_9_574 VPWR VGND sg13cmos5l_decap_8
X_3691_ _3691_/Q _3722_/CLK _3691_/D _3691_/RESET_B VPWR VGND sg13cmos5l_dfrbpq_1
X_2642_ _2642_/Y input8/X _2649_/S VPWR VGND sg13cmos5l_nor2_1
X_3514__369 _3514_/RESET_B VPWR VGND sg13cmos5l_tiehi
X_2573_ _2573_/Y _2573_/A _2573_/B VPWR VGND sg13cmos5l_nand2_1
XFILLER_5_780 VPWR VGND sg13cmos5l_fill_1
XFILLER_19_19 VPWR VGND sg13cmos5l_fill_2
X_3125_ _3125_/Y _3188_/A _3619_/Q _2956_/B _3124_/X _3122_/Y VPWR VGND sg13cmos5l_a221oi_1
XFILLER_27_106 VPWR VGND sg13cmos5l_decap_8
X_3056_ _3056_/Y _3050_/A _2994_/B _3053_/Y _3054_/Y _3055_/Y VPWR VGND sg13cmos5l_a221oi_1
XFILLER_36_673 VPWR VGND sg13cmos5l_fill_2
X_2007_ _3175_/A _3655_/Q VPWR VGND sg13cmos5l_inv_1
XFILLER_24_868 VPWR VGND sg13cmos5l_decap_4
XFILLER_11_529 VPWR VGND sg13cmos5l_decap_8
X_2909_ _3605_/D _3459_/A _2909_/B VPWR VGND sg13cmos5l_and2_1
XFILLER_3_728 VPWR VGND sg13cmos5l_fill_2
XFILLER_47_905 VPWR VGND sg13cmos5l_decap_8
XFILLER_46_448 VPWR VGND sg13cmos5l_decap_8
XFILLER_33_109 VPWR VGND sg13cmos5l_fill_1
XFILLER_27_684 VPWR VGND sg13cmos5l_decap_8
XFILLER_27_695 VPWR VGND sg13cmos5l_fill_1
XFILLER_15_857 VPWR VGND sg13cmos5l_decap_8
XFILLER_26_194 VPWR VGND sg13cmos5l_decap_8
XFILLER_30_805 VPWR VGND sg13cmos5l_decap_8
XFILLER_14_378 VPWR VGND sg13cmos5l_decap_8
XFILLER_25_95 VPWR VGND sg13cmos5l_decap_8
XFILLER_30_816 VPWR VGND sg13cmos5l_decap_8
XFILLER_30_827 VPWR VGND sg13cmos5l_fill_1
XFILLER_6_500 VPWR VGND sg13cmos5l_decap_8
XFILLER_10_584 VPWR VGND sg13cmos5l_fill_1
XFILLER_2_772 VPWR VGND sg13cmos5l_decap_8
XFILLER_49_242 VPWR VGND sg13cmos5l_fill_2
XFILLER_49_231 VPWR VGND sg13cmos5l_decap_8
XFILLER_38_949 VPWR VGND sg13cmos5l_decap_8
XFILLER_2_99 VPWR VGND sg13cmos5l_decap_8
XFILLER_18_662 VPWR VGND sg13cmos5l_decap_4
XFILLER_46_993 VPWR VGND sg13cmos5l_decap_8
XFILLER_45_481 VPWR VGND sg13cmos5l_decap_8
XFILLER_17_172 VPWR VGND sg13cmos5l_decap_8
XFILLER_20_326 VPWR VGND sg13cmos5l_decap_8
X_3743_ _3743_/Q clkload3/A _3743_/D _3743_/RESET_B VPWR VGND sg13cmos5l_dfrbpq_1
X_3674_ _3674_/Q _3731_/CLK _3674_/D _3674_/RESET_B VPWR VGND sg13cmos5l_dfrbpq_1
X_2625_ _3500_/D input11/X hold600/X _2627_/S VPWR VGND sg13cmos5l_mux2_1
X_2556_ _2558_/B _2560_/B _2560_/C _2535_/Y VPWR VGND sg13cmos5l_a21oi_1
X_2487_ _2487_/Y _3741_/Q _3763_/Q VPWR VGND sg13cmos5l_nor2b_1
XFILLER_29_938 VPWR VGND sg13cmos5l_decap_8
X_3108_ _3642_/D _3108_/A _3108_/B VPWR VGND sg13cmos5l_and2_1
XFILLER_28_426 VPWR VGND sg13cmos5l_decap_8
XFILLER_28_437 VPWR VGND sg13cmos5l_fill_2
XFILLER_37_982 VPWR VGND sg13cmos5l_decap_8
X_3792__420 _3792_/RESET_B VPWR VGND sg13cmos5l_tiehi
X_3039_ _3042_/A _3039_/A _3052_/D VPWR VGND sg13cmos5l_and2_1
XFILLER_23_120 VPWR VGND sg13cmos5l_decap_8
XFILLER_12_838 VPWR VGND sg13cmos5l_decap_4
XFILLER_11_326 VPWR VGND sg13cmos5l_decap_8
X_3671__148 _3671_/RESET_B VPWR VGND sg13cmos5l_tiehi
XFILLER_3_525 VPWR VGND sg13cmos5l_decap_8
XFILLER_2_4 VPWR VGND sg13cmos5l_decap_4
XFILLER_19_404 VPWR VGND sg13cmos5l_decap_8
XFILLER_47_735 VPWR VGND sg13cmos5l_fill_1
XFILLER_46_212 VPWR VGND sg13cmos5l_fill_2
XFILLER_46_201 VPWR VGND sg13cmos5l_decap_8
X_3543__340 _3543_/RESET_B VPWR VGND sg13cmos5l_tiehi
XFILLER_47_779 VPWR VGND sg13cmos5l_decap_8
XFILLER_35_908 VPWR VGND sg13cmos5l_fill_1
XFILLER_35_919 VPWR VGND sg13cmos5l_fill_2
X_3504__379 _3504_/RESET_B VPWR VGND sg13cmos5l_tiehi
XFILLER_43_941 VPWR VGND sg13cmos5l_decap_8
XFILLER_42_495 VPWR VGND sg13cmos5l_fill_1
XFILLER_30_624 VPWR VGND sg13cmos5l_decap_8
XFILLER_11_860 VPWR VGND sg13cmos5l_decap_8
XFILLER_7_820 VPWR VGND sg13cmos5l_decap_8
XFILLER_6_341 VPWR VGND sg13cmos5l_decap_8
XFILLER_10_392 VPWR VGND sg13cmos5l_decap_4
Xhold809 _2482_/A _3784_/Q VPWR VGND sg13cmos5l_dlygate4sd3_1
XFILLER_7_897 VPWR VGND sg13cmos5l_decap_8
X_2410_ _3770_/D _2561_/A _2410_/B VPWR VGND sg13cmos5l_nor2_1
X_3390_ _3390_/X _3390_/A _3398_/A _3390_/C VPWR VGND sg13cmos5l_or3_1
X_2341_ _2342_/C _2341_/A _2341_/B _2341_/C VPWR VGND sg13cmos5l_and3_1
XFILLER_42_1000 VPWR VGND sg13cmos5l_decap_8
XFILLER_2_580 VPWR VGND sg13cmos5l_decap_8
X_2272_ _2272_/Y _2269_/S _2271_/Y _2304_/B VPWR VGND sg13cmos5l_o21ai_1
XFILLER_38_746 VPWR VGND sg13cmos5l_fill_1
XFILLER_38_735 VPWR VGND sg13cmos5l_decap_8
XFILLER_26_908 VPWR VGND sg13cmos5l_fill_2
XFILLER_26_919 VPWR VGND sg13cmos5l_decap_8
XFILLER_18_470 VPWR VGND sg13cmos5l_fill_2
XFILLER_25_418 VPWR VGND sg13cmos5l_decap_8
XFILLER_46_790 VPWR VGND sg13cmos5l_decap_8
XFILLER_18_481 VPWR VGND sg13cmos5l_fill_1
XFILLER_34_941 VPWR VGND sg13cmos5l_fill_2
X_3594__260 _3594_/RESET_B VPWR VGND sg13cmos5l_tiehi
X_3735__134 _3735_/D VPWR VGND sg13cmos5l_tielo
XFILLER_34_996 VPWR VGND sg13cmos5l_decap_8
XFILLER_33_495 VPWR VGND sg13cmos5l_fill_2
X_1987_ _3189_/A _1987_/A VPWR VGND sg13cmos5l_inv_1
X_3726_ _3726_/Q _3728_/CLK _3726_/D _3726_/RESET_B VPWR VGND sg13cmos5l_dfrbpq_1
X_3657_ _3657_/Q _3664_/CLK _3657_/D _3657_/RESET_B VPWR VGND sg13cmos5l_dfrbpq_1
X_3588_ _3588_/Q clkload9/A _3588_/D _3588_/RESET_B VPWR VGND sg13cmos5l_dfrbpq_1
X_2608_ _2616_/S _3560_/Q _3559_/Q _2672_/A _2708_/A VPWR VGND sg13cmos5l_nand4_1
XFILLER_0_506 VPWR VGND sg13cmos5l_decap_8
X_2539_ _2540_/B _3787_/Q _2545_/B VPWR VGND sg13cmos5l_xnor2_1
XFILLER_44_738 VPWR VGND sg13cmos5l_fill_2
XFILLER_28_278 VPWR VGND sg13cmos5l_decap_8
XFILLER_25_952 VPWR VGND sg13cmos5l_decap_8
XFILLER_40_944 VPWR VGND sg13cmos5l_decap_8
XFILLER_11_123 VPWR VGND sg13cmos5l_decap_8
XFILLER_24_473 VPWR VGND sg13cmos5l_decap_8
XFILLER_8_606 VPWR VGND sg13cmos5l_decap_8
XFILLER_7_105 VPWR VGND sg13cmos5l_fill_2
XFILLER_12_668 VPWR VGND sg13cmos5l_decap_4
XFILLER_22_63 VPWR VGND sg13cmos5l_decap_4
XFILLER_4_867 VPWR VGND sg13cmos5l_decap_8
XFILLER_26_1017 VPWR VGND sg13cmos5l_decap_8
XFILLER_26_1028 VPWR VGND sg13cmos5l_fill_1
XFILLER_19_201 VPWR VGND sg13cmos5l_decap_8
XFILLER_19_278 VPWR VGND sg13cmos5l_decap_8
XFILLER_35_727 VPWR VGND sg13cmos5l_decap_8
XFILLER_16_930 VPWR VGND sg13cmos5l_fill_1
XFILLER_16_952 VPWR VGND sg13cmos5l_decap_8
XFILLER_15_451 VPWR VGND sg13cmos5l_fill_2
X_2890_ _2890_/Y _3004_/B _2890_/B VPWR VGND sg13cmos5l_nor2_1
XFILLER_31_933 VPWR VGND sg13cmos5l_fill_1
XFILLER_31_977 VPWR VGND sg13cmos5l_decap_8
X_3511_ _3511_/Q clkload6/A _3511_/D _3511_/RESET_B VPWR VGND sg13cmos5l_dfrbpq_1
Xhold606 hold606/X _3539_/Q VPWR VGND sg13cmos5l_dlygate4sd3_1
Xhold617 hold617/X _3529_/Q VPWR VGND sg13cmos5l_dlygate4sd3_1
Xhold639 _2767_/B _3573_/Q VPWR VGND sg13cmos5l_dlygate4sd3_1
Xhold628 hold628/X _3489_/Q VPWR VGND sg13cmos5l_dlygate4sd3_1
X_3442_ _3444_/A _3716_/Q _3439_/Y _3441_/Y _3717_/Q _3440_/Y VPWR VGND sg13cmos5l_a221oi_1
X_3373_ _3397_/A _3696_/Q _3376_/B _3390_/A VPWR VGND sg13cmos5l_a21o_1
X_2324_ _2341_/B _3754_/Q _3725_/Q _3759_/Q VPWR VGND sg13cmos5l_nand3_1
X_2255_ _2255_/Y _3746_/Q _2250_/Y _2254_/Y _3747_/Q VPWR VGND sg13cmos5l_a22oi_1
X_2186_ _2186_/Y _2175_/X _2180_/Y _2184_/Y _2185_/X _2181_/X VPWR VGND sg13cmos5l_a221oi_1
XFILLER_38_587 VPWR VGND sg13cmos5l_decap_4
XFILLER_40_207 VPWR VGND sg13cmos5l_decap_8
X_3557__317 _3557_/RESET_B VPWR VGND sg13cmos5l_tiehi
XFILLER_34_782 VPWR VGND sg13cmos5l_fill_1
XFILLER_22_988 VPWR VGND sg13cmos5l_decap_8
X_3533__350 _3533_/RESET_B VPWR VGND sg13cmos5l_tiehi
XFILLER_49_1006 VPWR VGND sg13cmos5l_decap_8
XFILLER_4_108 VPWR VGND sg13cmos5l_fill_1
X_3713__284 _3713_/RESET_B VPWR VGND sg13cmos5l_tiehi
X_3709_ _3709_/Q _3712_/CLK _3709_/D _3709_/RESET_B VPWR VGND sg13cmos5l_dfrbpq_1
XFILLER_1_815 VPWR VGND sg13cmos5l_decap_8
XFILLER_0_358 VPWR VGND sg13cmos5l_decap_8
X_3540__343 _3540_/RESET_B VPWR VGND sg13cmos5l_tiehi
XFILLER_16_215 VPWR VGND sg13cmos5l_decap_8
XFILLER_17_727 VPWR VGND sg13cmos5l_fill_1
XFILLER_44_568 VPWR VGND sg13cmos5l_fill_2
XFILLER_13_911 VPWR VGND sg13cmos5l_fill_2
XFILLER_13_944 VPWR VGND sg13cmos5l_fill_1
XFILLER_12_443 VPWR VGND sg13cmos5l_decap_4
XFILLER_9_948 VPWR VGND sg13cmos5l_decap_8
XFILLER_13_988 VPWR VGND sg13cmos5l_decap_8
XFILLER_33_62 VPWR VGND sg13cmos5l_fill_1
XFILLER_8_469 VPWR VGND sg13cmos5l_fill_1
XFILLER_4_631 VPWR VGND sg13cmos5l_fill_1
XFILLER_3_163 VPWR VGND sg13cmos5l_fill_1
XFILLER_3_130 VPWR VGND sg13cmos5l_decap_8
X_3584__270 _3584_/RESET_B VPWR VGND sg13cmos5l_tiehi
XFILLER_0_881 VPWR VGND sg13cmos5l_decap_8
XFILLER_48_852 VPWR VGND sg13cmos5l_decap_8
X_2040_ _2040_/Y _2582_/A _2030_/Y _2039_/Y VPWR VGND sg13cmos5l_o21ai_1
XFILLER_35_535 VPWR VGND sg13cmos5l_decap_8
XFILLER_23_719 VPWR VGND sg13cmos5l_decap_4
X_2942_ _2944_/A _2943_/A _2956_/A VPWR VGND sg13cmos5l_nand2_1
XFILLER_16_793 VPWR VGND sg13cmos5l_fill_2
X_3591__263 _3591_/RESET_B VPWR VGND sg13cmos5l_tiehi
X_2873_ _3589_/D _2939_/A _2912_/C VPWR VGND sg13cmos5l_nor2_1
Xhold469 _3459_/B _3691_/Q VPWR VGND sg13cmos5l_dlygate4sd3_1
X_3425_ _3425_/Y _3735_/Q _3336_/A _3685_/Q _2307_/A VPWR VGND sg13cmos5l_a22oi_1
X_3356_ _3357_/B _3267_/B _3391_/A _3355_/Y VPWR VGND sg13cmos5l_o21ai_1
X_2307_ _3761_/D _2307_/A _2307_/B VPWR VGND sg13cmos5l_nor2_1
X_3287_ _3288_/B _3287_/A _3298_/B VPWR VGND sg13cmos5l_nor2_1
X_2238_ _3743_/D _2361_/A _2238_/B VPWR VGND sg13cmos5l_nor2_1
X_2169_ _2171_/B _3739_/Q _2185_/B VPWR VGND sg13cmos5l_nor2_1
XFILLER_26_546 VPWR VGND sg13cmos5l_decap_8
XFILLER_13_218 VPWR VGND sg13cmos5l_decap_4
XFILLER_21_273 VPWR VGND sg13cmos5l_fill_1
XFILLER_6_918 VPWR VGND sg13cmos5l_decap_8
XFILLER_0_166 VPWR VGND sg13cmos5l_decap_4
XFILLER_0_199 VPWR VGND sg13cmos5l_decap_8
XFILLER_45_833 VPWR VGND sg13cmos5l_decap_8
XFILLER_17_579 VPWR VGND sg13cmos5l_decap_4
XFILLER_44_387 VPWR VGND sg13cmos5l_decap_8
XFILLER_9_701 VPWR VGND sg13cmos5l_decap_8
XFILLER_9_712 VPWR VGND sg13cmos5l_fill_2
XFILLER_12_262 VPWR VGND sg13cmos5l_decap_8
XFILLER_12_273 VPWR VGND sg13cmos5l_decap_8
XFILLER_5_44 VPWR VGND sg13cmos5l_fill_1
X_3210_ _3222_/B _3222_/A _3209_/X _3208_/Y VPWR VGND sg13cmos5l_o21ai_1
X_3141_ _3141_/Y _1987_/A _2946_/Y hold737/X VPWR VGND sg13cmos5l_a21oi_1
XFILLER_39_115 VPWR VGND sg13cmos5l_fill_2
X_3072_ _3638_/D _3072_/A _3072_/B _3072_/C VPWR VGND sg13cmos5l_nor3_1
X_2023_ _2024_/B _3545_/Q _3528_/Q _3511_/Q _3494_/Q _2810_/A1 _2810_/B1 VPWR VGND
+ sg13cmos5l_mux4_1
X_3523__360 _3523_/RESET_B VPWR VGND sg13cmos5l_tiehi
XFILLER_35_376 VPWR VGND sg13cmos5l_decap_8
X_2925_ _2925_/Y _2925_/A _2925_/B VPWR VGND sg13cmos5l_nor2_1
X_2856_ _2857_/A _2856_/A _2855_/Y VPWR VGND sg13cmos5l_nor2b_1
X_2787_ _2787_/Y _2782_/Y _2786_/Y _3569_/Q VPWR VGND sg13cmos5l_a21oi_1
X_3530__353 _3530_/RESET_B VPWR VGND sg13cmos5l_tiehi
X_3408_ _3410_/B _3408_/A _3390_/X VPWR VGND sg13cmos5l_nor2b_1
X_3339_ _3339_/Y _1929_/A _3454_/A2 _3460_/A VPWR VGND sg13cmos5l_o21ai_1
XFILLER_45_118 VPWR VGND sg13cmos5l_decap_8
XFILLER_45_129 VPWR VGND sg13cmos5l_decap_8
XFILLER_38_181 VPWR VGND sg13cmos5l_decap_8
XFILLER_42_814 VPWR VGND sg13cmos5l_decap_8
XFILLER_38_192 VPWR VGND sg13cmos5l_decap_8
XFILLER_42_825 VPWR VGND sg13cmos5l_fill_2
XFILLER_41_368 VPWR VGND sg13cmos5l_decap_4
XFILLER_10_766 VPWR VGND sg13cmos5l_decap_8
XFILLER_6_759 VPWR VGND sg13cmos5l_fill_2
XFILLER_10_799 VPWR VGND sg13cmos5l_decap_4
XFILLER_2_954 VPWR VGND sg13cmos5l_decap_8
XFILLER_1_475 VPWR VGND sg13cmos5l_decap_8
XFILLER_1_486 VPWR VGND sg13cmos5l_fill_2
XFILLER_49_457 VPWR VGND sg13cmos5l_decap_8
XFILLER_36_107 VPWR VGND sg13cmos5l_decap_8
XFILLER_17_310 VPWR VGND sg13cmos5l_decap_8
XFILLER_18_833 VPWR VGND sg13cmos5l_fill_1
XFILLER_17_343 VPWR VGND sg13cmos5l_fill_1
XFILLER_33_803 VPWR VGND sg13cmos5l_decap_4
XFILLER_18_899 VPWR VGND sg13cmos5l_decap_8
XFILLER_44_195 VPWR VGND sg13cmos5l_fill_2
XFILLER_13_560 VPWR VGND sg13cmos5l_decap_8
XFILLER_32_368 VPWR VGND sg13cmos5l_decap_4
XFILLER_9_531 VPWR VGND sg13cmos5l_fill_2
XFILLER_9_542 VPWR VGND sg13cmos5l_fill_2
X_2710_ _3554_/D _2711_/B _2708_/X _2709_/Y VPWR VGND sg13cmos5l_a21oi_1
X_3690_ _3690_/Q _3722_/CLK _3690_/D _3690_/RESET_B VPWR VGND sg13cmos5l_dfrbpq_1
X_2641_ _3513_/D input7/X hold603/X _2649_/S VPWR VGND sg13cmos5l_mux2_1
X_2572_ _2573_/B _2027_/B _3795_/Q _3803_/Q VPWR VGND sg13cmos5l_o21ai_1
X_3124_ _3124_/X _3126_/B _3140_/B VPWR VGND sg13cmos5l_and2_1
X_3055_ _3055_/Y _3055_/A _2966_/B VPWR VGND sg13cmos5l_nor2b_1
X_2006_ _2006_/Y _3682_/Q VPWR VGND sg13cmos5l_inv_1
XFILLER_36_652 VPWR VGND sg13cmos5l_decap_8
XFILLER_24_847 VPWR VGND sg13cmos5l_decap_8
X_3593__122 _3593_/D VPWR VGND sg13cmos5l_tielo
XFILLER_35_184 VPWR VGND sg13cmos5l_decap_4
XFILLER_11_508 VPWR VGND sg13cmos5l_decap_8
X_2908_ _3604_/D _3025_/A _2908_/B VPWR VGND sg13cmos5l_and2_1
XFILLER_32_880 VPWR VGND sg13cmos5l_fill_1
XFILLER_31_390 VPWR VGND sg13cmos5l_fill_2
X_2839_ _3581_/D _2839_/A VPWR VGND sg13cmos5l_inv_1
XFILLER_3_718 VPWR VGND sg13cmos5l_fill_1
XFILLER_4_8 VPWR VGND sg13cmos5l_decap_4
XFILLER_46_438 VPWR VGND sg13cmos5l_fill_1
XFILLER_46_427 VPWR VGND sg13cmos5l_fill_2
XFILLER_15_825 VPWR VGND sg13cmos5l_decap_8
XFILLER_26_162 VPWR VGND sg13cmos5l_decap_8
XFILLER_26_173 VPWR VGND sg13cmos5l_fill_1
XFILLER_14_368 VPWR VGND sg13cmos5l_decap_4
XFILLER_10_541 VPWR VGND sg13cmos5l_decap_8
XFILLER_10_552 VPWR VGND sg13cmos5l_fill_1
XFILLER_10_563 VPWR VGND sg13cmos5l_decap_8
XFILLER_41_95 VPWR VGND sg13cmos5l_decap_8
X_3513__370 _3513_/RESET_B VPWR VGND sg13cmos5l_tiehi
XFILLER_29_1015 VPWR VGND sg13cmos5l_decap_8
XFILLER_49_210 VPWR VGND sg13cmos5l_decap_8
XFILLER_38_928 VPWR VGND sg13cmos5l_decap_8
XFILLER_49_276 VPWR VGND sg13cmos5l_decap_8
XFILLER_37_438 VPWR VGND sg13cmos5l_decap_8
XFILLER_46_972 VPWR VGND sg13cmos5l_decap_8
XFILLER_17_151 VPWR VGND sg13cmos5l_decap_8
XFILLER_36_1008 VPWR VGND sg13cmos5l_decap_8
X_3520__363 _3520_/RESET_B VPWR VGND sg13cmos5l_tiehi
X_3742_ _3742_/Q clkload4/A _3742_/D _3742_/RESET_B VPWR VGND sg13cmos5l_dfrbpq_1
XFILLER_9_350 VPWR VGND sg13cmos5l_fill_2
X_3673_ _3673_/Q _3731_/CLK _3673_/D _3673_/RESET_B VPWR VGND sg13cmos5l_dfrbpq_1
X_2624_ _3499_/D input10/X hold552/X _2627_/S VPWR VGND sg13cmos5l_mux2_1
X_2555_ _3790_/D _2558_/A _2555_/B _2555_/C VPWR VGND sg13cmos5l_nor3_1
X_2486_ _2486_/Y _2465_/A _3742_/Q VPWR VGND sg13cmos5l_nand2b_1
X_3107_ _3108_/B _3084_/Y _3293_/B _3107_/S VPWR VGND sg13cmos5l_mux2_1
XFILLER_37_961 VPWR VGND sg13cmos5l_decap_8
X_3038_ _3052_/D _3629_/Q _3606_/Q _3634_/Q VPWR VGND sg13cmos5l_nand3_1
XFILLER_24_666 VPWR VGND sg13cmos5l_fill_1
XFILLER_23_176 VPWR VGND sg13cmos5l_decap_8
XFILLER_23_187 VPWR VGND sg13cmos5l_fill_1
XFILLER_11_32 VPWR VGND sg13cmos5l_decap_4
XFILLER_47_714 VPWR VGND sg13cmos5l_decap_8
XFILLER_4_1028 VPWR VGND sg13cmos5l_fill_1
XFILLER_47_758 VPWR VGND sg13cmos5l_decap_8
XFILLER_43_920 VPWR VGND sg13cmos5l_decap_8
XFILLER_28_983 VPWR VGND sg13cmos5l_decap_8
XFILLER_36_40 VPWR VGND sg13cmos5l_decap_4
XFILLER_27_482 VPWR VGND sg13cmos5l_decap_4
XFILLER_43_997 VPWR VGND sg13cmos5l_decap_8
XFILLER_14_154 VPWR VGND sg13cmos5l_decap_8
XFILLER_15_655 VPWR VGND sg13cmos5l_decap_8
XFILLER_15_666 VPWR VGND sg13cmos5l_fill_2
XFILLER_42_474 VPWR VGND sg13cmos5l_decap_4
XFILLER_30_669 VPWR VGND sg13cmos5l_fill_1
XFILLER_6_320 VPWR VGND sg13cmos5l_decap_8
XFILLER_7_876 VPWR VGND sg13cmos5l_decap_8
X_2340_ _2345_/B _2340_/A _2340_/B VPWR VGND sg13cmos5l_nor2_1
X_2271_ _2271_/Y _2271_/A _2421_/A VPWR VGND sg13cmos5l_nor2_1
XFILLER_28_4 VPWR VGND sg13cmos5l_decap_4
XFILLER_38_769 VPWR VGND sg13cmos5l_fill_1
XFILLER_37_246 VPWR VGND sg13cmos5l_fill_2
XFILLER_25_408 VPWR VGND sg13cmos5l_decap_4
XFILLER_33_452 VPWR VGND sg13cmos5l_decap_4
XFILLER_34_975 VPWR VGND sg13cmos5l_decap_8
X_1986_ _3466_/A _1986_/A VPWR VGND sg13cmos5l_inv_1
X_3725_ _3725_/Q _3783_/CLK _3725_/D _3725_/RESET_B VPWR VGND sg13cmos5l_dfrbpq_1
Xclkbuf_leaf_9_clk _3629_/CLK clkbuf_leaf_9_clk/A VPWR VGND sg13cmos5l_buf_8
X_3656_ _3656_/Q _3664_/CLK _3656_/D _3656_/RESET_B VPWR VGND sg13cmos5l_dfrbpq_1
X_3587_ _3587_/Q clkload9/A _3587_/D _3587_/RESET_B VPWR VGND sg13cmos5l_dfrbpq_1
X_2607_ _2607_/X input3/X input2/X _2607_/C VPWR VGND sg13cmos5l_and3_1
X_2538_ _2544_/A _2549_/A _2512_/Y _2415_/B VPWR VGND sg13cmos5l_o21ai_1
X_2469_ _2469_/Y _3783_/Q _3757_/Q VPWR VGND sg13cmos5l_nand2_1
XFILLER_28_246 VPWR VGND sg13cmos5l_decap_4
XFILLER_29_758 VPWR VGND sg13cmos5l_decap_8
XFILLER_44_728 VPWR VGND sg13cmos5l_fill_2
XFILLER_37_780 VPWR VGND sg13cmos5l_fill_1
XFILLER_16_408 VPWR VGND sg13cmos5l_fill_2
XFILLER_43_227 VPWR VGND sg13cmos5l_decap_8
XFILLER_37_791 VPWR VGND sg13cmos5l_decap_8
XFILLER_25_931 VPWR VGND sg13cmos5l_decap_8
X_3503__380 _3503_/RESET_B VPWR VGND sg13cmos5l_tiehi
XFILLER_40_923 VPWR VGND sg13cmos5l_decap_8
XFILLER_12_625 VPWR VGND sg13cmos5l_decap_8
XFILLER_24_496 VPWR VGND sg13cmos5l_fill_1
XFILLER_11_179 VPWR VGND sg13cmos5l_decap_4
XFILLER_3_312 VPWR VGND sg13cmos5l_decap_8
XFILLER_4_846 VPWR VGND sg13cmos5l_decap_8
X_3510__373 _3510_/RESET_B VPWR VGND sg13cmos5l_tiehi
XFILLER_3_378 VPWR VGND sg13cmos5l_decap_8
XFILLER_47_500 VPWR VGND sg13cmos5l_decap_8
XFILLER_34_238 VPWR VGND sg13cmos5l_decap_8
XFILLER_15_441 VPWR VGND sg13cmos5l_fill_2
XFILLER_15_463 VPWR VGND sg13cmos5l_decap_8
XFILLER_31_912 VPWR VGND sg13cmos5l_decap_8
XFILLER_30_433 VPWR VGND sg13cmos5l_decap_8
XFILLER_31_956 VPWR VGND sg13cmos5l_decap_8
XFILLER_30_466 VPWR VGND sg13cmos5l_fill_2
X_3510_ _3510_/Q clkload8/A _3510_/D _3510_/RESET_B VPWR VGND sg13cmos5l_dfrbpq_1
XFILLER_7_684 VPWR VGND sg13cmos5l_decap_8
Xhold618 _1949_/A _3776_/Q VPWR VGND sg13cmos5l_dlygate4sd3_1
Xhold607 hold607/X _3780_/Q VPWR VGND sg13cmos5l_dlygate4sd3_1
Xhold629 hold629/X _3543_/Q VPWR VGND sg13cmos5l_dlygate4sd3_1
X_3441_ _3441_/Y _1970_/A _3437_/B _3336_/A _3685_/Q VPWR VGND sg13cmos5l_a22oi_1
X_3372_ _3390_/A _3389_/A _3389_/B _3389_/C VPWR VGND sg13cmos5l_a21oi_1
X_2323_ _2341_/A _2337_/A _2337_/B VPWR VGND sg13cmos5l_nand2_1
XFILLER_38_500 VPWR VGND sg13cmos5l_fill_1
X_2254_ _2254_/Y _2254_/A VPWR VGND sg13cmos5l_inv_1
XFILLER_38_533 VPWR VGND sg13cmos5l_decap_8
X_2185_ _2185_/X _3739_/Q _2185_/B VPWR VGND sg13cmos5l_xor2_1
XFILLER_26_706 VPWR VGND sg13cmos5l_decap_8
XFILLER_19_791 VPWR VGND sg13cmos5l_decap_4
XFILLER_22_912 VPWR VGND sg13cmos5l_decap_8
XFILLER_34_761 VPWR VGND sg13cmos5l_decap_8
XFILLER_33_260 VPWR VGND sg13cmos5l_decap_8
XFILLER_22_967 VPWR VGND sg13cmos5l_decap_8
X_1969_ _2306_/A _1969_/A VPWR VGND sg13cmos5l_inv_1
X_3708_ _3708_/Q _3712_/CLK _3708_/D _3708_/RESET_B VPWR VGND sg13cmos5l_dfrbpq_1
X_3639_ _3639_/Q _3664_/CLK _3639_/D _3639_/RESET_B VPWR VGND sg13cmos5l_dfrbpq_1
XFILLER_29_522 VPWR VGND sg13cmos5l_decap_8
XFILLER_17_31 VPWR VGND sg13cmos5l_decap_8
XFILLER_44_547 VPWR VGND sg13cmos5l_decap_8
XFILLER_13_901 VPWR VGND sg13cmos5l_fill_1
XFILLER_24_260 VPWR VGND sg13cmos5l_decap_8
XFILLER_40_764 VPWR VGND sg13cmos5l_decap_8
XFILLER_9_927 VPWR VGND sg13cmos5l_decap_8
XFILLER_13_967 VPWR VGND sg13cmos5l_decap_8
XFILLER_24_293 VPWR VGND sg13cmos5l_decap_8
XFILLER_12_466 VPWR VGND sg13cmos5l_fill_1
XFILLER_4_643 VPWR VGND sg13cmos5l_decap_8
XFILLER_3_175 VPWR VGND sg13cmos5l_fill_1
XFILLER_0_860 VPWR VGND sg13cmos5l_decap_8
XFILLER_48_831 VPWR VGND sg13cmos5l_decap_8
XFILLER_35_503 VPWR VGND sg13cmos5l_decap_4
X_2941_ _2956_/A _3614_/Q _3615_/Q _3616_/Q VPWR VGND sg13cmos5l_or3_1
X_2872_ _2912_/C _2858_/Y _2871_/A _2871_/Y VPWR VGND sg13cmos5l_o21ai_1
XFILLER_8_982 VPWR VGND sg13cmos5l_decap_8
X_3424_ _3424_/Y _2306_/A _3684_/Q _3423_/Y VPWR VGND sg13cmos5l_o21ai_1
X_3355_ _3355_/Y _3355_/A _3355_/B _3355_/C _3355_/D VPWR VGND sg13cmos5l_nand4_1
X_2306_ _3760_/D _2306_/A _2307_/B VPWR VGND sg13cmos5l_nor2_1
X_3286_ _3288_/A _3278_/X _3282_/Y _3298_/B _3287_/A _3283_/Y VPWR VGND sg13cmos5l_a221oi_1
X_2237_ _2238_/B _2142_/Y _2236_/X _2237_/S VPWR VGND sg13cmos5l_mux2_1
XFILLER_38_352 VPWR VGND sg13cmos5l_fill_2
XFILLER_38_341 VPWR VGND sg13cmos5l_decap_8
X_2168_ _2185_/B _3738_/Q _3737_/Q _3736_/Q VPWR VGND sg13cmos5l_or3_1
X_2099_ _2138_/A _2130_/B _3249_/A VPWR VGND sg13cmos5l_nand2_1
XFILLER_22_720 VPWR VGND sg13cmos5l_decap_8
X_3500__383 _3500_/RESET_B VPWR VGND sg13cmos5l_tiehi
XFILLER_21_230 VPWR VGND sg13cmos5l_decap_4
XFILLER_10_937 VPWR VGND sg13cmos5l_decap_4
XFILLER_10_959 VPWR VGND sg13cmos5l_decap_8
XFILLER_0_145 VPWR VGND sg13cmos5l_decap_8
XFILLER_0_134 VPWR VGND sg13cmos5l_fill_2
XFILLER_0_178 VPWR VGND sg13cmos5l_decap_8
XFILLER_45_812 VPWR VGND sg13cmos5l_decap_8
Xheichips26_dna_sequencer uio_oe[0] VPWR VGND sg13cmos5l_tielo
XFILLER_28_63 VPWR VGND sg13cmos5l_decap_8
XFILLER_29_374 VPWR VGND sg13cmos5l_decap_8
XFILLER_45_889 VPWR VGND sg13cmos5l_decap_8
XFILLER_17_569 VPWR VGND sg13cmos5l_decap_4
XFILLER_44_377 VPWR VGND sg13cmos5l_decap_4
XFILLER_12_230 VPWR VGND sg13cmos5l_decap_4
XFILLER_8_267 VPWR VGND sg13cmos5l_decap_4
XFILLER_9_779 VPWR VGND sg13cmos5l_fill_1
XFILLER_5_985 VPWR VGND sg13cmos5l_decap_8
X_3140_ _3140_/Y _3140_/A _3140_/B VPWR VGND sg13cmos5l_nor2_1
X_3623__227 _3623_/RESET_B VPWR VGND sg13cmos5l_tiehi
X_3071_ _3071_/Y _3071_/A _3065_/A VPWR VGND sg13cmos5l_nor2b_1
XFILLER_36_812 VPWR VGND sg13cmos5l_decap_4
XFILLER_10_4 VPWR VGND sg13cmos5l_decap_4
X_2022_ _2022_/Y _2596_/A _2717_/C VPWR VGND sg13cmos5l_nand2b_1
XFILLER_23_517 VPWR VGND sg13cmos5l_decap_4
XFILLER_16_591 VPWR VGND sg13cmos5l_fill_2
X_2924_ _2929_/A _3609_/Q _2925_/B _2923_/Y VPWR VGND sg13cmos5l_a21o_1
XFILLER_31_561 VPWR VGND sg13cmos5l_decap_4
X_2855_ _2855_/Y _3588_/Q _3589_/Q _3590_/Q VPWR VGND sg13cmos5l_o21ai_1
X_2786_ _2786_/Y _2786_/A VPWR VGND sg13cmos5l_inv_1
X_3667__165 _3667_/RESET_B VPWR VGND sg13cmos5l_tiehi
X_3407_ _3700_/D _3384_/X _3408_/A _3406_/Y VPWR VGND sg13cmos5l_a21oi_1
X_3338_ _3687_/D _3459_/A _3338_/B VPWR VGND sg13cmos5l_and2_1
X_3269_ _3395_/A _3270_/B VPWR VGND sg13cmos5l_inv_1
XFILLER_14_528 VPWR VGND sg13cmos5l_fill_1
XFILLER_26_399 VPWR VGND sg13cmos5l_decap_8
XFILLER_22_561 VPWR VGND sg13cmos5l_fill_1
XFILLER_10_745 VPWR VGND sg13cmos5l_decap_8
XFILLER_6_716 VPWR VGND sg13cmos5l_decap_8
XFILLER_10_789 VPWR VGND sg13cmos5l_fill_1
XFILLER_2_933 VPWR VGND sg13cmos5l_decap_8
X_3681__107 _3681_/D VPWR VGND sg13cmos5l_tielo
Xhold790 _1968_/A _3732_/Q VPWR VGND sg13cmos5l_dlygate4sd3_1
XFILLER_49_447 VPWR VGND sg13cmos5l_decap_4
X_3581__274 _3581_/RESET_B VPWR VGND sg13cmos5l_tiehi
XFILLER_17_322 VPWR VGND sg13cmos5l_decap_8
XFILLER_33_826 VPWR VGND sg13cmos5l_decap_8
XFILLER_33_837 VPWR VGND sg13cmos5l_decap_8
XFILLER_33_859 VPWR VGND sg13cmos5l_fill_1
XFILLER_9_510 VPWR VGND sg13cmos5l_decap_4
XFILLER_13_583 VPWR VGND sg13cmos5l_decap_8
XFILLER_9_554 VPWR VGND sg13cmos5l_fill_2
X_2640_ _3512_/D input6/X hold574/X _2649_/S VPWR VGND sg13cmos5l_mux2_1
X_2571_ _2571_/Y _1954_/Y _3795_/Q _3803_/Q VPWR VGND sg13cmos5l_o21ai_1
XFILLER_4_292 VPWR VGND sg13cmos5l_decap_8
X_3123_ _3140_/B _3618_/Q _3619_/Q _3620_/Q VPWR VGND sg13cmos5l_o21ai_1
XFILLER_49_992 VPWR VGND sg13cmos5l_decap_8
XFILLER_48_480 VPWR VGND sg13cmos5l_fill_2
X_3054_ _3054_/Y _2986_/B _3054_/B VPWR VGND sg13cmos5l_nand2b_1
X_2005_ _2005_/Y _3683_/Q VPWR VGND sg13cmos5l_inv_1
XFILLER_23_303 VPWR VGND sg13cmos5l_decap_8
XFILLER_24_826 VPWR VGND sg13cmos5l_decap_8
XFILLER_23_325 VPWR VGND sg13cmos5l_decap_8
X_2907_ _2907_/Y _1941_/Y _2907_/A2 _2906_/Y VPWR VGND sg13cmos5l_a21oi_1
XFILLER_13_1009 VPWR VGND sg13cmos5l_decap_8
X_2838_ _2839_/A _2846_/A _2907_/A2 _2838_/B1 VPWR VGND sg13cmos5l_o21ai_1
X_2769_ _2769_/Y _2769_/A _2771_/B VPWR VGND sg13cmos5l_nor2_1
X_3682__438 _3682_/RESET_B VPWR VGND sg13cmos5l_tiehi
XFILLER_46_406 VPWR VGND sg13cmos5l_decap_8
XFILLER_18_119 VPWR VGND sg13cmos5l_decap_8
XFILLER_27_642 VPWR VGND sg13cmos5l_fill_1
XFILLER_42_612 VPWR VGND sg13cmos5l_fill_2
XFILLER_15_804 VPWR VGND sg13cmos5l_decap_8
XFILLER_14_336 VPWR VGND sg13cmos5l_decap_8
XFILLER_42_689 VPWR VGND sg13cmos5l_fill_2
XFILLER_42_678 VPWR VGND sg13cmos5l_decap_8
XFILLER_41_188 VPWR VGND sg13cmos5l_decap_4
XFILLER_23_881 VPWR VGND sg13cmos5l_decap_8
XFILLER_6_579 VPWR VGND sg13cmos5l_decap_4
XFILLER_49_255 VPWR VGND sg13cmos5l_decap_8
XFILLER_49_288 VPWR VGND sg13cmos5l_decap_8
XFILLER_37_428 VPWR VGND sg13cmos5l_fill_1
XFILLER_37_417 VPWR VGND sg13cmos5l_decap_8
XFILLER_18_620 VPWR VGND sg13cmos5l_fill_1
XFILLER_46_951 VPWR VGND sg13cmos5l_decap_8
XFILLER_45_472 VPWR VGND sg13cmos5l_fill_2
XFILLER_32_144 VPWR VGND sg13cmos5l_fill_2
XFILLER_33_689 VPWR VGND sg13cmos5l_fill_1
X_3741_ _3741_/Q clkload4/A _3741_/D _3741_/RESET_B VPWR VGND sg13cmos5l_dfrbpq_1
XFILLER_32_177 VPWR VGND sg13cmos5l_decap_4
XFILLER_13_380 VPWR VGND sg13cmos5l_fill_1
XFILLER_9_362 VPWR VGND sg13cmos5l_decap_8
XFILLER_9_373 VPWR VGND sg13cmos5l_fill_1
X_3672_ _3672_/Q _3731_/CLK _3672_/D _3672_/RESET_B VPWR VGND sg13cmos5l_dfrbpq_1
X_2623_ _3498_/D input9/X hold587/X _2627_/S VPWR VGND sg13cmos5l_mux2_1
X_2554_ _2555_/C _2502_/Y _2536_/S _2560_/B _2560_/C _2529_/B VPWR VGND sg13cmos5l_a221oi_1
X_2485_ _2485_/Y _3742_/Q _2465_/A VPWR VGND sg13cmos5l_nor2b_1
X_3664__168 _3664_/RESET_B VPWR VGND sg13cmos5l_tiehi
XFILLER_28_406 VPWR VGND sg13cmos5l_decap_8
X_3106_ _3293_/B _3349_/A _3287_/A VPWR VGND sg13cmos5l_and2_1
XFILLER_37_940 VPWR VGND sg13cmos5l_decap_8
X_3037_ _3039_/A _3633_/Q _3052_/C VPWR VGND sg13cmos5l_nand2_1
XFILLER_23_100 VPWR VGND sg13cmos5l_decap_8
XFILLER_23_155 VPWR VGND sg13cmos5l_decap_8
XFILLER_24_678 VPWR VGND sg13cmos5l_decap_8
XFILLER_23_199 VPWR VGND sg13cmos5l_decap_8
XFILLER_20_851 VPWR VGND sg13cmos5l_fill_2
X_3751__141 _3751_/RESET_B VPWR VGND sg13cmos5l_tiehi
XFILLER_3_505 VPWR VGND sg13cmos5l_fill_2
XFILLER_4_1007 VPWR VGND sg13cmos5l_decap_8
XFILLER_19_439 VPWR VGND sg13cmos5l_decap_8
XFILLER_28_962 VPWR VGND sg13cmos5l_decap_8
XFILLER_14_100 VPWR VGND sg13cmos5l_decap_8
XFILLER_15_634 VPWR VGND sg13cmos5l_decap_8
XFILLER_36_96 VPWR VGND sg13cmos5l_fill_2
XFILLER_43_976 VPWR VGND sg13cmos5l_decap_8
XFILLER_42_442 VPWR VGND sg13cmos5l_decap_4
XFILLER_7_855 VPWR VGND sg13cmos5l_decap_8
XFILLER_6_376 VPWR VGND sg13cmos5l_fill_1
X_2270_ _3747_/D _2270_/A _2270_/B VPWR VGND sg13cmos5l_nor2_1
XFILLER_37_214 VPWR VGND sg13cmos5l_fill_2
XFILLER_37_225 VPWR VGND sg13cmos5l_decap_8
XFILLER_19_984 VPWR VGND sg13cmos5l_decap_8
XFILLER_34_954 VPWR VGND sg13cmos5l_decap_8
XFILLER_21_615 VPWR VGND sg13cmos5l_decap_8
XFILLER_33_497 VPWR VGND sg13cmos5l_fill_1
X_1985_ _3465_/A _1985_/A VPWR VGND sg13cmos5l_inv_1
X_3724_ _3724_/Q _3728_/CLK _3724_/D _3724_/RESET_B VPWR VGND sg13cmos5l_dfrbpq_1
X_3670__150 _3670_/RESET_B VPWR VGND sg13cmos5l_tiehi
XFILLER_9_192 VPWR VGND sg13cmos5l_fill_2
X_3655_ _3655_/Q _3728_/CLK _3655_/D _3655_/RESET_B VPWR VGND sg13cmos5l_dfrbpq_1
X_2606_ _3485_/D hold614/X input13/X _2606_/S VPWR VGND sg13cmos5l_mux2_1
X_3586_ _3586_/Q clkload9/A _3586_/D _3586_/RESET_B VPWR VGND sg13cmos5l_dfrbpq_1
X_2537_ _2537_/Y _2522_/Y _2528_/Y _2533_/Y _2536_/X _2529_/Y VPWR VGND sg13cmos5l_a221oi_1
X_2468_ _3788_/D _2468_/A _2468_/B VPWR VGND sg13cmos5l_nor2_1
XFILLER_29_704 VPWR VGND sg13cmos5l_decap_8
X_2399_ _2399_/X _3768_/Q _2398_/Y _2399_/S VPWR VGND sg13cmos5l_mux2_1
XFILLER_29_715 VPWR VGND sg13cmos5l_fill_2
XFILLER_28_225 VPWR VGND sg13cmos5l_decap_8
XFILLER_25_910 VPWR VGND sg13cmos5l_decap_8
XFILLER_40_902 VPWR VGND sg13cmos5l_decap_8
XFILLER_19_1026 VPWR VGND sg13cmos5l_fill_2
XFILLER_25_987 VPWR VGND sg13cmos5l_decap_8
XFILLER_40_979 VPWR VGND sg13cmos5l_decap_8
XFILLER_11_158 VPWR VGND sg13cmos5l_decap_8
XFILLER_20_670 VPWR VGND sg13cmos5l_decap_8
XFILLER_20_681 VPWR VGND sg13cmos5l_fill_2
XFILLER_20_692 VPWR VGND sg13cmos5l_decap_8
XFILLER_4_825 VPWR VGND sg13cmos5l_decap_8
XFILLER_22_87 VPWR VGND sg13cmos5l_decap_8
XFILLER_22_98 VPWR VGND sg13cmos5l_fill_1
X_3801__204 _3801_/RESET_B VPWR VGND sg13cmos5l_tiehi
XFILLER_47_534 VPWR VGND sg13cmos5l_decap_4
XFILLER_47_578 VPWR VGND sg13cmos5l_decap_4
XFILLER_47_84 VPWR VGND sg13cmos5l_decap_8
XFILLER_28_781 VPWR VGND sg13cmos5l_fill_1
XFILLER_34_217 VPWR VGND sg13cmos5l_decap_8
XFILLER_16_987 VPWR VGND sg13cmos5l_decap_8
X_3578__279 _3578_/RESET_B VPWR VGND sg13cmos5l_tiehi
X_3619__232 _3619_/RESET_B VPWR VGND sg13cmos5l_tiehi
XFILLER_42_272 VPWR VGND sg13cmos5l_decap_8
XFILLER_30_401 VPWR VGND sg13cmos5l_fill_2
XFILLER_8_78 VPWR VGND sg13cmos5l_decap_4
XFILLER_7_652 VPWR VGND sg13cmos5l_decap_4
XFILLER_7_663 VPWR VGND sg13cmos5l_decap_8
Xhold608 hold608/X _3530_/Q VPWR VGND sg13cmos5l_dlygate4sd3_1
Xhold619 _3563_/D _2731_/Y VPWR VGND sg13cmos5l_dlygate4sd3_1
XFILLER_6_195 VPWR VGND sg13cmos5l_decap_8
X_3440_ _3440_/Y _2251_/B _3434_/A _3439_/A _2256_/B _3435_/Y VPWR VGND sg13cmos5l_a221oi_1
XFILLER_40_4 VPWR VGND sg13cmos5l_fill_2
X_3782__432 _3782_/RESET_B VPWR VGND sg13cmos5l_tiehi
X_3371_ _3389_/C _3696_/Q _3376_/B VPWR VGND sg13cmos5l_xnor2_1
X_2322_ _2332_/A _2322_/A _2337_/B VPWR VGND sg13cmos5l_nor2_1
XFILLER_38_512 VPWR VGND sg13cmos5l_decap_8
X_2253_ _2254_/A _2251_/Y _2253_/B VPWR VGND sg13cmos5l_nand2b_1
X_2184_ _2184_/Y _2189_/B _2202_/B VPWR VGND sg13cmos5l_nand2b_1
XFILLER_26_729 VPWR VGND sg13cmos5l_fill_2
XFILLER_25_217 VPWR VGND sg13cmos5l_decap_8
XFILLER_25_228 VPWR VGND sg13cmos5l_fill_1
XFILLER_34_740 VPWR VGND sg13cmos5l_decap_4
XFILLER_34_795 VPWR VGND sg13cmos5l_decap_8
XFILLER_21_423 VPWR VGND sg13cmos5l_decap_4
X_1968_ _2305_/A _1968_/A VPWR VGND sg13cmos5l_inv_1
X_3707_ _3707_/Q _3712_/CLK _3707_/D _3707_/RESET_B VPWR VGND sg13cmos5l_dfrbpq_1
X_3638_ _3638_/Q _3665_/CLK _3638_/D _3638_/RESET_B VPWR VGND sg13cmos5l_dfrbpq_1
X_3569_ _3569_/Q _3809_/CLK _3569_/D _3569_/RESET_B VPWR VGND sg13cmos5l_dfrbpq_1
XFILLER_0_305 VPWR VGND sg13cmos5l_decap_8
XFILLER_0_327 VPWR VGND sg13cmos5l_decap_8
XFILLER_29_567 VPWR VGND sg13cmos5l_fill_1
XFILLER_44_537 VPWR VGND sg13cmos5l_fill_1
XFILLER_44_526 VPWR VGND sg13cmos5l_decap_4
XFILLER_16_239 VPWR VGND sg13cmos5l_decap_8
XFILLER_13_913 VPWR VGND sg13cmos5l_fill_1
XFILLER_40_743 VPWR VGND sg13cmos5l_decap_8
XFILLER_9_906 VPWR VGND sg13cmos5l_decap_8
XFILLER_8_405 VPWR VGND sg13cmos5l_decap_8
XFILLER_12_478 VPWR VGND sg13cmos5l_decap_8
XFILLER_33_53 VPWR VGND sg13cmos5l_decap_4
XFILLER_32_1023 VPWR VGND sg13cmos5l_decap_4
XFILLER_4_666 VPWR VGND sg13cmos5l_decap_8
XFILLER_48_810 VPWR VGND sg13cmos5l_decap_8
XFILLER_48_887 VPWR VGND sg13cmos5l_decap_8
XFILLER_47_397 VPWR VGND sg13cmos5l_decap_8
XFILLER_43_570 VPWR VGND sg13cmos5l_fill_1
X_2940_ _3612_/D _2911_/B _2921_/B _3590_/D VPWR VGND sg13cmos5l_a21o_1
XFILLER_16_795 VPWR VGND sg13cmos5l_fill_1
X_2871_ _2871_/Y _2871_/A _2871_/B VPWR VGND sg13cmos5l_nand2_1
XFILLER_30_220 VPWR VGND sg13cmos5l_decap_8
XFILLER_31_765 VPWR VGND sg13cmos5l_decap_8
XFILLER_8_961 VPWR VGND sg13cmos5l_decap_8
XFILLER_7_460 VPWR VGND sg13cmos5l_decap_8
XFILLER_7_493 VPWR VGND sg13cmos5l_decap_8
X_3423_ _3423_/Y _3685_/Q _3734_/Q VPWR VGND sg13cmos5l_nand2b_1
X_3354_ _3357_/A _3259_/B _3292_/B _3382_/A _3264_/B VPWR VGND sg13cmos5l_a22oi_1
X_2305_ _3759_/D _2305_/A _2307_/B VPWR VGND sg13cmos5l_nor2_1
X_3285_ _3294_/B _3298_/B VPWR VGND sg13cmos5l_inv_1
XFILLER_39_843 VPWR VGND sg13cmos5l_decap_8
X_2236_ _2236_/X _2217_/B _2217_/C _2210_/X VPWR VGND sg13cmos5l_a21o_1
XFILLER_39_876 VPWR VGND sg13cmos5l_decap_4
XFILLER_39_898 VPWR VGND sg13cmos5l_decap_8
XFILLER_38_386 VPWR VGND sg13cmos5l_fill_2
X_2167_ _2270_/A _2457_/B _2457_/A VPWR VGND sg13cmos5l_nand2b_1
XFILLER_26_526 VPWR VGND sg13cmos5l_decap_4
XFILLER_0_1021 VPWR VGND sg13cmos5l_decap_8
X_2098_ _2098_/Y _3249_/A VPWR VGND sg13cmos5l_inv_1
XFILLER_22_754 VPWR VGND sg13cmos5l_decap_8
XFILLER_21_297 VPWR VGND sg13cmos5l_decap_4
XFILLER_5_419 VPWR VGND sg13cmos5l_decap_8
XFILLER_0_113 VPWR VGND sg13cmos5l_decap_8
X_3609__242 _3609_/RESET_B VPWR VGND sg13cmos5l_tiehi
XFILLER_28_42 VPWR VGND sg13cmos5l_fill_2
XFILLER_29_353 VPWR VGND sg13cmos5l_decap_4
XFILLER_45_868 VPWR VGND sg13cmos5l_decap_8
XFILLER_25_581 VPWR VGND sg13cmos5l_decap_8
X_3616__235 _3616_/RESET_B VPWR VGND sg13cmos5l_tiehi
XFILLER_40_595 VPWR VGND sg13cmos5l_fill_1
XFILLER_40_584 VPWR VGND sg13cmos5l_decap_8
XFILLER_12_297 VPWR VGND sg13cmos5l_decap_8
XFILLER_13_798 VPWR VGND sg13cmos5l_decap_8
XFILLER_8_279 VPWR VGND sg13cmos5l_decap_8
XFILLER_5_964 VPWR VGND sg13cmos5l_decap_8
XFILLER_4_474 VPWR VGND sg13cmos5l_decap_8
XFILLER_4_463 VPWR VGND sg13cmos5l_decap_4
X_3807__210 _3807_/RESET_B VPWR VGND sg13cmos5l_tiehi
X_3070_ _3072_/B _3070_/A _3071_/A VPWR VGND sg13cmos5l_nor2b_1
X_2021_ _2698_/A _2596_/A _3555_/Q _2711_/B VPWR VGND sg13cmos5l_nor3_1
XFILLER_48_684 VPWR VGND sg13cmos5l_decap_8
XFILLER_36_879 VPWR VGND sg13cmos5l_decap_8
XFILLER_16_570 VPWR VGND sg13cmos5l_decap_8
XFILLER_23_507 VPWR VGND sg13cmos5l_fill_1
X_2923_ _2923_/Y _2923_/A _2923_/B _2927_/B VPWR VGND sg13cmos5l_nor3_1
X_2854_ _2979_/A _3612_/Q _3029_/A VPWR VGND sg13cmos5l_xnor2_1
X_2785_ _2786_/A _2783_/Y _2784_/Y _2682_/B VPWR VGND sg13cmos5l_o21ai_1
XFILLER_8_780 VPWR VGND sg13cmos5l_decap_4
X_3406_ _3406_/Y _3385_/A _3408_/A _3236_/Y VPWR VGND sg13cmos5l_o21ai_1
X_3337_ _3337_/Y _3323_/Y hold682/X _3303_/A VPWR VGND sg13cmos5l_a21oi_1
X_3268_ _3270_/B _3265_/A _3248_/Y _2058_/B VPWR VGND sg13cmos5l_a21oi_1
X_2219_ _2219_/Y _3731_/Q _3709_/Q VPWR VGND sg13cmos5l_nor2_1
XFILLER_27_813 VPWR VGND sg13cmos5l_decap_8
X_3199_ _3199_/Y _3658_/Q _3631_/Q VPWR VGND sg13cmos5l_xnor2_1
XFILLER_42_838 VPWR VGND sg13cmos5l_decap_8
XFILLER_26_389 VPWR VGND sg13cmos5l_fill_1
XFILLER_41_326 VPWR VGND sg13cmos5l_decap_8
XFILLER_10_724 VPWR VGND sg13cmos5l_decap_8
XFILLER_30_32 VPWR VGND sg13cmos5l_decap_8
XFILLER_2_912 VPWR VGND sg13cmos5l_decap_8
XFILLER_1_400 VPWR VGND sg13cmos5l_decap_4
XFILLER_30_87 VPWR VGND sg13cmos5l_decap_8
Xhold780 _2949_/B _3615_/Q VPWR VGND sg13cmos5l_dlygate4sd3_1
Xhold791 _3061_/A _3634_/Q VPWR VGND sg13cmos5l_dlygate4sd3_1
XFILLER_7_1016 VPWR VGND sg13cmos5l_decap_8
XFILLER_2_989 VPWR VGND sg13cmos5l_decap_8
XFILLER_49_426 VPWR VGND sg13cmos5l_decap_8
XFILLER_7_1027 VPWR VGND sg13cmos5l_fill_2
XFILLER_45_610 VPWR VGND sg13cmos5l_decap_8
XFILLER_18_824 VPWR VGND sg13cmos5l_decap_4
XFILLER_45_643 VPWR VGND sg13cmos5l_decap_8
XFILLER_45_698 VPWR VGND sg13cmos5l_decap_8
XFILLER_44_164 VPWR VGND sg13cmos5l_fill_2
XFILLER_44_175 VPWR VGND sg13cmos5l_fill_2
XFILLER_41_893 VPWR VGND sg13cmos5l_decap_8
XFILLER_40_381 VPWR VGND sg13cmos5l_decap_8
XFILLER_9_588 VPWR VGND sg13cmos5l_decap_8
X_2570_ _3795_/D _2586_/A _2570_/B VPWR VGND sg13cmos5l_nor2_1
XFILLER_45_1022 VPWR VGND sg13cmos5l_decap_8
X_3122_ _3122_/Y _3187_/A _1981_/Y _3121_/Y _3638_/Q VPWR VGND sg13cmos5l_a22oi_1
XFILLER_49_971 VPWR VGND sg13cmos5l_decap_8
X_3779__437 _3779_/RESET_B VPWR VGND sg13cmos5l_tiehi
X_3053_ _3053_/Y _2966_/B _3055_/A VPWR VGND sg13cmos5l_nand2b_1
XFILLER_36_610 VPWR VGND sg13cmos5l_decap_8
X_2004_ _3324_/A _3684_/Q VPWR VGND sg13cmos5l_inv_1
X_2906_ _2906_/Y _3603_/Q _2907_/A2 _3025_/A VPWR VGND sg13cmos5l_o21ai_1
X_2837_ _3580_/D _2837_/A _2837_/B VPWR VGND sg13cmos5l_nor2_1
X_2768_ _2768_/Y _2912_/A _2768_/B VPWR VGND sg13cmos5l_nand2_1
X_2699_ _2699_/Y _2692_/A _3550_/Q _2693_/B hold653/X VPWR VGND sg13cmos5l_a22oi_1
XFILLER_2_219 VPWR VGND sg13cmos5l_decap_4
XFILLER_47_919 VPWR VGND sg13cmos5l_decap_8
X_3606__245 _3606_/RESET_B VPWR VGND sg13cmos5l_tiehi
XFILLER_46_429 VPWR VGND sg13cmos5l_fill_1
XFILLER_18_109 VPWR VGND sg13cmos5l_decap_4
XFILLER_27_654 VPWR VGND sg13cmos5l_decap_4
XFILLER_15_816 VPWR VGND sg13cmos5l_fill_1
XFILLER_25_76 VPWR VGND sg13cmos5l_decap_8
X_3613__238 _3613_/RESET_B VPWR VGND sg13cmos5l_tiehi
XFILLER_41_42 VPWR VGND sg13cmos5l_fill_2
XFILLER_6_514 VPWR VGND sg13cmos5l_decap_4
XFILLER_6_558 VPWR VGND sg13cmos5l_fill_2
XFILLER_6_547 VPWR VGND sg13cmos5l_decap_8
XFILLER_2_786 VPWR VGND sg13cmos5l_decap_8
XFILLER_2_14 VPWR VGND sg13cmos5l_decap_8
XFILLER_46_930 VPWR VGND sg13cmos5l_decap_8
XFILLER_45_495 VPWR VGND sg13cmos5l_decap_8
XFILLER_17_186 VPWR VGND sg13cmos5l_decap_8
XFILLER_33_668 VPWR VGND sg13cmos5l_decap_8
X_3740_ _3740_/Q clkload4/A _3740_/D _3740_/RESET_B VPWR VGND sg13cmos5l_dfrbpq_1
XFILLER_32_167 VPWR VGND sg13cmos5l_fill_1
XFILLER_9_352 VPWR VGND sg13cmos5l_fill_1
XFILLER_13_392 VPWR VGND sg13cmos5l_fill_2
XFILLER_12_1010 VPWR VGND sg13cmos5l_decap_8
X_3671_ _3671_/Q _3698_/CLK _3671_/D _3671_/RESET_B VPWR VGND sg13cmos5l_dfrbpq_1
X_2622_ _3497_/D input8/X hold572/X _2627_/S VPWR VGND sg13cmos5l_mux2_1
X_2553_ _2555_/B _2553_/A _2560_/B _2560_/C VPWR VGND sg13cmos5l_and3_1
X_2484_ _2484_/Y _3765_/Q _2484_/B VPWR VGND sg13cmos5l_nor2_1
X_3105_ _3641_/D _3143_/A _3105_/B VPWR VGND sg13cmos5l_nor2_1
X_3036_ _3036_/Y _3636_/Q _3052_/C VPWR VGND sg13cmos5l_nand2_1
XFILLER_37_996 VPWR VGND sg13cmos5l_decap_8
XFILLER_24_602 VPWR VGND sg13cmos5l_decap_8
XFILLER_24_624 VPWR VGND sg13cmos5l_decap_8
XFILLER_24_635 VPWR VGND sg13cmos5l_decap_8
XFILLER_36_484 VPWR VGND sg13cmos5l_decap_8
XFILLER_23_134 VPWR VGND sg13cmos5l_decap_8
XFILLER_24_657 VPWR VGND sg13cmos5l_decap_8
XFILLER_20_830 VPWR VGND sg13cmos5l_decap_8
XFILLER_20_885 VPWR VGND sg13cmos5l_decap_8
XFILLER_20_896 VPWR VGND sg13cmos5l_fill_1
XFILLER_3_539 VPWR VGND sg13cmos5l_fill_2
XFILLER_19_418 VPWR VGND sg13cmos5l_decap_8
XFILLER_28_941 VPWR VGND sg13cmos5l_decap_8
XFILLER_42_421 VPWR VGND sg13cmos5l_fill_1
XFILLER_27_495 VPWR VGND sg13cmos5l_fill_1
XFILLER_43_955 VPWR VGND sg13cmos5l_decap_8
XFILLER_14_178 VPWR VGND sg13cmos5l_decap_4
XFILLER_35_1021 VPWR VGND sg13cmos5l_decap_8
XFILLER_11_830 VPWR VGND sg13cmos5l_decap_8
XFILLER_7_834 VPWR VGND sg13cmos5l_decap_8
XFILLER_6_355 VPWR VGND sg13cmos5l_decap_8
XFILLER_35_7 VPWR VGND sg13cmos5l_decap_8
XFILLER_42_1014 VPWR VGND sg13cmos5l_decap_8
XFILLER_2_594 VPWR VGND sg13cmos5l_decap_8
XFILLER_37_259 VPWR VGND sg13cmos5l_decap_8
XFILLER_18_462 VPWR VGND sg13cmos5l_decap_4
XFILLER_19_963 VPWR VGND sg13cmos5l_decap_8
X_1984_ _3244_/B _3463_/A VPWR VGND sg13cmos5l_inv_1
XFILLER_21_649 VPWR VGND sg13cmos5l_decap_4
X_3723_ _3723_/Q _3783_/CLK _3723_/D _3723_/RESET_B VPWR VGND sg13cmos5l_dfrbpq_1
XFILLER_9_182 VPWR VGND sg13cmos5l_decap_4
X_3654_ _3654_/Q _3731_/CLK _3654_/D _3654_/RESET_B VPWR VGND sg13cmos5l_dfrbpq_1
X_2605_ _3484_/D hold615/X input12/X _2606_/S VPWR VGND sg13cmos5l_mux2_1
X_3585_ _3585_/Q clkload9/A _3585_/D _3585_/RESET_B VPWR VGND sg13cmos5l_dfrbpq_1
X_2536_ _2536_/X _2410_/B _2508_/Y _2536_/S VPWR VGND sg13cmos5l_mux2_1
X_2467_ _3787_/D _2467_/A _2561_/A VPWR VGND sg13cmos5l_nor2_1
X_2398_ _2398_/Y _2398_/A _2411_/B VPWR VGND sg13cmos5l_nand2_1
XFILLER_3_90 VPWR VGND sg13cmos5l_decap_8
XFILLER_28_204 VPWR VGND sg13cmos5l_decap_8
XFILLER_44_708 VPWR VGND sg13cmos5l_fill_1
X_3019_ _3019_/Y _1935_/A _3020_/A2 _3025_/A VPWR VGND sg13cmos5l_o21ai_1
XFILLER_19_1005 VPWR VGND sg13cmos5l_decap_8
XFILLER_25_966 VPWR VGND sg13cmos5l_decap_8
XFILLER_11_104 VPWR VGND sg13cmos5l_decap_8
XFILLER_12_616 VPWR VGND sg13cmos5l_decap_4
XFILLER_24_487 VPWR VGND sg13cmos5l_decap_8
XFILLER_40_958 VPWR VGND sg13cmos5l_decap_8
XFILLER_11_137 VPWR VGND sg13cmos5l_decap_8
XFILLER_20_660 VPWR VGND sg13cmos5l_fill_1
XFILLER_47_63 VPWR VGND sg13cmos5l_decap_8
XFILLER_19_215 VPWR VGND sg13cmos5l_decap_4
XFILLER_19_248 VPWR VGND sg13cmos5l_decap_8
XFILLER_28_760 VPWR VGND sg13cmos5l_fill_2
XFILLER_35_708 VPWR VGND sg13cmos5l_decap_8
XFILLER_27_270 VPWR VGND sg13cmos5l_decap_8
XFILLER_28_793 VPWR VGND sg13cmos5l_decap_4
XFILLER_16_966 VPWR VGND sg13cmos5l_decap_8
XFILLER_42_251 VPWR VGND sg13cmos5l_decap_8
XFILLER_15_476 VPWR VGND sg13cmos5l_decap_8
XFILLER_42_295 VPWR VGND sg13cmos5l_decap_8
XFILLER_30_479 VPWR VGND sg13cmos5l_decap_8
XFILLER_7_631 VPWR VGND sg13cmos5l_decap_8
Xhold609 hold609/X _3510_/Q VPWR VGND sg13cmos5l_dlygate4sd3_1
XFILLER_6_152 VPWR VGND sg13cmos5l_fill_1
X_3370_ _3389_/B _3690_/Q _3662_/Q _3695_/Q VPWR VGND sg13cmos5l_nand3_1
XFILLER_3_892 VPWR VGND sg13cmos5l_decap_8
X_2321_ _2349_/B _2319_/Y _2320_/Y _2333_/B VPWR VGND sg13cmos5l_a21oi_1
X_2252_ _2253_/B _2465_/A _2468_/A _2256_/C VPWR VGND sg13cmos5l_nand3_1
XFILLER_33_4 VPWR VGND sg13cmos5l_fill_2
X_2183_ _2202_/B _3764_/Q _3765_/Q _3766_/Q VPWR VGND sg13cmos5l_o21ai_1
XFILLER_38_568 VPWR VGND sg13cmos5l_fill_2
XFILLER_19_760 VPWR VGND sg13cmos5l_decap_8
XFILLER_19_782 VPWR VGND sg13cmos5l_fill_2
X_3706_ _3706_/Q _3712_/CLK _3706_/D _3706_/RESET_B VPWR VGND sg13cmos5l_dfrbpq_1
X_1967_ _1967_/Y _2428_/B VPWR VGND sg13cmos5l_inv_1
X_3637_ _3637_/Q _3666_/CLK _3637_/D _3637_/RESET_B VPWR VGND sg13cmos5l_dfrbpq_1
X_3568_ _3568_/Q _3809_/CLK _3568_/D _3568_/RESET_B VPWR VGND sg13cmos5l_dfrbpq_1
X_2519_ _2536_/S _2527_/B _2527_/C VPWR VGND sg13cmos5l_nor2_1
XFILLER_1_829 VPWR VGND sg13cmos5l_decap_8
X_3499_ _3499_/Q _3574_/CLK _3499_/D _3499_/RESET_B VPWR VGND sg13cmos5l_dfrbpq_1
XFILLER_29_535 VPWR VGND sg13cmos5l_decap_8
XFILLER_29_557 VPWR VGND sg13cmos5l_decap_4
XFILLER_16_229 VPWR VGND sg13cmos5l_decap_4
X_3677__135 _3677_/RESET_B VPWR VGND sg13cmos5l_tiehi
XFILLER_25_774 VPWR VGND sg13cmos5l_decap_8
XFILLER_25_785 VPWR VGND sg13cmos5l_fill_1
XFILLER_40_722 VPWR VGND sg13cmos5l_decap_8
XFILLER_33_32 VPWR VGND sg13cmos5l_decap_8
XFILLER_12_457 VPWR VGND sg13cmos5l_decap_8
XFILLER_32_1002 VPWR VGND sg13cmos5l_decap_8
XFILLER_21_980 VPWR VGND sg13cmos5l_decap_8
XFILLER_20_490 VPWR VGND sg13cmos5l_fill_1
XFILLER_3_144 VPWR VGND sg13cmos5l_fill_1
XFILLER_3_188 VPWR VGND sg13cmos5l_decap_8
XFILLER_0_895 VPWR VGND sg13cmos5l_decap_8
XFILLER_48_866 VPWR VGND sg13cmos5l_decap_8
X_3660__172 _3660_/RESET_B VPWR VGND sg13cmos5l_tiehi
XFILLER_47_376 VPWR VGND sg13cmos5l_decap_8
XFILLER_35_549 VPWR VGND sg13cmos5l_fill_2
XFILLER_16_763 VPWR VGND sg13cmos5l_decap_4
XFILLER_31_711 VPWR VGND sg13cmos5l_fill_2
X_2870_ _2871_/B hold757/X _2982_/A VPWR VGND sg13cmos5l_nand2b_1
XFILLER_15_284 VPWR VGND sg13cmos5l_decap_8
XFILLER_8_940 VPWR VGND sg13cmos5l_decap_8
Xclkbuf_leaf_10_clk _3664_/CLK clkload0/A VPWR VGND sg13cmos5l_buf_8
XFILLER_48_1020 VPWR VGND sg13cmos5l_decap_8
X_3422_ _3422_/Y _2306_/A _3684_/Q _3683_/Q _2305_/A _3421_/Y VPWR VGND sg13cmos5l_a221oi_1
X_3353_ _3391_/B _3395_/A _3353_/B VPWR VGND sg13cmos5l_nand2_1
X_2304_ _3758_/D _2304_/A _2304_/B VPWR VGND sg13cmos5l_and2_1
X_3284_ _3298_/B _3650_/Q _3284_/B VPWR VGND sg13cmos5l_xor2_1
X_2235_ _3742_/D _2361_/A _2235_/B VPWR VGND sg13cmos5l_nor2_1
X_2166_ _2304_/B _2586_/A _2457_/B VPWR VGND sg13cmos5l_nor2_1
XFILLER_26_505 VPWR VGND sg13cmos5l_decap_8
XFILLER_0_1000 VPWR VGND sg13cmos5l_decap_8
X_2097_ _3249_/A _3701_/Q _3463_/A VPWR VGND sg13cmos5l_xnor2_1
XFILLER_0_91 VPWR VGND sg13cmos5l_decap_4
XFILLER_16_1008 VPWR VGND sg13cmos5l_decap_8
XFILLER_21_210 VPWR VGND sg13cmos5l_fill_1
XFILLER_34_593 VPWR VGND sg13cmos5l_decap_8
X_2999_ _2999_/Y _3190_/A _3599_/Q _2998_/Y VPWR VGND sg13cmos5l_o21ai_1
XFILLER_22_788 VPWR VGND sg13cmos5l_decap_8
X_3748__147 _3748_/RESET_B VPWR VGND sg13cmos5l_tiehi
XFILLER_0_136 VPWR VGND sg13cmos5l_fill_1
XFILLER_49_619 VPWR VGND sg13cmos5l_decap_8
XFILLER_45_847 VPWR VGND sg13cmos5l_decap_8
XFILLER_17_505 VPWR VGND sg13cmos5l_decap_8
XFILLER_17_538 VPWR VGND sg13cmos5l_decap_4
XFILLER_28_98 VPWR VGND sg13cmos5l_fill_2
XFILLER_44_31 VPWR VGND sg13cmos5l_decap_8
XFILLER_32_508 VPWR VGND sg13cmos5l_fill_2
XFILLER_32_519 VPWR VGND sg13cmos5l_decap_4
XFILLER_44_64 VPWR VGND sg13cmos5l_decap_8
XFILLER_40_530 VPWR VGND sg13cmos5l_decap_4
XFILLER_25_593 VPWR VGND sg13cmos5l_fill_2
XFILLER_40_563 VPWR VGND sg13cmos5l_decap_8
XFILLER_13_777 VPWR VGND sg13cmos5l_decap_8
XFILLER_8_214 VPWR VGND sg13cmos5l_fill_1
XFILLER_9_737 VPWR VGND sg13cmos5l_decap_8
XFILLER_12_287 VPWR VGND sg13cmos5l_decap_4
XFILLER_5_943 VPWR VGND sg13cmos5l_decap_8
XFILLER_4_442 VPWR VGND sg13cmos5l_decap_8
X_2020_ _2717_/C _3555_/Q _2711_/B VPWR VGND sg13cmos5l_nor2_1
XFILLER_36_836 VPWR VGND sg13cmos5l_decap_8
XFILLER_39_1008 VPWR VGND sg13cmos5l_decap_8
X_2922_ _2927_/B _2925_/A _2925_/B VPWR VGND sg13cmos5l_and2_1
XFILLER_43_390 VPWR VGND sg13cmos5l_decap_8
X_2853_ _2864_/B _3612_/Q _3029_/A VPWR VGND sg13cmos5l_nor2_1
X_2784_ _2784_/Y _2810_/A1 _3505_/Q _2810_/B1 VPWR VGND sg13cmos5l_o21ai_1
X_3405_ _3699_/D _3363_/X _3408_/A _3404_/Y VPWR VGND sg13cmos5l_a21oi_1
X_3336_ _3336_/Y _3336_/A _3336_/B VPWR VGND sg13cmos5l_nand2_1
X_3267_ _3674_/D _3410_/A _3267_/B VPWR VGND sg13cmos5l_nor2_1
XFILLER_22_1023 VPWR VGND sg13cmos5l_decap_4
X_2218_ _2231_/B _3710_/Q _3709_/Q VPWR VGND sg13cmos5l_xnor2_1
XFILLER_26_302 VPWR VGND sg13cmos5l_fill_1
X_3198_ _3198_/Y _3657_/Q _3630_/Q VPWR VGND sg13cmos5l_xnor2_1
X_2149_ _2150_/B _3418_/B _2136_/Y _2158_/S VPWR VGND sg13cmos5l_mux2_1
XFILLER_27_847 VPWR VGND sg13cmos5l_decap_8
XFILLER_14_508 VPWR VGND sg13cmos5l_decap_8
XFILLER_14_519 VPWR VGND sg13cmos5l_fill_1
XFILLER_22_530 VPWR VGND sg13cmos5l_decap_8
XFILLER_34_390 VPWR VGND sg13cmos5l_decap_4
XFILLER_10_703 VPWR VGND sg13cmos5l_decap_8
XFILLER_30_66 VPWR VGND sg13cmos5l_decap_4
Xhold770 _2398_/A _3789_/Q VPWR VGND sg13cmos5l_dlygate4sd3_1
Xhold781 _1958_/A _3748_/Q VPWR VGND sg13cmos5l_dlygate4sd3_1
XFILLER_49_405 VPWR VGND sg13cmos5l_decap_8
XFILLER_39_42 VPWR VGND sg13cmos5l_fill_2
XFILLER_39_31 VPWR VGND sg13cmos5l_decap_8
XFILLER_2_968 VPWR VGND sg13cmos5l_decap_8
Xhold792 _3062_/B _3061_/X VPWR VGND sg13cmos5l_dlygate4sd3_1
XFILLER_29_162 VPWR VGND sg13cmos5l_decap_8
XFILLER_41_850 VPWR VGND sg13cmos5l_fill_2
XFILLER_13_552 VPWR VGND sg13cmos5l_decap_4
XFILLER_41_872 VPWR VGND sg13cmos5l_decap_8
XFILLER_13_574 VPWR VGND sg13cmos5l_decap_4
XFILLER_9_567 VPWR VGND sg13cmos5l_decap_8
XFILLER_5_740 VPWR VGND sg13cmos5l_fill_1
XFILLER_5_762 VPWR VGND sg13cmos5l_decap_8
XFILLER_45_1001 VPWR VGND sg13cmos5l_decap_8
XFILLER_4_283 VPWR VGND sg13cmos5l_fill_2
X_3705__304 _3705_/RESET_B VPWR VGND sg13cmos5l_tiehi
X_3121_ _3121_/Y _3618_/Q _3619_/Q VPWR VGND sg13cmos5l_xnor2_1
XFILLER_1_990 VPWR VGND sg13cmos5l_decap_8
XFILLER_49_950 VPWR VGND sg13cmos5l_decap_8
X_3052_ _3073_/B _3052_/A _3052_/B _3052_/C _3052_/D VPWR VGND sg13cmos5l_nor4_1
X_2003_ _3336_/A _3686_/Q VPWR VGND sg13cmos5l_inv_1
XFILLER_36_666 VPWR VGND sg13cmos5l_decap_8
X_2905_ _2905_/Y _1942_/Y _3020_/A2 _2904_/Y VPWR VGND sg13cmos5l_a21oi_1
X_2836_ _2837_/B _2843_/A _2907_/A2 _2755_/A VPWR VGND sg13cmos5l_o21ai_1
X_2767_ _2767_/Y _3572_/Q _2767_/B _2767_/C VPWR VGND sg13cmos5l_nor3_1
X_2698_ _2698_/Y _2698_/A _2698_/B VPWR VGND sg13cmos5l_nand2_1
X_3319_ _3319_/Y _3653_/Q _3319_/B VPWR VGND sg13cmos5l_nand2_1
XFILLER_27_677 VPWR VGND sg13cmos5l_decap_8
XFILLER_42_614 VPWR VGND sg13cmos5l_fill_1
XFILLER_41_102 VPWR VGND sg13cmos5l_fill_2
XFILLER_15_839 VPWR VGND sg13cmos5l_fill_1
XFILLER_26_187 VPWR VGND sg13cmos5l_decap_8
XFILLER_41_157 VPWR VGND sg13cmos5l_fill_2
XFILLER_25_88 VPWR VGND sg13cmos5l_decap_8
X_3730__408 _3730_/RESET_B VPWR VGND sg13cmos5l_tiehi
XFILLER_10_577 VPWR VGND sg13cmos5l_decap_8
XFILLER_2_765 VPWR VGND sg13cmos5l_decap_8
XFILLER_49_224 VPWR VGND sg13cmos5l_decap_8
XFILLER_46_986 VPWR VGND sg13cmos5l_decap_8
XFILLER_45_452 VPWR VGND sg13cmos5l_fill_1
XFILLER_18_655 VPWR VGND sg13cmos5l_decap_8
XFILLER_18_666 VPWR VGND sg13cmos5l_fill_1
XFILLER_45_474 VPWR VGND sg13cmos5l_fill_1
XFILLER_17_165 VPWR VGND sg13cmos5l_decap_8
XFILLER_33_647 VPWR VGND sg13cmos5l_fill_2
XFILLER_20_319 VPWR VGND sg13cmos5l_decap_8
XFILLER_32_157 VPWR VGND sg13cmos5l_decap_4
XFILLER_40_190 VPWR VGND sg13cmos5l_fill_1
X_3670_ _3670_/Q _3698_/CLK _3670_/D _3670_/RESET_B VPWR VGND sg13cmos5l_dfrbpq_1
X_2621_ _3496_/D input7/X hold591/X _2627_/S VPWR VGND sg13cmos5l_mux2_1
X_2552_ _3789_/D _2561_/A _2552_/B _2552_/C VPWR VGND sg13cmos5l_nor3_1
X_2483_ _2550_/A _2473_/Y _2481_/Y _2482_/X VPWR VGND sg13cmos5l_o21ai_1
X_3681__440 _3681_/RESET_B VPWR VGND sg13cmos5l_tiehi
X_3104_ _3105_/B _3104_/A _3104_/B VPWR VGND sg13cmos5l_nand2_1
X_3035_ _3052_/C _3033_/Y _3034_/Y _3032_/Y VPWR VGND sg13cmos5l_a21oi_1
XFILLER_37_975 VPWR VGND sg13cmos5l_decap_8
XFILLER_23_113 VPWR VGND sg13cmos5l_decap_8
X_2819_ _2819_/X _3542_/Q _3525_/Q _3508_/Q _3491_/Q _2819_/S0 _2832_/S1 VPWR VGND
+ sg13cmos5l_mux4_1
X_3799_ _3799_/Q _3806_/CLK _3799_/D _3799_/RESET_B VPWR VGND sg13cmos5l_dfrbpq_1
XFILLER_2_8 VPWR VGND sg13cmos5l_fill_2
XFILLER_47_728 VPWR VGND sg13cmos5l_decap_8
XFILLER_28_920 VPWR VGND sg13cmos5l_decap_8
XFILLER_43_934 VPWR VGND sg13cmos5l_decap_8
XFILLER_28_997 VPWR VGND sg13cmos5l_decap_8
XFILLER_30_606 VPWR VGND sg13cmos5l_decap_4
XFILLER_30_617 VPWR VGND sg13cmos5l_decap_8
XFILLER_35_1000 VPWR VGND sg13cmos5l_decap_8
XFILLER_23_691 VPWR VGND sg13cmos5l_decap_8
XFILLER_7_813 VPWR VGND sg13cmos5l_decap_8
XFILLER_6_334 VPWR VGND sg13cmos5l_decap_8
XFILLER_10_385 VPWR VGND sg13cmos5l_decap_8
XFILLER_10_396 VPWR VGND sg13cmos5l_fill_1
XFILLER_38_728 VPWR VGND sg13cmos5l_decap_8
XFILLER_34_901 VPWR VGND sg13cmos5l_decap_8
XFILLER_46_783 VPWR VGND sg13cmos5l_decap_8
XFILLER_33_411 VPWR VGND sg13cmos5l_decap_8
XFILLER_34_934 VPWR VGND sg13cmos5l_decap_8
XFILLER_33_488 VPWR VGND sg13cmos5l_decap_8
XFILLER_34_989 VPWR VGND sg13cmos5l_decap_8
X_1983_ _3464_/A _3320_/A VPWR VGND sg13cmos5l_inv_1
X_3722_ _3722_/Q _3722_/CLK _3722_/D _3722_/RESET_B VPWR VGND sg13cmos5l_dfrbpq_1
X_3653_ _3653_/Q _3728_/CLK _3653_/D _3653_/RESET_B VPWR VGND sg13cmos5l_dfrbpq_1
X_2604_ _3483_/D hold585/X input11/X _2606_/S VPWR VGND sg13cmos5l_mux2_1
XFILLER_6_890 VPWR VGND sg13cmos5l_decap_8
X_3584_ _3584_/Q _3629_/CLK _3584_/D _3584_/RESET_B VPWR VGND sg13cmos5l_dfrbpq_1
X_2535_ _2535_/Y _2410_/B _2536_/S _2534_/Y VPWR VGND sg13cmos5l_o21ai_1
X_2466_ _3786_/D _2466_/A _2561_/A VPWR VGND sg13cmos5l_nor2_1
X_2397_ _2397_/X _2390_/Y _2394_/Y _2396_/A VPWR VGND sg13cmos5l_a21o_1
X_3603__249 _3603_/RESET_B VPWR VGND sg13cmos5l_tiehi
X_3018_ _3626_/D _3452_/A _3018_/B VPWR VGND sg13cmos5l_and2_1
XFILLER_24_422 VPWR VGND sg13cmos5l_decap_8
XFILLER_24_433 VPWR VGND sg13cmos5l_fill_2
XFILLER_25_945 VPWR VGND sg13cmos5l_decap_8
XFILLER_40_937 VPWR VGND sg13cmos5l_decap_8
XFILLER_19_1028 VPWR VGND sg13cmos5l_fill_1
XFILLER_12_639 VPWR VGND sg13cmos5l_fill_1
XFILLER_22_56 VPWR VGND sg13cmos5l_decap_8
XFILLER_22_67 VPWR VGND sg13cmos5l_fill_1
XFILLER_47_31 VPWR VGND sg13cmos5l_decap_4
XFILLER_47_20 VPWR VGND sg13cmos5l_fill_2
XFILLER_47_53 VPWR VGND sg13cmos5l_fill_1
XFILLER_15_411 VPWR VGND sg13cmos5l_fill_2
XFILLER_16_923 VPWR VGND sg13cmos5l_decap_8
XFILLER_42_230 VPWR VGND sg13cmos5l_decap_8
XFILLER_15_422 VPWR VGND sg13cmos5l_decap_4
XFILLER_42_241 VPWR VGND sg13cmos5l_fill_1
XFILLER_31_926 VPWR VGND sg13cmos5l_decap_8
XFILLER_30_414 VPWR VGND sg13cmos5l_decap_8
XFILLER_6_120 VPWR VGND sg13cmos5l_fill_2
XFILLER_7_698 VPWR VGND sg13cmos5l_decap_8
XFILLER_3_871 VPWR VGND sg13cmos5l_decap_8
X_2320_ _2320_/Y _3753_/Q _3724_/Q VPWR VGND sg13cmos5l_xnor2_1
X_2251_ _2251_/Y _3718_/Q _2251_/B _2256_/C VPWR VGND sg13cmos5l_nor3_1
XFILLER_26_4 VPWR VGND sg13cmos5l_fill_2
XFILLER_38_547 VPWR VGND sg13cmos5l_fill_2
X_2182_ _2189_/B _3764_/Q _3765_/Q _3766_/Q VPWR VGND sg13cmos5l_nor3_1
XFILLER_46_580 VPWR VGND sg13cmos5l_decap_8
XFILLER_33_230 VPWR VGND sg13cmos5l_decap_4
XFILLER_22_926 VPWR VGND sg13cmos5l_decap_8
XFILLER_34_775 VPWR VGND sg13cmos5l_decap_8
X_1966_ _1966_/Y _3791_/Q VPWR VGND sg13cmos5l_inv_1
XFILLER_21_447 VPWR VGND sg13cmos5l_decap_4
X_3705_ _3705_/Q _3712_/CLK _3705_/D _3705_/RESET_B VPWR VGND sg13cmos5l_dfrbpq_1
X_3636_ _3636_/Q _3664_/CLK _3636_/D _3636_/RESET_B VPWR VGND sg13cmos5l_dfrbpq_1
XFILLER_1_808 VPWR VGND sg13cmos5l_decap_8
X_3567_ _3567_/Q clkload1/A _3567_/D _3567_/RESET_B VPWR VGND sg13cmos5l_dfrbpq_1
X_2518_ _2527_/C _2414_/X _2512_/Y _2549_/A VPWR VGND sg13cmos5l_a21o_1
X_3498_ _3498_/Q _3809_/CLK _3498_/D _3498_/RESET_B VPWR VGND sg13cmos5l_dfrbpq_1
X_2449_ _2450_/B _2430_/B _1951_/Y _2451_/S VPWR VGND sg13cmos5l_mux2_1
XFILLER_29_503 VPWR VGND sg13cmos5l_fill_1
XFILLER_40_712 VPWR VGND sg13cmos5l_fill_1
XFILLER_40_701 VPWR VGND sg13cmos5l_decap_8
XFILLER_24_241 VPWR VGND sg13cmos5l_decap_8
XFILLER_12_436 VPWR VGND sg13cmos5l_decap_8
XFILLER_25_797 VPWR VGND sg13cmos5l_decap_8
X_3577__281 _3577_/RESET_B VPWR VGND sg13cmos5l_tiehi
XFILLER_12_447 VPWR VGND sg13cmos5l_fill_1
XFILLER_4_624 VPWR VGND sg13cmos5l_decap_8
XFILLER_3_123 VPWR VGND sg13cmos5l_decap_8
XFILLER_3_156 VPWR VGND sg13cmos5l_decap_8
XFILLER_0_874 VPWR VGND sg13cmos5l_decap_8
XFILLER_48_845 VPWR VGND sg13cmos5l_decap_8
XFILLER_47_322 VPWR VGND sg13cmos5l_fill_2
XFILLER_43_561 VPWR VGND sg13cmos5l_decap_8
XFILLER_15_252 VPWR VGND sg13cmos5l_decap_4
XFILLER_16_786 VPWR VGND sg13cmos5l_decap_8
XFILLER_30_233 VPWR VGND sg13cmos5l_fill_1
XFILLER_8_996 VPWR VGND sg13cmos5l_decap_8
X_3421_ _3421_/Y _3732_/Q _2005_/Y _2006_/Y _3731_/Q VPWR VGND sg13cmos5l_a22oi_1
X_3352_ _3698_/D _3352_/A _3352_/B VPWR VGND sg13cmos5l_and2_1
X_2303_ _3757_/D _2303_/A _2303_/B VPWR VGND sg13cmos5l_and2_1
X_3283_ _3283_/Y _3283_/A _3283_/B VPWR VGND sg13cmos5l_nor2_1
XFILLER_39_823 VPWR VGND sg13cmos5l_decap_4
X_2234_ _2235_/B _2311_/B _2311_/C VPWR VGND sg13cmos5l_nand2_1
X_2165_ _3734_/D _3467_/A _2164_/Y _3466_/B VPWR VGND sg13cmos5l_a21oi_1
XFILLER_17_0 VPWR VGND sg13cmos5l_decap_4
XFILLER_38_388 VPWR VGND sg13cmos5l_fill_1
XFILLER_0_70 VPWR VGND sg13cmos5l_decap_8
X_2096_ _2096_/Y _2104_/A _2104_/B VPWR VGND sg13cmos5l_nand2_1
XFILLER_19_591 VPWR VGND sg13cmos5l_decap_8
XFILLER_26_539 VPWR VGND sg13cmos5l_decap_8
XFILLER_22_734 VPWR VGND sg13cmos5l_fill_2
XFILLER_34_572 VPWR VGND sg13cmos5l_fill_1
X_2998_ _2998_/Y _3189_/A _3598_/Q _2997_/Y VPWR VGND sg13cmos5l_o21ai_1
XFILLER_21_266 VPWR VGND sg13cmos5l_decap_8
X_1949_ _1949_/Y _1949_/A VPWR VGND sg13cmos5l_inv_1
X_3619_ _3619_/Q _3666_/CLK _3619_/D _3619_/RESET_B VPWR VGND sg13cmos5l_dfrbpq_1
XFILLER_0_159 VPWR VGND sg13cmos5l_decap_8
XFILLER_28_44 VPWR VGND sg13cmos5l_fill_1
XFILLER_29_322 VPWR VGND sg13cmos5l_fill_1
XFILLER_45_826 VPWR VGND sg13cmos5l_decap_8
XFILLER_44_314 VPWR VGND sg13cmos5l_fill_1
XFILLER_29_388 VPWR VGND sg13cmos5l_decap_4
XFILLER_44_54 VPWR VGND sg13cmos5l_fill_1
XFILLER_13_712 VPWR VGND sg13cmos5l_decap_8
XFILLER_13_723 VPWR VGND sg13cmos5l_fill_2
XFILLER_40_542 VPWR VGND sg13cmos5l_fill_2
XFILLER_13_745 VPWR VGND sg13cmos5l_decap_4
XFILLER_8_226 VPWR VGND sg13cmos5l_decap_4
XFILLER_8_259 VPWR VGND sg13cmos5l_fill_2
XFILLER_5_922 VPWR VGND sg13cmos5l_decap_8
XFILLER_5_999 VPWR VGND sg13cmos5l_decap_8
XFILLER_0_682 VPWR VGND sg13cmos5l_decap_8
XFILLER_48_664 VPWR VGND sg13cmos5l_decap_4
XFILLER_35_314 VPWR VGND sg13cmos5l_decap_8
XFILLER_35_369 VPWR VGND sg13cmos5l_decap_8
X_2921_ _2921_/X _2921_/A _2921_/B VPWR VGND sg13cmos5l_or2_1
X_2852_ _2852_/Y _2852_/A _2856_/A VPWR VGND sg13cmos5l_xnor2_1
X_2783_ _2783_/Y _3488_/Q _2810_/A1 VPWR VGND sg13cmos5l_nor2b_1
XFILLER_7_281 VPWR VGND sg13cmos5l_decap_8
X_3404_ _3404_/Y _3388_/C _3408_/A _3236_/Y VPWR VGND sg13cmos5l_o21ai_1
X_3335_ _3335_/Y _3335_/A _3335_/B VPWR VGND sg13cmos5l_nor2_1
XFILLER_39_620 VPWR VGND sg13cmos5l_fill_2
X_3266_ _3267_/B _2138_/A _3265_/Y _3266_/S VPWR VGND sg13cmos5l_mux2_1
X_2217_ _2217_/X _2217_/A _2217_/B _2217_/C VPWR VGND sg13cmos5l_and3_1
XFILLER_22_1002 VPWR VGND sg13cmos5l_decap_8
XFILLER_39_664 VPWR VGND sg13cmos5l_fill_1
XFILLER_38_152 VPWR VGND sg13cmos5l_fill_2
X_3197_ _3197_/Y _3659_/Q _3203_/B VPWR VGND sg13cmos5l_nand2_1
X_2148_ _2158_/S _2145_/Y _2147_/Y _2110_/Y VPWR VGND sg13cmos5l_o21ai_1
XFILLER_26_325 VPWR VGND sg13cmos5l_decap_4
XFILLER_42_807 VPWR VGND sg13cmos5l_decap_8
X_2079_ _2155_/B _3726_/Q _2151_/B VPWR VGND sg13cmos5l_nand2_1
XFILLER_35_870 VPWR VGND sg13cmos5l_decap_8
X_3498__385 _3498_/RESET_B VPWR VGND sg13cmos5l_tiehi
XFILLER_10_759 VPWR VGND sg13cmos5l_decap_8
Xhold771 _2400_/B _2399_/X VPWR VGND sg13cmos5l_dlygate4sd3_1
XFILLER_2_947 VPWR VGND sg13cmos5l_decap_8
XFILLER_1_435 VPWR VGND sg13cmos5l_fill_1
Xhold760 _1999_/A _3715_/Q VPWR VGND sg13cmos5l_dlygate4sd3_1
Xhold782 _3748_/D _2273_/Y VPWR VGND sg13cmos5l_dlygate4sd3_1
Xhold793 _3072_/C _3071_/Y VPWR VGND sg13cmos5l_dlygate4sd3_1
XFILLER_17_336 VPWR VGND sg13cmos5l_decap_8
XFILLER_33_807 VPWR VGND sg13cmos5l_fill_1
XFILLER_44_188 VPWR VGND sg13cmos5l_fill_2
XFILLER_44_177 VPWR VGND sg13cmos5l_fill_1
XFILLER_26_881 VPWR VGND sg13cmos5l_decap_8
XFILLER_13_597 VPWR VGND sg13cmos5l_fill_2
XFILLER_5_796 VPWR VGND sg13cmos5l_decap_8
XFILLER_4_262 VPWR VGND sg13cmos5l_decap_8
X_3120_ _3131_/A _3120_/A _3120_/B VPWR VGND sg13cmos5l_nor2_1
X_3051_ _3067_/A _3051_/A _3051_/B VPWR VGND sg13cmos5l_nor2_1
X_2002_ _2484_/B _3743_/Q VPWR VGND sg13cmos5l_inv_1
XFILLER_36_645 VPWR VGND sg13cmos5l_decap_8
XFILLER_23_317 VPWR VGND sg13cmos5l_fill_2
XFILLER_23_339 VPWR VGND sg13cmos5l_decap_4
XFILLER_16_391 VPWR VGND sg13cmos5l_decap_8
XFILLER_35_199 VPWR VGND sg13cmos5l_decap_8
XFILLER_31_350 VPWR VGND sg13cmos5l_fill_2
X_2904_ _2904_/Y _3602_/Q _3020_/A2 _3452_/A VPWR VGND sg13cmos5l_o21ai_1
XFILLER_32_873 VPWR VGND sg13cmos5l_decap_8
X_2835_ _2837_/A _2835_/A _2843_/B VPWR VGND sg13cmos5l_nor2_1
XFILLER_31_372 VPWR VGND sg13cmos5l_decap_8
X_2766_ _2766_/Y _2766_/A _2771_/A VPWR VGND sg13cmos5l_nor2_1
X_2697_ _2697_/Y _2607_/C _2698_/B _2693_/B _1950_/Y _2696_/Y VPWR VGND sg13cmos5l_a221oi_1
X_3318_ _3318_/Y _2005_/Y _3330_/A _3317_/Y VPWR VGND sg13cmos5l_o21ai_1
X_3249_ _3249_/Y _3249_/A _3249_/B _3249_/C VPWR VGND sg13cmos5l_nand3_1
XFILLER_26_133 VPWR VGND sg13cmos5l_fill_1
XFILLER_26_155 VPWR VGND sg13cmos5l_decap_8
XFILLER_10_534 VPWR VGND sg13cmos5l_decap_8
XFILLER_22_383 VPWR VGND sg13cmos5l_fill_1
XFILLER_23_895 VPWR VGND sg13cmos5l_decap_8
XFILLER_10_556 VPWR VGND sg13cmos5l_decap_8
XFILLER_41_88 VPWR VGND sg13cmos5l_decap_8
XFILLER_2_733 VPWR VGND sg13cmos5l_decap_8
XFILLER_29_1008 VPWR VGND sg13cmos5l_decap_8
Xhold590 _2276_/B _3719_/Q VPWR VGND sg13cmos5l_dlygate4sd3_1
XFILLER_49_269 VPWR VGND sg13cmos5l_decap_8
XFILLER_46_965 VPWR VGND sg13cmos5l_decap_8
XFILLER_17_144 VPWR VGND sg13cmos5l_decap_8
X_3657__178 _3657_/RESET_B VPWR VGND sg13cmos5l_tiehi
XFILLER_33_659 VPWR VGND sg13cmos5l_fill_1
XFILLER_41_670 VPWR VGND sg13cmos5l_decap_8
XFILLER_14_884 VPWR VGND sg13cmos5l_fill_2
XFILLER_9_343 VPWR VGND sg13cmos5l_decap_8
XFILLER_13_394 VPWR VGND sg13cmos5l_fill_1
X_2620_ _3495_/D input6/X hold560/X _2627_/S VPWR VGND sg13cmos5l_mux2_1
X_2551_ _2552_/C _2521_/A _2536_/S _2560_/B _2560_/C _2520_/Y VPWR VGND sg13cmos5l_a221oi_1
X_2482_ _2482_/X _2482_/A _2482_/B VPWR VGND sg13cmos5l_xor2_1
X_3488__395 _3488_/RESET_B VPWR VGND sg13cmos5l_tiehi
X_3103_ _3104_/B _3107_/S _3103_/B VPWR VGND sg13cmos5l_nand2_1
X_3034_ _3034_/Y _3628_/Q _3605_/Q VPWR VGND sg13cmos5l_xnor2_1
XFILLER_37_954 VPWR VGND sg13cmos5l_decap_8
XFILLER_23_169 VPWR VGND sg13cmos5l_decap_8
X_3671__109 _3671_/D VPWR VGND sg13cmos5l_tielo
X_3495__388 _3495_/RESET_B VPWR VGND sg13cmos5l_tiehi
XFILLER_32_681 VPWR VGND sg13cmos5l_decap_8
XFILLER_20_876 VPWR VGND sg13cmos5l_decap_4
X_2818_ _2818_/X _3544_/Q _3527_/Q _3510_/Q _3493_/Q _2819_/S0 _2832_/S1 VPWR VGND
+ sg13cmos5l_mux4_1
X_3798_ _3798_/Q _3806_/CLK _3798_/D _3798_/RESET_B VPWR VGND sg13cmos5l_dfrbpq_1
X_2749_ _2749_/Y _2682_/B _2748_/Y _2755_/A VPWR VGND sg13cmos5l_o21ai_1
XFILLER_47_707 VPWR VGND sg13cmos5l_decap_8
XFILLER_46_239 VPWR VGND sg13cmos5l_decap_4
XFILLER_27_442 VPWR VGND sg13cmos5l_fill_2
XFILLER_28_976 VPWR VGND sg13cmos5l_decap_8
XFILLER_36_44 VPWR VGND sg13cmos5l_fill_1
XFILLER_43_913 VPWR VGND sg13cmos5l_decap_8
XFILLER_15_604 VPWR VGND sg13cmos5l_decap_4
XFILLER_15_648 VPWR VGND sg13cmos5l_decap_8
XFILLER_14_147 VPWR VGND sg13cmos5l_decap_8
XFILLER_11_810 VPWR VGND sg13cmos5l_fill_1
XFILLER_7_869 VPWR VGND sg13cmos5l_decap_8
XFILLER_2_552 VPWR VGND sg13cmos5l_decap_8
XFILLER_37_239 VPWR VGND sg13cmos5l_decap_8
XFILLER_19_921 VPWR VGND sg13cmos5l_decap_8
XFILLER_46_762 VPWR VGND sg13cmos5l_decap_8
XFILLER_45_261 VPWR VGND sg13cmos5l_decap_4
XFILLER_19_998 VPWR VGND sg13cmos5l_decap_8
XFILLER_18_497 VPWR VGND sg13cmos5l_decap_8
XFILLER_34_968 VPWR VGND sg13cmos5l_decap_8
X_1982_ _3190_/A _3136_/B VPWR VGND sg13cmos5l_inv_1
X_3721_ _3721_/Q _3728_/CLK _3721_/D _3721_/RESET_B VPWR VGND sg13cmos5l_dfrbpq_1
X_3652_ _3652_/Q _3728_/CLK _3652_/D _3652_/RESET_B VPWR VGND sg13cmos5l_dfrbpq_1
X_2603_ _3482_/D hold605/X input10/X _2606_/S VPWR VGND sg13cmos5l_mux2_1
X_3583_ _3583_/Q _3629_/CLK _3583_/D _3583_/RESET_B VPWR VGND sg13cmos5l_dfrbpq_1
X_2534_ _2534_/Y _2534_/A _2536_/S VPWR VGND sg13cmos5l_nand2_1
XFILLER_47_0 VPWR VGND sg13cmos5l_decap_4
XFILLER_5_390 VPWR VGND sg13cmos5l_decap_8
X_2465_ _3785_/D _2465_/A _2465_/B VPWR VGND sg13cmos5l_and2_1
X_2396_ _2396_/Y _2396_/A VPWR VGND sg13cmos5l_inv_1
XFILLER_28_239 VPWR VGND sg13cmos5l_decap_8
XFILLER_37_751 VPWR VGND sg13cmos5l_fill_1
XFILLER_25_924 VPWR VGND sg13cmos5l_decap_8
X_3017_ _3017_/Y _3007_/Y hold714/X _3015_/A VPWR VGND sg13cmos5l_a21oi_1
XFILLER_40_916 VPWR VGND sg13cmos5l_decap_8
XFILLER_24_467 VPWR VGND sg13cmos5l_fill_2
X_3688__414 _3688_/RESET_B VPWR VGND sg13cmos5l_tiehi
XFILLER_4_839 VPWR VGND sg13cmos5l_decap_8
X_3647__188 _3647_/RESET_B VPWR VGND sg13cmos5l_tiehi
X_3799__409 _3799_/RESET_B VPWR VGND sg13cmos5l_tiehi
XFILLER_43_732 VPWR VGND sg13cmos5l_decap_8
XFILLER_43_798 VPWR VGND sg13cmos5l_decap_8
XFILLER_42_286 VPWR VGND sg13cmos5l_decap_4
XFILLER_31_949 VPWR VGND sg13cmos5l_decap_8
XFILLER_7_611 VPWR VGND sg13cmos5l_decap_4
XFILLER_11_684 VPWR VGND sg13cmos5l_fill_1
XFILLER_6_132 VPWR VGND sg13cmos5l_decap_8
XFILLER_10_183 VPWR VGND sg13cmos5l_fill_2
XFILLER_7_677 VPWR VGND sg13cmos5l_decap_8
XFILLER_3_850 VPWR VGND sg13cmos5l_decap_8
XFILLER_2_382 VPWR VGND sg13cmos5l_fill_2
X_2250_ _2250_/Y _2261_/A _2247_/X _2256_/C _2249_/Y VPWR VGND sg13cmos5l_a22oi_1
X_3485__398 _3485_/RESET_B VPWR VGND sg13cmos5l_tiehi
XFILLER_38_526 VPWR VGND sg13cmos5l_decap_8
X_2181_ _2181_/X _2185_/B _2198_/A _2181_/C VPWR VGND sg13cmos5l_and3_1
XFILLER_19_4 VPWR VGND sg13cmos5l_fill_2
XFILLER_19_784 VPWR VGND sg13cmos5l_fill_1
XFILLER_18_272 VPWR VGND sg13cmos5l_decap_8
XFILLER_22_905 VPWR VGND sg13cmos5l_decap_8
XFILLER_33_253 VPWR VGND sg13cmos5l_decap_8
XFILLER_15_990 VPWR VGND sg13cmos5l_decap_8
X_1965_ _1965_/Y _3792_/Q VPWR VGND sg13cmos5l_inv_1
X_3704_ _3704_/Q _3712_/CLK _3704_/D _3704_/RESET_B VPWR VGND sg13cmos5l_dfrbpq_1
XFILLER_30_982 VPWR VGND sg13cmos5l_decap_8
X_3635_ _3635_/Q _3664_/CLK _3635_/D _3635_/RESET_B VPWR VGND sg13cmos5l_dfrbpq_1
X_3566_ _3566_/Q clkload5/A _3566_/D _3566_/RESET_B VPWR VGND sg13cmos5l_dfrbpq_1
X_2517_ _2521_/C _2414_/X _2512_/Y _2549_/A VPWR VGND sg13cmos5l_a21oi_1
X_3497_ _3497_/Q _3809_/CLK _3497_/D _3497_/RESET_B VPWR VGND sg13cmos5l_dfrbpq_1
X_2448_ _2448_/Y _2434_/A _2451_/S _2447_/Y VPWR VGND sg13cmos5l_a21oi_1
XFILLER_25_1022 VPWR VGND sg13cmos5l_decap_8
X_2379_ _2379_/X _2379_/A _2379_/B VPWR VGND sg13cmos5l_and2_1
XFILLER_29_515 VPWR VGND sg13cmos5l_decap_8
XFILLER_25_743 VPWR VGND sg13cmos5l_decap_4
XFILLER_25_754 VPWR VGND sg13cmos5l_fill_2
XFILLER_40_757 VPWR VGND sg13cmos5l_decap_8
X_3731__334 _3731_/RESET_B VPWR VGND sg13cmos5l_tiehi
XFILLER_4_636 VPWR VGND sg13cmos5l_decap_8
XFILLER_0_853 VPWR VGND sg13cmos5l_decap_8
XFILLER_48_824 VPWR VGND sg13cmos5l_decap_8
XFILLER_35_507 VPWR VGND sg13cmos5l_fill_1
XFILLER_16_721 VPWR VGND sg13cmos5l_fill_2
XFILLER_15_231 VPWR VGND sg13cmos5l_fill_1
XFILLER_43_584 VPWR VGND sg13cmos5l_decap_4
XFILLER_30_201 VPWR VGND sg13cmos5l_fill_1
XFILLER_31_779 VPWR VGND sg13cmos5l_decap_8
XFILLER_12_982 VPWR VGND sg13cmos5l_decap_8
XFILLER_8_975 VPWR VGND sg13cmos5l_decap_8
XFILLER_7_474 VPWR VGND sg13cmos5l_fill_1
X_3420_ _3712_/D _3466_/B _3420_/B VPWR VGND sg13cmos5l_nor2_1
X_3351_ _3697_/D _3351_/A _3352_/B VPWR VGND sg13cmos5l_and2_1
XFILLER_3_691 VPWR VGND sg13cmos5l_fill_1
X_2302_ _3756_/D _2303_/A _2302_/B VPWR VGND sg13cmos5l_and2_1
X_3282_ _3282_/Y _3283_/A _3283_/B _3281_/Y VPWR VGND sg13cmos5l_a21oi_1
X_2233_ _2311_/C _2232_/B _2232_/C _2231_/X VPWR VGND sg13cmos5l_a21o_1
XFILLER_38_334 VPWR VGND sg13cmos5l_decap_8
XFILLER_38_323 VPWR VGND sg13cmos5l_decap_4
X_2164_ _2164_/Y _3467_/B _2164_/B VPWR VGND sg13cmos5l_nand2_1
X_2095_ _2104_/B _3678_/Q _3677_/Q _3679_/Q VPWR VGND sg13cmos5l_o21ai_1
X_3678__446 _3678_/RESET_B VPWR VGND sg13cmos5l_tiehi
XFILLER_19_570 VPWR VGND sg13cmos5l_decap_8
XFILLER_21_234 VPWR VGND sg13cmos5l_fill_1
XFILLER_21_245 VPWR VGND sg13cmos5l_fill_1
X_3637__198 _3637_/RESET_B VPWR VGND sg13cmos5l_tiehi
X_2997_ _2997_/Y _3190_/A _3599_/Q _2996_/Y VPWR VGND sg13cmos5l_a21oi_1
X_1948_ _2442_/A _1948_/A VPWR VGND sg13cmos5l_inv_1
X_3618_ _3618_/Q _3666_/CLK _3618_/D _3618_/RESET_B VPWR VGND sg13cmos5l_dfrbpq_1
XFILLER_0_127 VPWR VGND sg13cmos5l_fill_2
X_3549_ _3549_/Q clkload1/A _3549_/D _3549_/RESET_B VPWR VGND sg13cmos5l_dfrbpq_1
XFILLER_28_56 VPWR VGND sg13cmos5l_decap_8
XFILLER_45_805 VPWR VGND sg13cmos5l_decap_8
XFILLER_29_367 VPWR VGND sg13cmos5l_decap_8
XFILLER_44_11 VPWR VGND sg13cmos5l_fill_2
XFILLER_12_223 VPWR VGND sg13cmos5l_decap_8
XFILLER_12_234 VPWR VGND sg13cmos5l_fill_1
XFILLER_5_901 VPWR VGND sg13cmos5l_decap_8
XFILLER_5_27 VPWR VGND sg13cmos5l_fill_2
XFILLER_4_422 VPWR VGND sg13cmos5l_fill_2
XFILLER_5_978 VPWR VGND sg13cmos5l_decap_8
XFILLER_5_49 VPWR VGND sg13cmos5l_fill_2
XFILLER_4_488 VPWR VGND sg13cmos5l_fill_2
XFILLER_47_120 VPWR VGND sg13cmos5l_fill_1
XFILLER_10_8 VPWR VGND sg13cmos5l_fill_2
XFILLER_36_816 VPWR VGND sg13cmos5l_fill_1
XFILLER_36_805 VPWR VGND sg13cmos5l_decap_8
Xclkbuf_2_3__f_clk clkload0/A clkbuf_0_clk/X VPWR VGND sg13cmos5l_buf_8
XFILLER_35_304 VPWR VGND sg13cmos5l_decap_4
XFILLER_35_326 VPWR VGND sg13cmos5l_decap_4
XFILLER_35_359 VPWR VGND sg13cmos5l_fill_1
XFILLER_44_882 VPWR VGND sg13cmos5l_decap_8
X_2920_ _2921_/B _2923_/A _2923_/B VPWR VGND sg13cmos5l_and2_1
XFILLER_16_584 VPWR VGND sg13cmos5l_decap_8
XFILLER_31_554 VPWR VGND sg13cmos5l_decap_8
X_2851_ _2856_/A _3588_/Q _3589_/Q _3590_/Q VPWR VGND sg13cmos5l_nor3_1
XFILLER_31_565 VPWR VGND sg13cmos5l_fill_1
XFILLER_8_750 VPWR VGND sg13cmos5l_decap_4
X_2782_ _2782_/Y _2810_/A1 _3539_/Q _2781_/Y VPWR VGND sg13cmos5l_o21ai_1
XFILLER_7_260 VPWR VGND sg13cmos5l_decap_4
XFILLER_7_271 VPWR VGND sg13cmos5l_fill_1
X_3403_ _3408_/A _3394_/Y _3400_/Y _3402_/Y VPWR VGND sg13cmos5l_o21ai_1
X_3334_ _3335_/B hold710/X _3327_/X _3352_/B VPWR VGND sg13cmos5l_o21ai_1
X_3265_ _3265_/Y _3265_/A _3265_/B VPWR VGND sg13cmos5l_nand2_1
X_2216_ _2216_/X _2217_/B _2217_/C _2217_/A VPWR VGND sg13cmos5l_a21o_1
X_3196_ _3228_/B _3135_/B _3105_/B _3214_/S VPWR VGND sg13cmos5l_mux2_1
XFILLER_38_142 VPWR VGND sg13cmos5l_decap_4
XFILLER_27_827 VPWR VGND sg13cmos5l_decap_4
XFILLER_39_698 VPWR VGND sg13cmos5l_decap_8
X_2147_ _2147_/Y _3419_/B _3415_/B _2146_/Y VPWR VGND sg13cmos5l_o21ai_1
X_2078_ _2155_/A _3728_/Q _2151_/B VPWR VGND sg13cmos5l_xnor2_1
XFILLER_26_348 VPWR VGND sg13cmos5l_fill_2
XFILLER_26_359 VPWR VGND sg13cmos5l_fill_2
XFILLER_22_521 VPWR VGND sg13cmos5l_decap_4
XFILLER_14_69 VPWR VGND sg13cmos5l_decap_4
XFILLER_22_587 VPWR VGND sg13cmos5l_decap_8
XFILLER_6_709 VPWR VGND sg13cmos5l_decap_8
XFILLER_10_738 VPWR VGND sg13cmos5l_decap_8
XFILLER_5_219 VPWR VGND sg13cmos5l_decap_4
XFILLER_30_46 VPWR VGND sg13cmos5l_decap_4
XFILLER_2_926 VPWR VGND sg13cmos5l_decap_8
Xhold772 hold772/X _3677_/Q VPWR VGND sg13cmos5l_dlygate4sd3_1
Xhold761 _3448_/B _3447_/X VPWR VGND sg13cmos5l_dlygate4sd3_1
Xhold750 _1939_/A _3623_/Q VPWR VGND sg13cmos5l_dlygate4sd3_1
Xhold783 _2971_/C _3594_/Q VPWR VGND sg13cmos5l_dlygate4sd3_1
XFILLER_39_11 VPWR VGND sg13cmos5l_fill_2
Xhold794 _2108_/A _3700_/Q VPWR VGND sg13cmos5l_dlygate4sd3_1
XFILLER_45_624 VPWR VGND sg13cmos5l_decap_4
XFILLER_45_679 VPWR VGND sg13cmos5l_fill_2
XFILLER_45_657 VPWR VGND sg13cmos5l_decap_4
XFILLER_33_819 VPWR VGND sg13cmos5l_decap_8
XFILLER_9_503 VPWR VGND sg13cmos5l_decap_8
XFILLER_9_514 VPWR VGND sg13cmos5l_fill_2
X_3733__226 _3733_/RESET_B VPWR VGND sg13cmos5l_tiehi
X_3553__325 _3553_/RESET_B VPWR VGND sg13cmos5l_tiehi
XFILLER_4_241 VPWR VGND sg13cmos5l_decap_8
XFILLER_4_285 VPWR VGND sg13cmos5l_fill_1
X_3050_ _3051_/B _3050_/A _3050_/B VPWR VGND sg13cmos5l_nor2_1
XFILLER_0_491 VPWR VGND sg13cmos5l_fill_1
XFILLER_49_985 VPWR VGND sg13cmos5l_decap_8
X_2001_ _2511_/A _3744_/Q VPWR VGND sg13cmos5l_inv_1
XFILLER_48_473 VPWR VGND sg13cmos5l_decap_8
XFILLER_35_101 VPWR VGND sg13cmos5l_decap_8
XFILLER_24_819 VPWR VGND sg13cmos5l_decap_8
X_3738__159 _3738_/RESET_B VPWR VGND sg13cmos5l_tiehi
XFILLER_17_871 VPWR VGND sg13cmos5l_fill_2
XFILLER_17_893 VPWR VGND sg13cmos5l_decap_8
XFILLER_44_690 VPWR VGND sg13cmos5l_decap_8
X_2903_ _2903_/Y _1943_/Y _2907_/A2 _2902_/Y VPWR VGND sg13cmos5l_a21oi_1
XFILLER_32_885 VPWR VGND sg13cmos5l_decap_4
X_2834_ _2843_/B _2817_/Y _2821_/X _2830_/Y _2833_/Y VPWR VGND sg13cmos5l_a22oi_1
X_2765_ _2771_/A _3572_/Q _2759_/Y _2768_/B VPWR VGND sg13cmos5l_a21o_1
X_2696_ _2696_/Y input4/X _3549_/Q _2597_/C VPWR VGND sg13cmos5l_o21ai_1
X_3317_ _3317_/Y _3682_/Q _3317_/B VPWR VGND sg13cmos5l_nand2_1
X_3248_ _3248_/Y _3248_/A _3249_/B VPWR VGND sg13cmos5l_xnor2_1
XFILLER_39_484 VPWR VGND sg13cmos5l_fill_2
XFILLER_39_473 VPWR VGND sg13cmos5l_fill_1
X_3179_ _3179_/Y _1935_/Y _3179_/A2 _3178_/Y VPWR VGND sg13cmos5l_a21oi_1
XFILLER_27_624 VPWR VGND sg13cmos5l_decap_4
XFILLER_42_605 VPWR VGND sg13cmos5l_decap_8
XFILLER_14_329 VPWR VGND sg13cmos5l_decap_8
XFILLER_42_649 VPWR VGND sg13cmos5l_fill_2
XFILLER_41_126 VPWR VGND sg13cmos5l_fill_2
XFILLER_25_57 VPWR VGND sg13cmos5l_fill_2
XFILLER_23_874 VPWR VGND sg13cmos5l_decap_8
Xhold580 hold580/X _3505_/Q VPWR VGND sg13cmos5l_dlygate4sd3_1
Xhold591 hold591/X _3496_/Q VPWR VGND sg13cmos5l_dlygate4sd3_1
XFILLER_49_248 VPWR VGND sg13cmos5l_decap_8
XFILLER_2_28 VPWR VGND sg13cmos5l_fill_2
XFILLER_46_944 VPWR VGND sg13cmos5l_decap_8
XFILLER_32_137 VPWR VGND sg13cmos5l_decap_8
XFILLER_33_649 VPWR VGND sg13cmos5l_fill_1
XFILLER_12_1024 VPWR VGND sg13cmos5l_decap_4
X_2550_ _2552_/B _2550_/A _2560_/B _2560_/C VPWR VGND sg13cmos5l_and3_1
XFILLER_5_583 VPWR VGND sg13cmos5l_fill_1
XFILLER_5_572 VPWR VGND sg13cmos5l_decap_8
X_2481_ _2481_/Y _3788_/Q _2545_/B _2545_/C _2480_/Y VPWR VGND sg13cmos5l_a22oi_1
XFILLER_49_4 VPWR VGND sg13cmos5l_decap_8
X_3102_ _3103_/B _3348_/A _3287_/A VPWR VGND sg13cmos5l_nand2_1
XFILLER_49_782 VPWR VGND sg13cmos5l_decap_8
XFILLER_37_933 VPWR VGND sg13cmos5l_decap_8
X_3033_ _3033_/Y _3627_/Q _3604_/Q VPWR VGND sg13cmos5l_xnor2_1
XFILLER_36_421 VPWR VGND sg13cmos5l_decap_8
XFILLER_24_616 VPWR VGND sg13cmos5l_decap_4
XFILLER_36_498 VPWR VGND sg13cmos5l_decap_8
XFILLER_23_148 VPWR VGND sg13cmos5l_decap_8
XFILLER_32_660 VPWR VGND sg13cmos5l_fill_2
XFILLER_20_844 VPWR VGND sg13cmos5l_decap_8
XFILLER_20_866 VPWR VGND sg13cmos5l_decap_4
X_2817_ _2817_/Y _2682_/B _2809_/X _2816_/Y VPWR VGND sg13cmos5l_o21ai_1
X_3797_ _3797_/Q clkload2/A _3797_/D _3797_/RESET_B VPWR VGND sg13cmos5l_dfrbpq_1
X_2748_ _2748_/Y _2751_/A _2751_/B VPWR VGND sg13cmos5l_nand2b_1
X_2679_ _3543_/D input12/X hold629/X _2681_/S VPWR VGND sg13cmos5l_mux2_1
XFILLER_28_955 VPWR VGND sg13cmos5l_decap_8
XFILLER_15_627 VPWR VGND sg13cmos5l_decap_8
XFILLER_43_969 VPWR VGND sg13cmos5l_decap_8
XFILLER_42_446 VPWR VGND sg13cmos5l_fill_1
XFILLER_11_844 VPWR VGND sg13cmos5l_decap_4
XFILLER_7_848 VPWR VGND sg13cmos5l_decap_8
XFILLER_6_369 VPWR VGND sg13cmos5l_decap_8
X_3767__130 _3767_/D VPWR VGND sg13cmos5l_tielo
XFILLER_7_0 VPWR VGND sg13cmos5l_decap_8
XFILLER_42_1028 VPWR VGND sg13cmos5l_fill_1
XFILLER_37_207 VPWR VGND sg13cmos5l_decap_8
XFILLER_46_730 VPWR VGND sg13cmos5l_decap_4
XFILLER_19_977 VPWR VGND sg13cmos5l_decap_8
XFILLER_34_947 VPWR VGND sg13cmos5l_decap_8
XFILLER_21_608 VPWR VGND sg13cmos5l_decap_8
X_1981_ _1981_/Y _1981_/A VPWR VGND sg13cmos5l_inv_1
XFILLER_14_660 VPWR VGND sg13cmos5l_decap_8
XFILLER_14_682 VPWR VGND sg13cmos5l_decap_8
XFILLER_20_118 VPWR VGND sg13cmos5l_fill_2
X_3720_ _3720_/Q _3728_/CLK _3720_/D _3720_/RESET_B VPWR VGND sg13cmos5l_dfrbpq_1
X_3651_ _3651_/Q _3722_/CLK _3651_/D _3651_/RESET_B VPWR VGND sg13cmos5l_dfrbpq_1
X_3582_ _3582_/Q _3629_/CLK _3582_/D _3582_/RESET_B VPWR VGND sg13cmos5l_dfrbpq_1
X_2602_ _3481_/D hold575/X input9/X _2606_/S VPWR VGND sg13cmos5l_mux2_1
X_2533_ _2533_/Y _2557_/A VPWR VGND sg13cmos5l_inv_1
X_2464_ _3784_/D _2464_/A _2465_/B VPWR VGND sg13cmos5l_and2_1
X_2395_ _2396_/A _3773_/Q _2395_/B VPWR VGND sg13cmos5l_xor2_1
XFILLER_3_60 VPWR VGND sg13cmos5l_decap_8
XFILLER_3_1011 VPWR VGND sg13cmos5l_decap_8
XFILLER_28_218 VPWR VGND sg13cmos5l_decap_8
XFILLER_49_590 VPWR VGND sg13cmos5l_decap_8
XFILLER_24_402 VPWR VGND sg13cmos5l_decap_8
X_3016_ _3016_/Y _3625_/Q _3016_/B VPWR VGND sg13cmos5l_nand2b_1
XFILLER_36_262 VPWR VGND sg13cmos5l_decap_4
XFILLER_12_608 VPWR VGND sg13cmos5l_fill_2
XFILLER_19_1019 VPWR VGND sg13cmos5l_decap_8
XFILLER_11_118 VPWR VGND sg13cmos5l_fill_1
XFILLER_32_490 VPWR VGND sg13cmos5l_decap_8
XFILLER_4_818 VPWR VGND sg13cmos5l_decap_8
XFILLER_3_306 VPWR VGND sg13cmos5l_fill_1
X_3729__412 _3729_/RESET_B VPWR VGND sg13cmos5l_tiehi
XFILLER_0_7 VPWR VGND sg13cmos5l_decap_8
XFILLER_47_538 VPWR VGND sg13cmos5l_fill_2
XFILLER_47_527 VPWR VGND sg13cmos5l_decap_8
XFILLER_28_730 VPWR VGND sg13cmos5l_decap_8
XFILLER_28_774 VPWR VGND sg13cmos5l_decap_8
XFILLER_27_284 VPWR VGND sg13cmos5l_decap_4
XFILLER_43_766 VPWR VGND sg13cmos5l_fill_1
XFILLER_42_265 VPWR VGND sg13cmos5l_decap_8
Xclkbuf_leaf_22_clk clkload5/A clkbuf_leaf_3_clk/A VPWR VGND sg13cmos5l_buf_8
XFILLER_7_656 VPWR VGND sg13cmos5l_fill_2
XFILLER_7_645 VPWR VGND sg13cmos5l_decap_8
XFILLER_6_111 VPWR VGND sg13cmos5l_fill_1
XFILLER_10_162 VPWR VGND sg13cmos5l_decap_8
XFILLER_10_173 VPWR VGND sg13cmos5l_fill_2
XFILLER_10_195 VPWR VGND sg13cmos5l_decap_8
XFILLER_6_188 VPWR VGND sg13cmos5l_decap_8
XFILLER_12_91 VPWR VGND sg13cmos5l_fill_1
XFILLER_2_361 VPWR VGND sg13cmos5l_decap_8
X_2180_ _2180_/Y _2465_/A _2177_/Y _2179_/Y _2176_/Y VPWR VGND sg13cmos5l_a22oi_1
XFILLER_26_6 VPWR VGND sg13cmos5l_fill_1
XFILLER_38_505 VPWR VGND sg13cmos5l_decap_8
XFILLER_18_240 VPWR VGND sg13cmos5l_fill_1
X_3602__251 _3602_/RESET_B VPWR VGND sg13cmos5l_tiehi
XFILLER_33_210 VPWR VGND sg13cmos5l_fill_2
XFILLER_34_733 VPWR VGND sg13cmos5l_decap_8
XFILLER_34_744 VPWR VGND sg13cmos5l_fill_2
XFILLER_21_416 VPWR VGND sg13cmos5l_fill_2
XFILLER_21_427 VPWR VGND sg13cmos5l_fill_1
XFILLER_34_788 VPWR VGND sg13cmos5l_decap_8
X_1964_ _3031_/A _1964_/A VPWR VGND sg13cmos5l_inv_1
XFILLER_14_490 VPWR VGND sg13cmos5l_decap_8
Xclkbuf_leaf_13_clk _3698_/CLK clkload0/A VPWR VGND sg13cmos5l_buf_8
X_3703_ _3703_/Q _3728_/CLK _3703_/D _3703_/RESET_B VPWR VGND sg13cmos5l_dfrbpq_1
XFILLER_30_961 VPWR VGND sg13cmos5l_decap_8
X_3634_ _3634_/Q _3664_/CLK _3634_/D _3634_/RESET_B VPWR VGND sg13cmos5l_dfrbpq_1
X_3565_ _3565_/Q clkload5/A _3565_/D _3565_/RESET_B VPWR VGND sg13cmos5l_dfrbpq_1
X_3496_ _3496_/Q clkload7/A _3496_/D _3496_/RESET_B VPWR VGND sg13cmos5l_dfrbpq_1
X_2516_ _2521_/B _2504_/X _2510_/Y _2514_/X VPWR VGND sg13cmos5l_a21o_1
X_2447_ _2447_/Y _2434_/C _2451_/S _2465_/B VPWR VGND sg13cmos5l_o21ai_1
XFILLER_25_1001 VPWR VGND sg13cmos5l_decap_8
X_2378_ _2379_/B _3768_/Q _3769_/Q VPWR VGND sg13cmos5l_nand2_1
XFILLER_44_519 VPWR VGND sg13cmos5l_decap_8
XFILLER_37_593 VPWR VGND sg13cmos5l_fill_1
XFILLER_17_69 VPWR VGND sg13cmos5l_fill_2
X_3718__102 _3718_/D VPWR VGND sg13cmos5l_tielo
XFILLER_25_766 VPWR VGND sg13cmos5l_fill_2
XFILLER_40_736 VPWR VGND sg13cmos5l_decap_8
XFILLER_12_405 VPWR VGND sg13cmos5l_fill_2
XFILLER_33_57 VPWR VGND sg13cmos5l_fill_1
XFILLER_32_1016 VPWR VGND sg13cmos5l_decap_8
XFILLER_32_1027 VPWR VGND sg13cmos5l_fill_2
XFILLER_33_79 VPWR VGND sg13cmos5l_decap_4
XFILLER_21_994 VPWR VGND sg13cmos5l_decap_8
X_3653__182 _3653_/RESET_B VPWR VGND sg13cmos5l_tiehi
XFILLER_0_832 VPWR VGND sg13cmos5l_decap_8
XFILLER_48_803 VPWR VGND sg13cmos5l_decap_8
XFILLER_47_324 VPWR VGND sg13cmos5l_fill_1
XFILLER_28_582 VPWR VGND sg13cmos5l_decap_4
XFILLER_43_574 VPWR VGND sg13cmos5l_decap_4
XFILLER_16_799 VPWR VGND sg13cmos5l_decap_8
XFILLER_30_213 VPWR VGND sg13cmos5l_decap_8
XFILLER_31_747 VPWR VGND sg13cmos5l_decap_8
XFILLER_31_758 VPWR VGND sg13cmos5l_decap_8
XFILLER_12_961 VPWR VGND sg13cmos5l_decap_8
XFILLER_8_954 VPWR VGND sg13cmos5l_decap_8
X_3491__392 _3491_/RESET_B VPWR VGND sg13cmos5l_tiehi
XFILLER_7_453 VPWR VGND sg13cmos5l_decap_8
XFILLER_7_486 VPWR VGND sg13cmos5l_decap_8
X_3712__290 _3712_/RESET_B VPWR VGND sg13cmos5l_tiehi
X_3350_ _3696_/D _3350_/A _3410_/A VPWR VGND sg13cmos5l_nor2_1
X_2301_ _3755_/D _2303_/A _2301_/B VPWR VGND sg13cmos5l_and2_1
X_3563__305 _3563_/RESET_B VPWR VGND sg13cmos5l_tiehi
XFILLER_31_4 VPWR VGND sg13cmos5l_decap_4
X_3281_ _3281_/Y _3280_/B _3273_/B _3109_/A VPWR VGND sg13cmos5l_a21oi_1
XFILLER_39_836 VPWR VGND sg13cmos5l_decap_8
X_2232_ _2311_/B _2232_/A _2232_/B _2232_/C VPWR VGND sg13cmos5l_nand3_1
Xclkbuf_leaf_2_clk _3806_/CLK clkbuf_leaf_2_clk/A VPWR VGND sg13cmos5l_buf_8
XFILLER_39_869 VPWR VGND sg13cmos5l_decap_8
X_2163_ _2164_/B _2087_/A _2084_/Y _2160_/Y _2162_/Y VPWR VGND sg13cmos5l_a22oi_1
XFILLER_38_379 VPWR VGND sg13cmos5l_decap_8
XFILLER_26_519 VPWR VGND sg13cmos5l_decap_8
XFILLER_47_891 VPWR VGND sg13cmos5l_decap_8
XFILLER_0_1014 VPWR VGND sg13cmos5l_decap_8
X_2094_ _2094_/Y _3678_/Q _3677_/Q VPWR VGND sg13cmos5l_xnor2_1
XFILLER_22_736 VPWR VGND sg13cmos5l_fill_1
XFILLER_22_747 VPWR VGND sg13cmos5l_decap_8
X_2996_ _2996_/Y _3189_/A _3598_/Q _3597_/Q _3188_/A _2995_/Y VPWR VGND sg13cmos5l_a221oi_1
X_1947_ _1947_/Y _2455_/B VPWR VGND sg13cmos5l_inv_1
XFILLER_9_92 VPWR VGND sg13cmos5l_decap_8
XFILLER_30_791 VPWR VGND sg13cmos5l_decap_8
X_3617_ _3617_/Q _3666_/CLK _3617_/D _3617_/RESET_B VPWR VGND sg13cmos5l_dfrbpq_1
X_3548_ _3548_/Q clkload1/A _3548_/D _3548_/RESET_B VPWR VGND sg13cmos5l_dfrbpq_1
XFILLER_0_106 VPWR VGND sg13cmos5l_decap_8
X_3479_ _3479_/Q clkload7/A _3479_/D _3479_/RESET_B VPWR VGND sg13cmos5l_dfrbpq_1
XFILLER_28_35 VPWR VGND sg13cmos5l_decap_8
XFILLER_38_880 VPWR VGND sg13cmos5l_fill_2
XFILLER_44_45 VPWR VGND sg13cmos5l_decap_4
XFILLER_25_574 VPWR VGND sg13cmos5l_decap_8
XFILLER_44_78 VPWR VGND sg13cmos5l_decap_4
XFILLER_13_736 VPWR VGND sg13cmos5l_decap_4
XFILLER_13_758 VPWR VGND sg13cmos5l_decap_4
XFILLER_40_577 VPWR VGND sg13cmos5l_decap_8
XFILLER_5_957 VPWR VGND sg13cmos5l_decap_8
XFILLER_4_467 VPWR VGND sg13cmos5l_fill_2
XFILLER_4_456 VPWR VGND sg13cmos5l_decap_8
XFILLER_0_651 VPWR VGND sg13cmos5l_decap_8
XFILLER_47_165 VPWR VGND sg13cmos5l_fill_2
XFILLER_44_861 VPWR VGND sg13cmos5l_decap_8
XFILLER_16_530 VPWR VGND sg13cmos5l_decap_8
XFILLER_16_563 VPWR VGND sg13cmos5l_decap_8
X_2850_ _2939_/A _3018_/B _3459_/A VPWR VGND sg13cmos5l_nand2b_1
XFILLER_15_1011 VPWR VGND sg13cmos5l_decap_8
XFILLER_31_577 VPWR VGND sg13cmos5l_decap_8
X_2781_ _2781_/Y _2810_/A1 _1990_/Y _2810_/B1 VPWR VGND sg13cmos5l_a21oi_1
XFILLER_8_773 VPWR VGND sg13cmos5l_decap_8
XFILLER_8_795 VPWR VGND sg13cmos5l_fill_2
X_3402_ _3402_/Y _3378_/A _3375_/Y _3401_/Y VPWR VGND sg13cmos5l_a21oi_1
X_3333_ _3335_/A _3333_/A _3327_/X VPWR VGND sg13cmos5l_nor2b_1
XFILLER_39_600 VPWR VGND sg13cmos5l_decap_4
X_3264_ _3673_/D _3410_/A _3264_/B VPWR VGND sg13cmos5l_nor2_1
X_2215_ _2217_/C _3710_/Q _3709_/Q _3711_/Q VPWR VGND sg13cmos5l_o21ai_1
X_3643__192 _3643_/RESET_B VPWR VGND sg13cmos5l_tiehi
X_3195_ _3214_/S _3191_/Y _3193_/Y _3194_/Y VPWR VGND sg13cmos5l_o21ai_1
XFILLER_27_806 VPWR VGND sg13cmos5l_decap_8
X_2146_ _2146_/Y _3416_/B _2146_/B VPWR VGND sg13cmos5l_nand2b_1
XFILLER_27_839 VPWR VGND sg13cmos5l_fill_1
X_2077_ _2082_/A _3728_/Q _2151_/B VPWR VGND sg13cmos5l_nand2_1
XFILLER_22_544 VPWR VGND sg13cmos5l_decap_4
X_3719__252 _3719_/RESET_B VPWR VGND sg13cmos5l_tiehi
XFILLER_10_717 VPWR VGND sg13cmos5l_decap_8
X_3574__286 _3574_/RESET_B VPWR VGND sg13cmos5l_tiehi
X_2979_ _2979_/X _2979_/A _2979_/B _2979_/C VPWR VGND sg13cmos5l_and3_1
X_3650__185 _3650_/RESET_B VPWR VGND sg13cmos5l_tiehi
XFILLER_2_905 VPWR VGND sg13cmos5l_decap_8
Xhold740 _2926_/C _2925_/Y VPWR VGND sg13cmos5l_dlygate4sd3_1
Xhold762 _2928_/A _3608_/Q VPWR VGND sg13cmos5l_dlygate4sd3_1
Xhold751 _3015_/B _3014_/X VPWR VGND sg13cmos5l_dlygate4sd3_1
Xhold773 _3045_/A _3633_/Q VPWR VGND sg13cmos5l_dlygate4sd3_1
Xhold784 _2918_/A _3609_/Q VPWR VGND sg13cmos5l_dlygate4sd3_1
Xhold795 _3396_/A _3697_/Q VPWR VGND sg13cmos5l_dlygate4sd3_1
XFILLER_49_419 VPWR VGND sg13cmos5l_fill_2
XFILLER_7_1009 VPWR VGND sg13cmos5l_decap_8
XFILLER_18_817 VPWR VGND sg13cmos5l_fill_2
XFILLER_29_132 VPWR VGND sg13cmos5l_decap_4
XFILLER_44_102 VPWR VGND sg13cmos5l_decap_8
XFILLER_18_828 VPWR VGND sg13cmos5l_fill_1
X_3696__322 _3696_/RESET_B VPWR VGND sg13cmos5l_tiehi
XFILLER_26_850 VPWR VGND sg13cmos5l_decap_8
XFILLER_25_371 VPWR VGND sg13cmos5l_decap_8
XFILLER_41_886 VPWR VGND sg13cmos5l_decap_8
XFILLER_40_374 VPWR VGND sg13cmos5l_decap_8
XFILLER_13_599 VPWR VGND sg13cmos5l_fill_1
XFILLER_5_710 VPWR VGND sg13cmos5l_fill_1
XFILLER_5_776 VPWR VGND sg13cmos5l_decap_4
XFILLER_45_1015 VPWR VGND sg13cmos5l_decap_8
XFILLER_0_470 VPWR VGND sg13cmos5l_decap_8
XFILLER_49_964 VPWR VGND sg13cmos5l_decap_8
X_2000_ _2000_/Y _3714_/Q VPWR VGND sg13cmos5l_inv_1
XFILLER_17_850 VPWR VGND sg13cmos5l_decap_8
XFILLER_23_319 VPWR VGND sg13cmos5l_fill_1
X_2902_ _2902_/Y _3601_/Q _2907_/A2 _3452_/A VPWR VGND sg13cmos5l_o21ai_1
X_2833_ _2833_/Y _2683_/B _2831_/X _2832_/X _2790_/Y _3570_/Q VPWR VGND sg13cmos5l_a221oi_1
X_2764_ _2768_/B _2876_/A _2911_/A VPWR VGND sg13cmos5l_nor2b_1
X_2695_ _2695_/Y _2693_/Y _2694_/Y _3801_/D VPWR VGND sg13cmos5l_a21oi_1
X_3316_ _3330_/A _3655_/Q _3314_/Y _3315_/Y VPWR VGND sg13cmos5l_o21ai_1
XFILLER_39_441 VPWR VGND sg13cmos5l_decap_8
X_3247_ _3247_/Y _2098_/Y _3265_/B _3244_/Y _3246_/X VPWR VGND sg13cmos5l_a22oi_1
XFILLER_39_496 VPWR VGND sg13cmos5l_decap_8
X_3178_ _3178_/Y _3657_/Q _3181_/A2 _3459_/A VPWR VGND sg13cmos5l_o21ai_1
X_2129_ _3413_/B _2132_/C _2132_/B VPWR VGND sg13cmos5l_and2_1
XFILLER_26_124 VPWR VGND sg13cmos5l_fill_1
XFILLER_27_647 VPWR VGND sg13cmos5l_decap_8
XFILLER_27_658 VPWR VGND sg13cmos5l_fill_2
XFILLER_41_116 VPWR VGND sg13cmos5l_fill_1
XFILLER_25_69 VPWR VGND sg13cmos5l_decap_8
XFILLER_41_35 VPWR VGND sg13cmos5l_decap_8
XFILLER_6_518 VPWR VGND sg13cmos5l_fill_2
XFILLER_6_507 VPWR VGND sg13cmos5l_decap_8
XFILLER_22_396 VPWR VGND sg13cmos5l_decap_8
XFILLER_1_201 VPWR VGND sg13cmos5l_decap_4
Xhold570 hold570/X _3493_/Q VPWR VGND sg13cmos5l_dlygate4sd3_1
XFILLER_9_4 VPWR VGND sg13cmos5l_decap_8
Xhold581 hold581/X _3537_/Q VPWR VGND sg13cmos5l_dlygate4sd3_1
XFILLER_49_205 VPWR VGND sg13cmos5l_fill_1
Xhold592 hold592/X _3527_/Q VPWR VGND sg13cmos5l_dlygate4sd3_1
XFILLER_2_779 VPWR VGND sg13cmos5l_decap_8
XFILLER_1_245 VPWR VGND sg13cmos5l_decap_4
XFILLER_49_238 VPWR VGND sg13cmos5l_decap_4
XFILLER_1_278 VPWR VGND sg13cmos5l_fill_2
XFILLER_46_923 VPWR VGND sg13cmos5l_decap_8
XFILLER_18_625 VPWR VGND sg13cmos5l_fill_2
XFILLER_45_488 VPWR VGND sg13cmos5l_decap_8
XFILLER_17_179 VPWR VGND sg13cmos5l_decap_8
X_3737__160 _3737_/RESET_B VPWR VGND sg13cmos5l_tiehi
XFILLER_13_330 VPWR VGND sg13cmos5l_decap_8
XFILLER_9_312 VPWR VGND sg13cmos5l_decap_4
XFILLER_14_886 VPWR VGND sg13cmos5l_fill_1
XFILLER_12_1003 VPWR VGND sg13cmos5l_decap_8
X_2480_ _2480_/Y _3787_/Q _2545_/B VPWR VGND sg13cmos5l_nand2_1
X_3629__216 _3629_/RESET_B VPWR VGND sg13cmos5l_tiehi
X_3101_ _3104_/A _3111_/B _3101_/B _3101_/C VPWR VGND sg13cmos5l_nand3b_1
X_3744__153 _3744_/RESET_B VPWR VGND sg13cmos5l_tiehi
XFILLER_49_761 VPWR VGND sg13cmos5l_decap_8
XFILLER_37_912 VPWR VGND sg13cmos5l_decap_8
X_3032_ _3032_/Y _3629_/Q _3606_/Q VPWR VGND sg13cmos5l_nand2_1
X_3640__195 _3640_/RESET_B VPWR VGND sg13cmos5l_tiehi
XFILLER_37_989 VPWR VGND sg13cmos5l_decap_8
XFILLER_36_455 VPWR VGND sg13cmos5l_fill_2
XFILLER_23_127 VPWR VGND sg13cmos5l_decap_8
XFILLER_20_823 VPWR VGND sg13cmos5l_decap_8
X_2816_ _2816_/Y _2811_/Y _2815_/Y _3569_/Q VPWR VGND sg13cmos5l_a21oi_1
X_3716__277 _3716_/RESET_B VPWR VGND sg13cmos5l_tiehi
X_3796_ _3796_/Q _3806_/CLK _3796_/D _3796_/RESET_B VPWR VGND sg13cmos5l_dfrbpq_1
X_3571__289 _3571_/RESET_B VPWR VGND sg13cmos5l_tiehi
X_2747_ _2751_/B _2582_/A _2578_/C _2746_/Y VPWR VGND sg13cmos5l_a21oi_1
X_2678_ _3542_/D input11/X hold547/X _2681_/S VPWR VGND sg13cmos5l_mux2_1
XFILLER_46_208 VPWR VGND sg13cmos5l_decap_4
XFILLER_39_271 VPWR VGND sg13cmos5l_decap_4
XFILLER_28_934 VPWR VGND sg13cmos5l_decap_8
XFILLER_27_444 VPWR VGND sg13cmos5l_fill_1
XFILLER_43_948 VPWR VGND sg13cmos5l_decap_8
XFILLER_11_823 VPWR VGND sg13cmos5l_decap_8
XFILLER_23_661 VPWR VGND sg13cmos5l_decap_8
XFILLER_23_672 VPWR VGND sg13cmos5l_fill_2
XFILLER_35_1014 VPWR VGND sg13cmos5l_decap_8
XFILLER_11_867 VPWR VGND sg13cmos5l_decap_8
XFILLER_22_171 VPWR VGND sg13cmos5l_decap_8
XFILLER_22_182 VPWR VGND sg13cmos5l_fill_1
XFILLER_7_827 VPWR VGND sg13cmos5l_decap_8
XFILLER_6_348 VPWR VGND sg13cmos5l_decap_8
XFILLER_42_1007 VPWR VGND sg13cmos5l_decap_8
XFILLER_2_587 VPWR VGND sg13cmos5l_decap_8
XFILLER_19_956 VPWR VGND sg13cmos5l_decap_8
XFILLER_45_241 VPWR VGND sg13cmos5l_decap_8
XFILLER_18_455 VPWR VGND sg13cmos5l_decap_8
XFILLER_34_915 VPWR VGND sg13cmos5l_decap_4
XFILLER_46_797 VPWR VGND sg13cmos5l_decap_8
X_1980_ _3350_/A _3160_/C VPWR VGND sg13cmos5l_inv_1
XFILLER_13_171 VPWR VGND sg13cmos5l_decap_4
XFILLER_9_164 VPWR VGND sg13cmos5l_fill_2
X_3650_ _3650_/Q _3698_/CLK _3650_/D _3650_/RESET_B VPWR VGND sg13cmos5l_dfrbpq_1
XFILLER_9_186 VPWR VGND sg13cmos5l_fill_2
XFILLER_9_197 VPWR VGND sg13cmos5l_decap_8
X_2601_ _3480_/D hold576/X input8/X _2606_/S VPWR VGND sg13cmos5l_mux2_1
X_3581_ _3581_/Q _3629_/CLK _3581_/D _3581_/RESET_B VPWR VGND sg13cmos5l_dfrbpq_1
X_2532_ _2557_/A _2473_/Y _2481_/Y _2531_/Y VPWR VGND sg13cmos5l_o21ai_1
X_2463_ _2463_/Y _1955_/Y _2907_/A2 _2462_/Y VPWR VGND sg13cmos5l_a21oi_1
X_2394_ _2394_/Y _2388_/X _2401_/B _2393_/Y VPWR VGND sg13cmos5l_o21ai_1
XFILLER_3_83 VPWR VGND sg13cmos5l_decap_8
X_3015_ _3623_/D _3015_/A _3015_/B VPWR VGND sg13cmos5l_nor2_1
XFILLER_37_764 VPWR VGND sg13cmos5l_fill_2
XFILLER_25_959 VPWR VGND sg13cmos5l_decap_8
XFILLER_33_992 VPWR VGND sg13cmos5l_decap_8
X_3779_ _3779_/Q clkload5/A _3779_/D _3779_/RESET_B VPWR VGND sg13cmos5l_dfrbpq_1
XFILLER_19_208 VPWR VGND sg13cmos5l_decap_8
XFILLER_43_701 VPWR VGND sg13cmos5l_fill_2
XFILLER_28_753 VPWR VGND sg13cmos5l_decap_8
XFILLER_28_786 VPWR VGND sg13cmos5l_decap_8
XFILLER_15_436 VPWR VGND sg13cmos5l_fill_2
XFILLER_16_959 VPWR VGND sg13cmos5l_decap_8
XFILLER_27_263 VPWR VGND sg13cmos5l_decap_8
XFILLER_28_797 VPWR VGND sg13cmos5l_fill_1
XFILLER_11_620 VPWR VGND sg13cmos5l_fill_1
XFILLER_6_145 VPWR VGND sg13cmos5l_decap_8
XFILLER_3_885 VPWR VGND sg13cmos5l_decap_8
XFILLER_2_384 VPWR VGND sg13cmos5l_fill_1
X_3741__156 _3741_/RESET_B VPWR VGND sg13cmos5l_tiehi
XFILLER_19_6 VPWR VGND sg13cmos5l_fill_1
XFILLER_19_753 VPWR VGND sg13cmos5l_decap_8
XFILLER_19_775 VPWR VGND sg13cmos5l_fill_2
XFILLER_18_263 VPWR VGND sg13cmos5l_decap_4
X_1963_ _3187_/A _1963_/A VPWR VGND sg13cmos5l_inv_1
XFILLER_30_940 VPWR VGND sg13cmos5l_decap_8
X_3702_ _3702_/Q _3731_/CLK _3702_/D _3702_/RESET_B VPWR VGND sg13cmos5l_dfrbpq_1
X_3633_ _3633_/Q _3664_/CLK _3633_/D _3633_/RESET_B VPWR VGND sg13cmos5l_dfrbpq_1
X_3564_ _3564_/Q clkload5/A _3564_/D _3564_/RESET_B VPWR VGND sg13cmos5l_dfrbpq_1
X_2515_ _2527_/B _2504_/X _2510_/Y _2514_/X VPWR VGND sg13cmos5l_a21oi_1
X_3495_ _3495_/Q _3809_/CLK _3495_/D _3495_/RESET_B VPWR VGND sg13cmos5l_dfrbpq_1
X_2446_ _2451_/S _2446_/A _2446_/B VPWR VGND sg13cmos5l_nor2_1
X_2377_ _2377_/Y _3789_/Q _3768_/Q VPWR VGND sg13cmos5l_nand2_1
X_3798__411 _3798_/RESET_B VPWR VGND sg13cmos5l_tiehi
XFILLER_37_550 VPWR VGND sg13cmos5l_decap_4
XFILLER_37_572 VPWR VGND sg13cmos5l_decap_8
XFILLER_25_723 VPWR VGND sg13cmos5l_decap_4
XFILLER_13_918 VPWR VGND sg13cmos5l_decap_8
XFILLER_21_973 VPWR VGND sg13cmos5l_decap_8
XFILLER_20_483 VPWR VGND sg13cmos5l_decap_8
XFILLER_3_104 VPWR VGND sg13cmos5l_decap_4
XFILLER_3_137 VPWR VGND sg13cmos5l_decap_8
XFILLER_0_811 VPWR VGND sg13cmos5l_decap_8
XFILLER_0_888 VPWR VGND sg13cmos5l_decap_8
XFILLER_48_859 VPWR VGND sg13cmos5l_decap_8
X_3621__116 _3621_/D VPWR VGND sg13cmos5l_tielo
XFILLER_47_369 VPWR VGND sg13cmos5l_decap_8
XFILLER_16_723 VPWR VGND sg13cmos5l_fill_1
XFILLER_16_756 VPWR VGND sg13cmos5l_decap_8
XFILLER_16_767 VPWR VGND sg13cmos5l_fill_2
X_3632__212 _3632_/RESET_B VPWR VGND sg13cmos5l_tiehi
XFILLER_8_933 VPWR VGND sg13cmos5l_decap_8
XFILLER_7_432 VPWR VGND sg13cmos5l_decap_8
XFILLER_7_410 VPWR VGND sg13cmos5l_decap_8
XFILLER_11_494 VPWR VGND sg13cmos5l_fill_2
XFILLER_48_1013 VPWR VGND sg13cmos5l_decap_8
XFILLER_3_682 VPWR VGND sg13cmos5l_decap_8
X_2300_ _2300_/Y _1924_/Y _3458_/A2 _2299_/Y VPWR VGND sg13cmos5l_a21oi_1
X_3280_ _3283_/B _3649_/Q _3280_/B VPWR VGND sg13cmos5l_xnor2_1
X_2231_ _2231_/X _2231_/A _2231_/B VPWR VGND sg13cmos5l_and2_1
XFILLER_2_181 VPWR VGND sg13cmos5l_decap_8
XFILLER_24_4 VPWR VGND sg13cmos5l_decap_8
X_2162_ _2162_/Y _3467_/A _3467_/B _2161_/Y VPWR VGND sg13cmos5l_a21oi_1
X_2093_ _2150_/A _2087_/A _2087_/B hold743/X VPWR VGND sg13cmos5l_o21ai_1
XFILLER_47_870 VPWR VGND sg13cmos5l_decap_8
XFILLER_0_84 VPWR VGND sg13cmos5l_decap_8
XFILLER_21_203 VPWR VGND sg13cmos5l_decap_8
XFILLER_34_586 VPWR VGND sg13cmos5l_fill_2
X_2995_ _2995_/Y _3638_/Q _3000_/B _3004_/B _3637_/Q VPWR VGND sg13cmos5l_a22oi_1
XFILLER_9_71 VPWR VGND sg13cmos5l_decap_8
X_1946_ _2455_/A _1946_/A VPWR VGND sg13cmos5l_inv_1
X_3616_ _3616_/Q _3665_/CLK _3616_/D _3616_/RESET_B VPWR VGND sg13cmos5l_dfrbpq_1
X_3547_ _3547_/Q clkload2/A _3547_/D _3547_/RESET_B VPWR VGND sg13cmos5l_dfrbpq_1
XFILLER_0_129 VPWR VGND sg13cmos5l_fill_1
X_3478_ _3478_/Q _3809_/CLK _3478_/D _3478_/RESET_B VPWR VGND sg13cmos5l_dfrbpq_1
X_2429_ _2430_/B _2268_/Y _2428_/Y _2439_/B VPWR VGND sg13cmos5l_mux2_1
X_3794__127 _3794_/D VPWR VGND sg13cmos5l_tielo
XFILLER_44_24 VPWR VGND sg13cmos5l_decap_8
XFILLER_25_531 VPWR VGND sg13cmos5l_fill_1
XFILLER_25_564 VPWR VGND sg13cmos5l_decap_8
XFILLER_40_523 VPWR VGND sg13cmos5l_decap_8
XFILLER_9_708 VPWR VGND sg13cmos5l_decap_4
XFILLER_40_556 VPWR VGND sg13cmos5l_decap_8
XFILLER_21_792 VPWR VGND sg13cmos5l_decap_4
XFILLER_5_936 VPWR VGND sg13cmos5l_decap_8
XFILLER_4_435 VPWR VGND sg13cmos5l_decap_8
XFILLER_48_601 VPWR VGND sg13cmos5l_decap_8
XFILLER_0_696 VPWR VGND sg13cmos5l_decap_4
XFILLER_18_80 VPWR VGND sg13cmos5l_fill_2
XFILLER_44_840 VPWR VGND sg13cmos5l_decap_8
XFILLER_16_542 VPWR VGND sg13cmos5l_decap_8
XFILLER_43_383 VPWR VGND sg13cmos5l_decap_8
XFILLER_16_597 VPWR VGND sg13cmos5l_decap_8
XFILLER_31_523 VPWR VGND sg13cmos5l_fill_2
XFILLER_31_589 VPWR VGND sg13cmos5l_fill_2
X_2780_ _2780_/X _3537_/Q _3520_/Q _3503_/Q _3486_/Q _2810_/A1 _2810_/B1 VPWR VGND
+ sg13cmos5l_mux4_1
XFILLER_7_295 VPWR VGND sg13cmos5l_decap_4
X_3401_ _3401_/Y _3401_/A _3401_/B VPWR VGND sg13cmos5l_nor2_1
X_3332_ _3332_/Y _3332_/A _3332_/B VPWR VGND sg13cmos5l_nor2_1
X_3263_ _3264_/B _3355_/A _3355_/B VPWR VGND sg13cmos5l_nand2_1
X_3194_ _3194_/Y _3112_/Y _3141_/Y _3116_/Y VPWR VGND sg13cmos5l_a21oi_1
X_2214_ _2214_/Y _2214_/A _2214_/B VPWR VGND sg13cmos5l_nor2_1
XFILLER_22_1016 VPWR VGND sg13cmos5l_decap_8
XFILLER_39_656 VPWR VGND sg13cmos5l_decap_4
X_2145_ _2145_/Y _2132_/Y _2137_/Y _3419_/B _3415_/B _2144_/Y VPWR VGND sg13cmos5l_a221oi_1
XFILLER_22_1027 VPWR VGND sg13cmos5l_fill_2
XFILLER_38_199 VPWR VGND sg13cmos5l_decap_4
X_2076_ _2087_/A _2076_/A _2151_/B VPWR VGND sg13cmos5l_nor2_1
XFILLER_34_361 VPWR VGND sg13cmos5l_fill_2
X_2978_ _2987_/A _2978_/A _2979_/B VPWR VGND sg13cmos5l_xnor2_1
X_1929_ _1929_/Y _1929_/A VPWR VGND sg13cmos5l_inv_1
Xhold730 _1971_/A _3735_/Q VPWR VGND sg13cmos5l_dlygate4sd3_1
XFILLER_30_59 VPWR VGND sg13cmos5l_decap_8
Xhold741 _2934_/A _2926_/Y VPWR VGND sg13cmos5l_dlygate4sd3_1
Xhold763 _2929_/B _2928_/Y VPWR VGND sg13cmos5l_dlygate4sd3_1
Xhold752 _1974_/A _3765_/Q VPWR VGND sg13cmos5l_dlygate4sd3_1
XFILLER_39_24 VPWR VGND sg13cmos5l_decap_8
Xhold774 hold774/X _3059_/A VPWR VGND sg13cmos5l_dlygate4sd3_1
Xhold785 _2178_/B _3736_/Q VPWR VGND sg13cmos5l_dlygate4sd3_1
Xhold796 _3203_/C _3664_/Q VPWR VGND sg13cmos5l_dlygate4sd3_1
XFILLER_45_637 VPWR VGND sg13cmos5l_fill_2
XFILLER_17_317 VPWR VGND sg13cmos5l_fill_1
XFILLER_44_147 VPWR VGND sg13cmos5l_fill_2
XFILLER_38_1012 VPWR VGND sg13cmos5l_decap_8
XFILLER_25_350 VPWR VGND sg13cmos5l_fill_2
XFILLER_41_843 VPWR VGND sg13cmos5l_decap_8
XFILLER_25_394 VPWR VGND sg13cmos5l_decap_8
XFILLER_26_895 VPWR VGND sg13cmos5l_fill_2
XFILLER_13_545 VPWR VGND sg13cmos5l_decap_8
XFILLER_13_567 VPWR VGND sg13cmos5l_decap_8
XFILLER_9_538 VPWR VGND sg13cmos5l_decap_4
XFILLER_13_578 VPWR VGND sg13cmos5l_fill_1
XFILLER_5_733 VPWR VGND sg13cmos5l_decap_8
XFILLER_4_221 VPWR VGND sg13cmos5l_fill_1
XFILLER_4_210 VPWR VGND sg13cmos5l_decap_8
XFILLER_4_276 VPWR VGND sg13cmos5l_decap_8
XFILLER_49_943 VPWR VGND sg13cmos5l_decap_8
XFILLER_1_983 VPWR VGND sg13cmos5l_decap_8
XFILLER_36_604 VPWR VGND sg13cmos5l_fill_1
XFILLER_36_659 VPWR VGND sg13cmos5l_decap_8
XFILLER_17_873 VPWR VGND sg13cmos5l_fill_1
X_2901_ _3600_/D _3452_/A _2901_/B VPWR VGND sg13cmos5l_and2_1
XFILLER_31_331 VPWR VGND sg13cmos5l_decap_8
X_2832_ _2832_/X _3534_/Q _3517_/Q _3500_/Q _3483_/Q _2832_/S0 _2832_/S1 VPWR VGND
+ sg13cmos5l_mux4_1
XFILLER_31_364 VPWR VGND sg13cmos5l_decap_4
XFILLER_31_386 VPWR VGND sg13cmos5l_decap_4
XFILLER_32_898 VPWR VGND sg13cmos5l_decap_8
X_2763_ _2766_/A _2912_/A _2912_/B _2759_/Y VPWR VGND sg13cmos5l_a21oi_1
X_2694_ _2694_/Y _2692_/A _3548_/Q _2698_/B _3567_/Q VPWR VGND sg13cmos5l_a22oi_1
XFILLER_6_72 VPWR VGND sg13cmos5l_decap_4
X_3315_ _3315_/Y _3463_/A _3466_/A _3320_/C VPWR VGND sg13cmos5l_nand3_1
X_3246_ _3246_/X _3700_/Q _3243_/Y _3260_/B VPWR VGND sg13cmos5l_a21o_1
X_3177_ _3656_/D _3459_/A _3177_/B VPWR VGND sg13cmos5l_and2_1
XFILLER_27_615 VPWR VGND sg13cmos5l_decap_4
X_2128_ _2132_/B _2135_/A _2135_/B _1972_/Y VPWR VGND sg13cmos5l_o21ai_1
XFILLER_26_114 VPWR VGND sg13cmos5l_fill_1
X_2059_ _2063_/B _3732_/Q _3733_/Q _3734_/Q VPWR VGND sg13cmos5l_nor3_1
XFILLER_26_169 VPWR VGND sg13cmos5l_decap_4
XFILLER_41_128 VPWR VGND sg13cmos5l_fill_1
XFILLER_25_59 VPWR VGND sg13cmos5l_fill_1
XFILLER_35_681 VPWR VGND sg13cmos5l_decap_8
XFILLER_22_364 VPWR VGND sg13cmos5l_fill_2
XFILLER_10_548 VPWR VGND sg13cmos5l_decap_4
Xhold571 _3493_/D _2616_/X VPWR VGND sg13cmos5l_dlygate4sd3_1
XFILLER_2_758 VPWR VGND sg13cmos5l_decap_8
XFILLER_1_224 VPWR VGND sg13cmos5l_decap_4
Xhold560 hold560/X _3495_/Q VPWR VGND sg13cmos5l_dlygate4sd3_1
Xhold582 hold582/X _3536_/Q VPWR VGND sg13cmos5l_dlygate4sd3_1
Xhold593 _3030_/A _3612_/Q VPWR VGND sg13cmos5l_dlygate4sd3_1
X_3804__207 _3804_/RESET_B VPWR VGND sg13cmos5l_tiehi
XFILLER_49_217 VPWR VGND sg13cmos5l_decap_8
XFILLER_46_902 VPWR VGND sg13cmos5l_decap_8
XFILLER_18_604 VPWR VGND sg13cmos5l_decap_8
XFILLER_46_979 VPWR VGND sg13cmos5l_decap_8
XFILLER_17_158 VPWR VGND sg13cmos5l_decap_8
XFILLER_14_832 VPWR VGND sg13cmos5l_decap_4
XFILLER_26_692 VPWR VGND sg13cmos5l_decap_8
XFILLER_41_684 VPWR VGND sg13cmos5l_decap_4
X_3100_ _3107_/S _3111_/B _3101_/B VPWR VGND sg13cmos5l_nand2b_1
X_3709__296 _3709_/RESET_B VPWR VGND sg13cmos5l_tiehi
XFILLER_1_780 VPWR VGND sg13cmos5l_decap_8
XFILLER_49_740 VPWR VGND sg13cmos5l_decap_8
X_3031_ _3636_/D _3031_/A _3072_/A VPWR VGND sg13cmos5l_nor2_1
XFILLER_37_968 VPWR VGND sg13cmos5l_decap_8
XFILLER_36_412 VPWR VGND sg13cmos5l_decap_4
X_2815_ _2815_/Y _2815_/A VPWR VGND sg13cmos5l_inv_1
XFILLER_32_695 VPWR VGND sg13cmos5l_fill_1
X_3795_ _3795_/Q _3806_/CLK _3795_/D _3795_/RESET_B VPWR VGND sg13cmos5l_dfrbpq_1
X_2746_ _2746_/Y _2846_/B _2746_/B VPWR VGND sg13cmos5l_nor2_1
X_2677_ _3541_/D input10/X hold589/X _2681_/S VPWR VGND sg13cmos5l_mux2_1
XFILLER_28_1011 VPWR VGND sg13cmos5l_decap_8
XFILLER_28_913 VPWR VGND sg13cmos5l_decap_8
X_3229_ _3230_/B _3218_/B _3227_/Y _3143_/A VPWR VGND sg13cmos5l_a21oi_1
XFILLER_43_927 VPWR VGND sg13cmos5l_decap_8
XFILLER_23_684 VPWR VGND sg13cmos5l_decap_8
XFILLER_10_345 VPWR VGND sg13cmos5l_fill_2
XFILLER_6_327 VPWR VGND sg13cmos5l_decap_8
XFILLER_10_378 VPWR VGND sg13cmos5l_decap_8
XFILLER_2_511 VPWR VGND sg13cmos5l_fill_2
XFILLER_2_500 VPWR VGND sg13cmos5l_decap_8
XFILLER_19_902 VPWR VGND sg13cmos5l_decap_4
XFILLER_45_220 VPWR VGND sg13cmos5l_fill_2
XFILLER_46_776 VPWR VGND sg13cmos5l_decap_8
XFILLER_34_927 VPWR VGND sg13cmos5l_decap_8
XFILLER_42_993 VPWR VGND sg13cmos5l_decap_8
XFILLER_13_194 VPWR VGND sg13cmos5l_decap_8
XFILLER_10_890 VPWR VGND sg13cmos5l_decap_8
X_3580_ _3580_/Q _3809_/CLK _3580_/D _3580_/RESET_B VPWR VGND sg13cmos5l_dfrbpq_1
X_2600_ _3479_/D hold561/X input7/X _2606_/S VPWR VGND sg13cmos5l_mux2_1
X_2531_ _2531_/Y _2531_/A _2530_/Y VPWR VGND sg13cmos5l_nor2b_1
XFILLER_6_883 VPWR VGND sg13cmos5l_decap_8
X_2462_ _2462_/Y _3783_/Q _2907_/A2 _2303_/A VPWR VGND sg13cmos5l_o21ai_1
X_2393_ _2393_/Y _2393_/A _2411_/B VPWR VGND sg13cmos5l_nand2_1
XFILLER_37_710 VPWR VGND sg13cmos5l_decap_4
X_3014_ _3014_/X _3002_/B _3152_/B _3014_/S VPWR VGND sg13cmos5l_mux2_1
XFILLER_36_253 VPWR VGND sg13cmos5l_decap_4
XFILLER_25_938 VPWR VGND sg13cmos5l_decap_8
XFILLER_33_971 VPWR VGND sg13cmos5l_decap_8
XFILLER_20_621 VPWR VGND sg13cmos5l_fill_1
XFILLER_22_49 VPWR VGND sg13cmos5l_decap_8
X_3778_ _3778_/Q clkload5/A _3778_/D _3778_/RESET_B VPWR VGND sg13cmos5l_dfrbpq_1
X_2729_ _3562_/D _2363_/A _1951_/Y _2728_/Y VPWR VGND sg13cmos5l_a21oi_1
XFILLER_3_319 VPWR VGND sg13cmos5l_decap_4
XFILLER_47_46 VPWR VGND sg13cmos5l_decap_8
XFILLER_47_35 VPWR VGND sg13cmos5l_fill_1
XFILLER_16_916 VPWR VGND sg13cmos5l_decap_8
XFILLER_27_242 VPWR VGND sg13cmos5l_decap_8
XFILLER_43_713 VPWR VGND sg13cmos5l_decap_8
X_3775__445 _3775_/RESET_B VPWR VGND sg13cmos5l_tiehi
XFILLER_42_223 VPWR VGND sg13cmos5l_decap_8
XFILLER_27_297 VPWR VGND sg13cmos5l_decap_8
XFILLER_31_919 VPWR VGND sg13cmos5l_decap_8
XFILLER_24_982 VPWR VGND sg13cmos5l_decap_8
XFILLER_30_407 VPWR VGND sg13cmos5l_decap_8
XFILLER_6_102 VPWR VGND sg13cmos5l_decap_8
XFILLER_12_82 VPWR VGND sg13cmos5l_decap_8
XFILLER_3_864 VPWR VGND sg13cmos5l_decap_8
XFILLER_19_743 VPWR VGND sg13cmos5l_decap_4
XFILLER_46_595 VPWR VGND sg13cmos5l_fill_2
XFILLER_46_573 VPWR VGND sg13cmos5l_decap_8
XFILLER_33_223 VPWR VGND sg13cmos5l_decap_8
XFILLER_33_234 VPWR VGND sg13cmos5l_fill_1
XFILLER_34_768 VPWR VGND sg13cmos5l_decap_8
XFILLER_22_919 VPWR VGND sg13cmos5l_decap_8
XFILLER_33_267 VPWR VGND sg13cmos5l_fill_1
X_1962_ _3188_/A _1962_/A VPWR VGND sg13cmos5l_inv_1
X_3701_ _3701_/Q _3731_/CLK _3701_/D _3701_/RESET_B VPWR VGND sg13cmos5l_dfrbpq_1
XFILLER_30_996 VPWR VGND sg13cmos5l_decap_8
X_3632_ _3632_/Q _3722_/CLK _3632_/D _3632_/RESET_B VPWR VGND sg13cmos5l_dfrbpq_1
X_3563_ _3563_/Q clkload1/A _3563_/D _3563_/RESET_B VPWR VGND sg13cmos5l_dfrbpq_1
X_2514_ _2514_/X _2410_/B _2534_/A _2513_/Y VPWR VGND sg13cmos5l_a21o_1
X_3494_ _3494_/Q clkload6/A _3494_/D _3494_/RESET_B VPWR VGND sg13cmos5l_dfrbpq_1
X_2445_ _2446_/B _2455_/B _2443_/Y _2455_/A VPWR VGND sg13cmos5l_o21ai_1
X_2376_ _2376_/X _2376_/A _2376_/B VPWR VGND sg13cmos5l_and2_1
XFILLER_29_529 VPWR VGND sg13cmos5l_fill_2
XFILLER_17_38 VPWR VGND sg13cmos5l_decap_4
XFILLER_24_212 VPWR VGND sg13cmos5l_decap_8
XFILLER_24_234 VPWR VGND sg13cmos5l_decap_8
XFILLER_12_407 VPWR VGND sg13cmos5l_fill_1
XFILLER_24_267 VPWR VGND sg13cmos5l_fill_2
XFILLER_24_278 VPWR VGND sg13cmos5l_fill_2
XFILLER_12_429 VPWR VGND sg13cmos5l_decap_8
XFILLER_21_952 VPWR VGND sg13cmos5l_decap_8
XFILLER_20_462 VPWR VGND sg13cmos5l_decap_8
XFILLER_4_617 VPWR VGND sg13cmos5l_decap_8
XFILLER_3_116 VPWR VGND sg13cmos5l_decap_8
XFILLER_0_867 VPWR VGND sg13cmos5l_decap_8
XFILLER_48_838 VPWR VGND sg13cmos5l_decap_8
XFILLER_47_315 VPWR VGND sg13cmos5l_decap_8
XFILLER_43_532 VPWR VGND sg13cmos5l_decap_8
XFILLER_43_554 VPWR VGND sg13cmos5l_decap_8
XFILLER_15_245 VPWR VGND sg13cmos5l_decap_8
XFILLER_15_256 VPWR VGND sg13cmos5l_fill_1
XFILLER_8_912 VPWR VGND sg13cmos5l_decap_8
XFILLER_12_996 VPWR VGND sg13cmos5l_decap_8
XFILLER_8_989 VPWR VGND sg13cmos5l_decap_8
X_2230_ _3741_/D _2361_/A _2230_/B VPWR VGND sg13cmos5l_nor2_1
XFILLER_2_171 VPWR VGND sg13cmos5l_decap_4
XFILLER_39_816 VPWR VGND sg13cmos5l_decap_8
XFILLER_39_805 VPWR VGND sg13cmos5l_decap_4
X_2161_ _2161_/Y _2161_/A _2161_/B VPWR VGND sg13cmos5l_nor2_1
XFILLER_38_348 VPWR VGND sg13cmos5l_decap_4
X_2092_ _2092_/X _2092_/A _2092_/B VPWR VGND sg13cmos5l_xor2_1
XFILLER_19_551 VPWR VGND sg13cmos5l_decap_8
XFILLER_19_584 VPWR VGND sg13cmos5l_decap_8
XFILLER_0_63 VPWR VGND sg13cmos5l_decap_8
XFILLER_34_532 VPWR VGND sg13cmos5l_decap_8
XFILLER_22_727 VPWR VGND sg13cmos5l_decap_8
X_2994_ _3620_/D _3072_/A _2994_/B VPWR VGND sg13cmos5l_nor2_1
XFILLER_9_50 VPWR VGND sg13cmos5l_decap_8
X_1945_ _2364_/A _2363_/A VPWR VGND sg13cmos5l_inv_1
X_3615_ _3615_/Q _3665_/CLK _3615_/D _3615_/RESET_B VPWR VGND sg13cmos5l_dfrbpq_1
X_3546_ _3546_/Q clkload2/A _3546_/D _3546_/RESET_B VPWR VGND sg13cmos5l_dfrbpq_1
X_3477_ _3558_/D _3477_/A _3477_/B _3477_/C VPWR VGND sg13cmos5l_nor3_1
X_2428_ _2428_/Y _3794_/Q _2428_/B VPWR VGND sg13cmos5l_nand2b_1
X_2359_ _3764_/D _2340_/B _2360_/S _2358_/Y VPWR VGND sg13cmos5l_a21oi_1
XFILLER_45_819 VPWR VGND sg13cmos5l_decap_8
XFILLER_44_307 VPWR VGND sg13cmos5l_decap_8
XFILLER_38_893 VPWR VGND sg13cmos5l_decap_8
XFILLER_40_502 VPWR VGND sg13cmos5l_decap_8
XFILLER_13_705 VPWR VGND sg13cmos5l_decap_8
XFILLER_8_219 VPWR VGND sg13cmos5l_decap_8
XFILLER_21_771 VPWR VGND sg13cmos5l_decap_8
XFILLER_5_915 VPWR VGND sg13cmos5l_decap_8
XFILLER_0_675 VPWR VGND sg13cmos5l_decap_8
XFILLER_48_668 VPWR VGND sg13cmos5l_fill_2
XFILLER_47_167 VPWR VGND sg13cmos5l_fill_1
XFILLER_29_871 VPWR VGND sg13cmos5l_fill_1
XFILLER_43_362 VPWR VGND sg13cmos5l_decap_8
XFILLER_43_351 VPWR VGND sg13cmos5l_fill_2
XFILLER_44_896 VPWR VGND sg13cmos5l_decap_8
XFILLER_31_535 VPWR VGND sg13cmos5l_fill_2
XFILLER_34_80 VPWR VGND sg13cmos5l_fill_1
X_3400_ _3400_/Y _3390_/X _3409_/A _3399_/Y VPWR VGND sg13cmos5l_o21ai_1
X_3331_ _3332_/B hold694/X _3327_/X _3352_/B VPWR VGND sg13cmos5l_o21ai_1
XFILLER_3_491 VPWR VGND sg13cmos5l_decap_8
X_3262_ _3355_/B _3261_/A _3261_/B _2108_/Y VPWR VGND sg13cmos5l_a21o_1
X_3193_ _3193_/Y _3108_/B _3139_/B _3192_/Y VPWR VGND sg13cmos5l_o21ai_1
X_2213_ _2213_/Y _2214_/B VPWR VGND sg13cmos5l_inv_1
X_2144_ _2144_/Y _2137_/B _2137_/C _3418_/B VPWR VGND sg13cmos5l_a21oi_1
XFILLER_26_318 VPWR VGND sg13cmos5l_decap_8
XFILLER_26_329 VPWR VGND sg13cmos5l_fill_2
XFILLER_47_690 VPWR VGND sg13cmos5l_fill_2
X_2075_ _2088_/B _2073_/Y _2074_/Y _2072_/Y VPWR VGND sg13cmos5l_a21oi_1
XFILLER_35_830 VPWR VGND sg13cmos5l_fill_2
XFILLER_34_340 VPWR VGND sg13cmos5l_decap_8
XFILLER_35_852 VPWR VGND sg13cmos5l_decap_4
XFILLER_35_863 VPWR VGND sg13cmos5l_decap_8
XFILLER_14_39 VPWR VGND sg13cmos5l_fill_2
XFILLER_22_557 VPWR VGND sg13cmos5l_decap_4
X_2977_ _2977_/Y _3611_/Q _2974_/Y _2975_/Y _2976_/Y VPWR VGND sg13cmos5l_a22oi_1
X_1928_ _1928_/Y _1928_/A VPWR VGND sg13cmos5l_inv_1
XFILLER_30_16 VPWR VGND sg13cmos5l_decap_8
Xhold720 hold720/X _3653_/Q VPWR VGND sg13cmos5l_dlygate4sd3_1
Xhold764 _2937_/A _2929_/Y VPWR VGND sg13cmos5l_dlygate4sd3_1
Xhold731 _2304_/A _3731_/Q VPWR VGND sg13cmos5l_dlygate4sd3_1
Xhold742 _2092_/A _3727_/Q VPWR VGND sg13cmos5l_dlygate4sd3_1
Xhold753 _1986_/A _3703_/Q VPWR VGND sg13cmos5l_dlygate4sd3_1
Xhold775 _2852_/A _3591_/Q VPWR VGND sg13cmos5l_dlygate4sd3_1
Xhold786 _3386_/A _3694_/Q VPWR VGND sg13cmos5l_dlygate4sd3_1
X_3529_ _3529_/Q clkload7/A _3529_/D _3529_/RESET_B VPWR VGND sg13cmos5l_dfrbpq_1
Xhold797 _3222_/C _3221_/X VPWR VGND sg13cmos5l_dlygate4sd3_1
XFILLER_38_690 VPWR VGND sg13cmos5l_decap_4
XFILLER_17_329 VPWR VGND sg13cmos5l_decap_8
XFILLER_26_874 VPWR VGND sg13cmos5l_decap_8
XFILLER_21_590 VPWR VGND sg13cmos5l_decap_8
XFILLER_5_701 VPWR VGND sg13cmos5l_decap_8
XFILLER_4_255 VPWR VGND sg13cmos5l_decap_8
XFILLER_4_299 VPWR VGND sg13cmos5l_decap_8
XFILLER_20_82 VPWR VGND sg13cmos5l_decap_4
XFILLER_1_962 VPWR VGND sg13cmos5l_decap_8
XFILLER_49_922 VPWR VGND sg13cmos5l_decap_8
XFILLER_0_461 VPWR VGND sg13cmos5l_fill_1
XFILLER_49_999 VPWR VGND sg13cmos5l_decap_8
X_2900_ _3598_/D _2863_/Y hold703/X _2939_/A VPWR VGND sg13cmos5l_a21oi_1
XFILLER_16_384 VPWR VGND sg13cmos5l_decap_8
XFILLER_43_181 VPWR VGND sg13cmos5l_decap_4
XFILLER_31_321 VPWR VGND sg13cmos5l_decap_4
XFILLER_32_866 VPWR VGND sg13cmos5l_decap_8
X_2831_ _2831_/X _3536_/Q _3519_/Q _3502_/Q _3485_/Q _2832_/S0 _2832_/S1 VPWR VGND
+ sg13cmos5l_mux4_1
X_2762_ _2762_/Y _2911_/A _2912_/A VPWR VGND sg13cmos5l_nor2b_1
XFILLER_8_550 VPWR VGND sg13cmos5l_fill_1
XFILLER_6_51 VPWR VGND sg13cmos5l_decap_8
X_2693_ _2693_/Y _2693_/A _2693_/B VPWR VGND sg13cmos5l_nand2_1
XFILLER_6_95 VPWR VGND sg13cmos5l_decap_8
X_3314_ _3314_/Y _3652_/Q _3319_/B VPWR VGND sg13cmos5l_nand2_1
X_3245_ _3260_/B _3672_/Q _3673_/Q VPWR VGND sg13cmos5l_xnor2_1
XFILLER_39_454 VPWR VGND sg13cmos5l_decap_4
X_3176_ _3176_/Y _3164_/Y hold686/X _3143_/A VPWR VGND sg13cmos5l_a21oi_1
XFILLER_27_605 VPWR VGND sg13cmos5l_decap_4
X_2127_ _2132_/C _2135_/A _2135_/B _2127_/C VPWR VGND sg13cmos5l_or3_1
X_2058_ _2146_/B _2058_/A _2058_/B VPWR VGND sg13cmos5l_or2_1
XFILLER_26_148 VPWR VGND sg13cmos5l_decap_8
XFILLER_35_660 VPWR VGND sg13cmos5l_decap_4
XFILLER_23_822 VPWR VGND sg13cmos5l_decap_8
XFILLER_25_38 VPWR VGND sg13cmos5l_fill_2
XFILLER_23_888 VPWR VGND sg13cmos5l_decap_8
Xhold561 hold561/X _3479_/Q VPWR VGND sg13cmos5l_dlygate4sd3_1
XFILLER_2_726 VPWR VGND sg13cmos5l_decap_8
Xhold572 hold572/X _3497_/Q VPWR VGND sg13cmos5l_dlygate4sd3_1
Xhold550 hold550/X _3478_/Q VPWR VGND sg13cmos5l_dlygate4sd3_1
X_3483__400 _3483_/RESET_B VPWR VGND sg13cmos5l_tiehi
Xhold594 _3635_/D _3030_/X VPWR VGND sg13cmos5l_dlygate4sd3_1
Xhold583 _1925_/A _3690_/Q VPWR VGND sg13cmos5l_dlygate4sd3_1
XFILLER_45_402 VPWR VGND sg13cmos5l_decap_8
XFILLER_18_627 VPWR VGND sg13cmos5l_fill_1
XFILLER_46_958 VPWR VGND sg13cmos5l_decap_8
XFILLER_17_104 VPWR VGND sg13cmos5l_fill_1
XFILLER_17_137 VPWR VGND sg13cmos5l_decap_8
XFILLER_14_800 VPWR VGND sg13cmos5l_decap_8
XFILLER_14_855 VPWR VGND sg13cmos5l_decap_4
XFILLER_41_663 VPWR VGND sg13cmos5l_decap_4
XFILLER_13_376 VPWR VGND sg13cmos5l_decap_4
XFILLER_15_60 VPWR VGND sg13cmos5l_fill_1
XFILLER_9_369 VPWR VGND sg13cmos5l_decap_4
XFILLER_0_291 VPWR VGND sg13cmos5l_decap_8
X_3030_ _3030_/X _3030_/A _3030_/B VPWR VGND sg13cmos5l_and2_1
XFILLER_49_796 VPWR VGND sg13cmos5l_decap_8
XFILLER_37_947 VPWR VGND sg13cmos5l_decap_8
XFILLER_45_980 VPWR VGND sg13cmos5l_decap_8
XFILLER_17_660 VPWR VGND sg13cmos5l_decap_8
XFILLER_23_107 VPWR VGND sg13cmos5l_fill_2
XFILLER_32_674 VPWR VGND sg13cmos5l_decap_8
X_2814_ _2815_/A _2812_/Y _2813_/Y _2682_/B VPWR VGND sg13cmos5l_o21ai_1
X_3794_ _3794_/Q clkload5/A _3794_/D _3794_/RESET_B VPWR VGND sg13cmos5l_dfrbpq_1
XFILLER_9_892 VPWR VGND sg13cmos5l_decap_8
X_2745_ _2746_/B _2745_/A _2745_/B _2745_/C _2745_/D VPWR VGND sg13cmos5l_nand4_1
X_2676_ _3540_/D input9/X hold611/X _2681_/S VPWR VGND sg13cmos5l_mux2_1
X_3228_ _3230_/A _3227_/Y _3228_/B VPWR VGND sg13cmos5l_nand2b_1
X_3159_ _3159_/X _3652_/Q _3159_/B VPWR VGND sg13cmos5l_or2_1
XFILLER_27_435 VPWR VGND sg13cmos5l_decap_8
XFILLER_43_906 VPWR VGND sg13cmos5l_decap_8
XFILLER_15_608 VPWR VGND sg13cmos5l_fill_1
XFILLER_28_969 VPWR VGND sg13cmos5l_decap_8
XFILLER_36_980 VPWR VGND sg13cmos5l_decap_8
XFILLER_14_107 VPWR VGND sg13cmos5l_decap_4
XFILLER_11_803 VPWR VGND sg13cmos5l_decap_8
XFILLER_23_674 VPWR VGND sg13cmos5l_fill_1
XFILLER_10_302 VPWR VGND sg13cmos5l_decap_8
XFILLER_19_914 VPWR VGND sg13cmos5l_decap_8
XFILLER_45_287 VPWR VGND sg13cmos5l_decap_4
XFILLER_45_265 VPWR VGND sg13cmos5l_fill_1
XFILLER_42_972 VPWR VGND sg13cmos5l_decap_8
XFILLER_14_674 VPWR VGND sg13cmos5l_decap_4
X_3635__200 _3635_/RESET_B VPWR VGND sg13cmos5l_tiehi
XFILLER_9_133 VPWR VGND sg13cmos5l_decap_4
XFILLER_14_696 VPWR VGND sg13cmos5l_fill_1
XFILLER_6_862 VPWR VGND sg13cmos5l_decap_8
X_2530_ _2530_/Y _2530_/A _2530_/B _2530_/C VPWR VGND sg13cmos5l_nand3_1
X_3570__291 _3570_/RESET_B VPWR VGND sg13cmos5l_tiehi
XFILLER_5_383 VPWR VGND sg13cmos5l_decap_8
X_2461_ _2461_/Y _1956_/Y _3454_/A2 _2460_/Y VPWR VGND sg13cmos5l_a21oi_1
XFILLER_47_4 VPWR VGND sg13cmos5l_fill_2
X_2392_ _2401_/B _2411_/B VPWR VGND sg13cmos5l_inv_1
XFILLER_3_1025 VPWR VGND sg13cmos5l_decap_4
X_3013_ _3622_/D _3072_/A _3013_/B VPWR VGND sg13cmos5l_nor2_1
XFILLER_37_766 VPWR VGND sg13cmos5l_fill_1
XFILLER_37_755 VPWR VGND sg13cmos5l_decap_4
XFILLER_37_744 VPWR VGND sg13cmos5l_decap_8
XFILLER_25_917 VPWR VGND sg13cmos5l_decap_8
XFILLER_36_243 VPWR VGND sg13cmos5l_fill_1
XFILLER_24_416 VPWR VGND sg13cmos5l_fill_2
XFILLER_40_909 VPWR VGND sg13cmos5l_decap_8
Xclkbuf_leaf_16_clk _3731_/CLK clkbuf_leaf_2_clk/A VPWR VGND sg13cmos5l_buf_8
XFILLER_33_950 VPWR VGND sg13cmos5l_decap_8
X_3777_ _3777_/Q clkload5/A _3777_/D _3777_/RESET_B VPWR VGND sg13cmos5l_dfrbpq_1
XFILLER_20_677 VPWR VGND sg13cmos5l_decap_4
XFILLER_20_699 VPWR VGND sg13cmos5l_decap_8
X_3768__453 _3768_/RESET_B VPWR VGND sg13cmos5l_tiehi
X_2728_ _2728_/Y _2363_/A _1950_/A _2457_/A VPWR VGND sg13cmos5l_o21ai_1
X_2659_ _3526_/D input12/X hold556/X _2660_/S VPWR VGND sg13cmos5l_mux2_1
X_3480__403 _3480_/RESET_B VPWR VGND sg13cmos5l_tiehi
X_3701__312 _3701_/RESET_B VPWR VGND sg13cmos5l_tiehi
XFILLER_28_744 VPWR VGND sg13cmos5l_decap_4
XFILLER_43_725 VPWR VGND sg13cmos5l_decap_8
XFILLER_43_703 VPWR VGND sg13cmos5l_fill_1
XFILLER_42_202 VPWR VGND sg13cmos5l_decap_8
XFILLER_42_279 VPWR VGND sg13cmos5l_decap_8
XFILLER_24_961 VPWR VGND sg13cmos5l_decap_8
XFILLER_23_493 VPWR VGND sg13cmos5l_decap_8
XFILLER_7_604 VPWR VGND sg13cmos5l_decap_8
XFILLER_6_125 VPWR VGND sg13cmos5l_decap_8
XFILLER_11_677 VPWR VGND sg13cmos5l_decap_8
XFILLER_12_61 VPWR VGND sg13cmos5l_decap_8
XFILLER_6_169 VPWR VGND sg13cmos5l_fill_2
XFILLER_3_843 VPWR VGND sg13cmos5l_decap_8
XFILLER_2_375 VPWR VGND sg13cmos5l_decap_8
XFILLER_38_519 VPWR VGND sg13cmos5l_decap_8
XFILLER_19_711 VPWR VGND sg13cmos5l_decap_8
XFILLER_19_722 VPWR VGND sg13cmos5l_fill_2
XFILLER_37_80 VPWR VGND sg13cmos5l_fill_2
XFILLER_19_799 VPWR VGND sg13cmos5l_fill_2
XFILLER_34_703 VPWR VGND sg13cmos5l_fill_2
XFILLER_18_298 VPWR VGND sg13cmos5l_decap_8
XFILLER_33_246 VPWR VGND sg13cmos5l_decap_8
X_1961_ _1961_/Y _1961_/A VPWR VGND sg13cmos5l_inv_1
XFILLER_15_983 VPWR VGND sg13cmos5l_decap_8
X_3700_ _3700_/Q _3731_/CLK _3700_/D _3700_/RESET_B VPWR VGND sg13cmos5l_dfrbpq_1
XFILLER_30_975 VPWR VGND sg13cmos5l_decap_8
X_3631_ _3631_/Q _3722_/CLK _3631_/D _3631_/RESET_B VPWR VGND sg13cmos5l_dfrbpq_1
X_3562_ _3562_/Q clkload1/A _3562_/D _3562_/RESET_B VPWR VGND sg13cmos5l_dfrbpq_1
X_2513_ _2513_/Y _2397_/X _2411_/X _2511_/X _2203_/Y _2412_/Y VPWR VGND sg13cmos5l_a221oi_1
X_3493_ _3493_/Q clkload8/A _3493_/D _3493_/RESET_B VPWR VGND sg13cmos5l_dfrbpq_1
Xclkbuf_leaf_5_clk clkload7/A clkbuf_leaf_9_clk/A VPWR VGND sg13cmos5l_buf_8
X_2444_ _2446_/A _2438_/X _2441_/Y _2443_/Y _3778_/Q _2442_/Y VPWR VGND sg13cmos5l_a221oi_1
X_2375_ _2376_/B _3768_/Q _3769_/Q _3770_/Q VPWR VGND sg13cmos5l_o21ai_1
XFILLER_25_1015 VPWR VGND sg13cmos5l_decap_8
XFILLER_29_508 VPWR VGND sg13cmos5l_decap_8
XFILLER_37_530 VPWR VGND sg13cmos5l_fill_2
XFILLER_24_224 VPWR VGND sg13cmos5l_decap_4
XFILLER_25_747 VPWR VGND sg13cmos5l_fill_2
XFILLER_33_16 VPWR VGND sg13cmos5l_decap_8
XFILLER_21_931 VPWR VGND sg13cmos5l_decap_8
X_3549__333 _3549_/RESET_B VPWR VGND sg13cmos5l_tiehi
XFILLER_0_846 VPWR VGND sg13cmos5l_decap_8
XFILLER_48_817 VPWR VGND sg13cmos5l_decap_8
XFILLER_43_500 VPWR VGND sg13cmos5l_decap_4
XFILLER_16_714 VPWR VGND sg13cmos5l_decap_8
XFILLER_43_588 VPWR VGND sg13cmos5l_fill_2
XFILLER_30_227 VPWR VGND sg13cmos5l_fill_2
XFILLER_12_975 VPWR VGND sg13cmos5l_decap_8
XFILLER_8_968 VPWR VGND sg13cmos5l_decap_8
XFILLER_7_467 VPWR VGND sg13cmos5l_decap_8
XFILLER_38_327 VPWR VGND sg13cmos5l_fill_2
X_2160_ _2160_/Y _2150_/Y _2154_/X _2159_/Y VPWR VGND sg13cmos5l_o21ai_1
X_2091_ _2092_/B _3726_/Q _2151_/B _2072_/Y VPWR VGND sg13cmos5l_a21oi_1
XFILLER_0_42 VPWR VGND sg13cmos5l_decap_8
XFILLER_46_371 VPWR VGND sg13cmos5l_decap_8
XFILLER_0_1028 VPWR VGND sg13cmos5l_fill_1
X_3758__463 _3758_/RESET_B VPWR VGND sg13cmos5l_tiehi
X_2993_ _3050_/B _2994_/B VPWR VGND sg13cmos5l_inv_1
X_1944_ _1944_/Y _3576_/Q VPWR VGND sg13cmos5l_inv_1
XFILLER_21_238 VPWR VGND sg13cmos5l_decap_8
XFILLER_30_772 VPWR VGND sg13cmos5l_decap_8
X_3614_ _3614_/Q _3665_/CLK _3614_/D _3614_/RESET_B VPWR VGND sg13cmos5l_dfrbpq_1
X_3545_ _3545_/Q clkload6/A _3545_/D _3545_/RESET_B VPWR VGND sg13cmos5l_dfrbpq_1
X_3765__456 _3765_/RESET_B VPWR VGND sg13cmos5l_tiehi
X_3476_ _3557_/D _2689_/B _2717_/B _2686_/Y VPWR VGND sg13cmos5l_a21oi_1
X_2427_ _2439_/B _3794_/Q _2426_/Y _2425_/Y VPWR VGND sg13cmos5l_o21ai_1
X_2358_ _2358_/Y _2340_/A _2360_/S _2304_/B VPWR VGND sg13cmos5l_o21ai_1
X_2289_ _2290_/A _3804_/Q _2698_/A _2029_/B _3803_/Q _3806_/Q VPWR VGND sg13cmos5l_a221oi_1
XFILLER_28_49 VPWR VGND sg13cmos5l_decap_8
XFILLER_37_360 VPWR VGND sg13cmos5l_fill_2
XFILLER_37_393 VPWR VGND sg13cmos5l_fill_1
X_3772__449 _3772_/RESET_B VPWR VGND sg13cmos5l_tiehi
XFILLER_12_216 VPWR VGND sg13cmos5l_decap_8
XFILLER_4_415 VPWR VGND sg13cmos5l_decap_8
XFILLER_0_665 VPWR VGND sg13cmos5l_decap_4
XFILLER_35_308 VPWR VGND sg13cmos5l_fill_2
XFILLER_44_875 VPWR VGND sg13cmos5l_decap_8
XFILLER_16_577 VPWR VGND sg13cmos5l_decap_8
XFILLER_31_525 VPWR VGND sg13cmos5l_fill_1
XFILLER_31_547 VPWR VGND sg13cmos5l_decap_8
XFILLER_15_1025 VPWR VGND sg13cmos5l_decap_4
XFILLER_8_754 VPWR VGND sg13cmos5l_fill_1
XFILLER_11_282 VPWR VGND sg13cmos5l_decap_8
XFILLER_7_264 VPWR VGND sg13cmos5l_fill_2
XFILLER_7_253 VPWR VGND sg13cmos5l_decap_8
X_3708__104 _3708_/D VPWR VGND sg13cmos5l_tielo
X_3330_ _3332_/A _3330_/A _3327_/X VPWR VGND sg13cmos5l_nor2b_1
XFILLER_4_993 VPWR VGND sg13cmos5l_decap_8
X_3261_ _3355_/A _3261_/A _3261_/B _3261_/C VPWR VGND sg13cmos5l_nand3_1
X_3192_ _3192_/Y _3192_/A _3192_/B _3192_/C VPWR VGND sg13cmos5l_nand3_1
X_2212_ _2214_/B _3712_/Q _2217_/B VPWR VGND sg13cmos5l_xor2_1
XFILLER_38_146 VPWR VGND sg13cmos5l_fill_2
XFILLER_38_135 VPWR VGND sg13cmos5l_decap_8
XFILLER_38_113 VPWR VGND sg13cmos5l_decap_8
X_2143_ _3415_/B _2113_/Y _2141_/X _2143_/S VPWR VGND sg13cmos5l_mux2_1
XFILLER_26_308 VPWR VGND sg13cmos5l_fill_1
X_2074_ _2074_/Y _3721_/Q _3692_/Q VPWR VGND sg13cmos5l_xnor2_1
XFILLER_34_330 VPWR VGND sg13cmos5l_decap_4
XFILLER_22_525 VPWR VGND sg13cmos5l_fill_1
X_2976_ _2976_/Y _3610_/Q _3592_/Q VPWR VGND sg13cmos5l_nor2_1
X_3650__111 _3650_/D VPWR VGND sg13cmos5l_tielo
X_1927_ _1927_/Y _1927_/A VPWR VGND sg13cmos5l_inv_1
Xhold710 hold710/X _3684_/Q VPWR VGND sg13cmos5l_dlygate4sd3_1
Xhold721 hold721/X _3652_/Q VPWR VGND sg13cmos5l_dlygate4sd3_1
XFILLER_30_39 VPWR VGND sg13cmos5l_decap_8
Xhold732 hold732/X _3588_/Q VPWR VGND sg13cmos5l_dlygate4sd3_1
XFILLER_2_919 VPWR VGND sg13cmos5l_decap_8
Xhold754 _2401_/A _3790_/Q VPWR VGND sg13cmos5l_dlygate4sd3_1
Xhold743 hold743/X _2092_/X VPWR VGND sg13cmos5l_dlygate4sd3_1
Xhold776 _2978_/A _3595_/Q VPWR VGND sg13cmos5l_dlygate4sd3_1
Xhold787 _3101_/C _3641_/Q VPWR VGND sg13cmos5l_dlygate4sd3_1
Xhold765 hold765/X _3801_/Q VPWR VGND sg13cmos5l_dlygate4sd3_1
X_3528_ _3528_/Q clkload6/A _3528_/D _3528_/RESET_B VPWR VGND sg13cmos5l_dfrbpq_1
Xhold798 _1972_/A _3704_/Q VPWR VGND sg13cmos5l_dlygate4sd3_1
X_3459_ _3723_/D _3459_/A _3459_/B VPWR VGND sg13cmos5l_and2_1
XFILLER_45_628 VPWR VGND sg13cmos5l_fill_1
XFILLER_45_617 VPWR VGND sg13cmos5l_decap_8
XFILLER_44_149 VPWR VGND sg13cmos5l_fill_1
XFILLER_25_352 VPWR VGND sg13cmos5l_fill_1
XFILLER_26_864 VPWR VGND sg13cmos5l_fill_2
XFILLER_25_363 VPWR VGND sg13cmos5l_decap_4
XFILLER_25_385 VPWR VGND sg13cmos5l_decap_4
XFILLER_40_322 VPWR VGND sg13cmos5l_decap_4
XFILLER_40_399 VPWR VGND sg13cmos5l_fill_1
XFILLER_40_388 VPWR VGND sg13cmos5l_fill_1
XFILLER_4_234 VPWR VGND sg13cmos5l_decap_8
XFILLER_49_901 VPWR VGND sg13cmos5l_decap_8
XFILLER_0_440 VPWR VGND sg13cmos5l_fill_1
XFILLER_1_941 VPWR VGND sg13cmos5l_decap_8
XFILLER_48_444 VPWR VGND sg13cmos5l_decap_4
XFILLER_0_484 VPWR VGND sg13cmos5l_decap_8
XFILLER_49_978 VPWR VGND sg13cmos5l_decap_8
XFILLER_48_466 VPWR VGND sg13cmos5l_decap_8
XFILLER_36_617 VPWR VGND sg13cmos5l_fill_1
XFILLER_17_864 VPWR VGND sg13cmos5l_decap_8
XFILLER_45_80 VPWR VGND sg13cmos5l_decap_4
XFILLER_44_683 VPWR VGND sg13cmos5l_decap_8
XFILLER_44_661 VPWR VGND sg13cmos5l_decap_8
XFILLER_43_160 VPWR VGND sg13cmos5l_decap_8
XFILLER_16_363 VPWR VGND sg13cmos5l_decap_8
XFILLER_17_886 VPWR VGND sg13cmos5l_decap_8
XFILLER_32_834 VPWR VGND sg13cmos5l_fill_2
X_2830_ _2830_/Y _2790_/A _2822_/X _2829_/Y VPWR VGND sg13cmos5l_o21ai_1
X_3673__144 _3673_/RESET_B VPWR VGND sg13cmos5l_tiehi
X_3755__466 _3755_/RESET_B VPWR VGND sg13cmos5l_tiehi
XFILLER_32_889 VPWR VGND sg13cmos5l_fill_1
X_2761_ _2761_/Y _2911_/A _2876_/A VPWR VGND sg13cmos5l_nand2b_1
X_2692_ _2693_/B _2692_/A input2/X VPWR VGND sg13cmos5l_nor2_1
X_3313_ _3317_/B _3319_/B _3310_/Y _3320_/C _3312_/Y VPWR VGND sg13cmos5l_a22oi_1
X_3762__459 _3762_/RESET_B VPWR VGND sg13cmos5l_tiehi
X_3244_ _3244_/Y _3243_/Y _3244_/B VPWR VGND sg13cmos5l_nand2b_1
XFILLER_6_1023 VPWR VGND sg13cmos5l_decap_4
X_3175_ _3175_/Y _3175_/A _3175_/B VPWR VGND sg13cmos5l_nand2_1
X_2126_ _2127_/C _3731_/Q _2228_/B VPWR VGND sg13cmos5l_nand2_1
XFILLER_27_628 VPWR VGND sg13cmos5l_fill_1
X_2057_ _3420_/B _2057_/A _2058_/B VPWR VGND sg13cmos5l_nor2_1
XFILLER_26_138 VPWR VGND sg13cmos5l_fill_1
XFILLER_41_108 VPWR VGND sg13cmos5l_decap_4
XFILLER_34_160 VPWR VGND sg13cmos5l_decap_8
XFILLER_22_322 VPWR VGND sg13cmos5l_decap_8
XFILLER_34_171 VPWR VGND sg13cmos5l_fill_2
XFILLER_10_506 VPWR VGND sg13cmos5l_decap_8
X_2959_ _2959_/X _2944_/Y _2964_/B _2964_/C VPWR VGND sg13cmos5l_a21o_1
Xhold551 hold551/X _3491_/Q VPWR VGND sg13cmos5l_dlygate4sd3_1
Xhold540 _1946_/A _3779_/Q VPWR VGND sg13cmos5l_dlygate4sd3_1
Xhold562 hold562/X _3545_/Q VPWR VGND sg13cmos5l_dlygate4sd3_1
Xhold595 hold595/X _3492_/Q VPWR VGND sg13cmos5l_dlygate4sd3_1
Xhold573 hold573/X _3494_/Q VPWR VGND sg13cmos5l_dlygate4sd3_1
Xhold584 _3722_/D _3458_/Y VPWR VGND sg13cmos5l_dlygate4sd3_1
XFILLER_46_937 VPWR VGND sg13cmos5l_decap_8
XFILLER_14_823 VPWR VGND sg13cmos5l_decap_4
XFILLER_26_672 VPWR VGND sg13cmos5l_fill_2
XFILLER_25_171 VPWR VGND sg13cmos5l_fill_1
XFILLER_13_344 VPWR VGND sg13cmos5l_decap_4
XFILLER_15_72 VPWR VGND sg13cmos5l_decap_4
XFILLER_12_1017 VPWR VGND sg13cmos5l_decap_8
XFILLER_12_1028 VPWR VGND sg13cmos5l_fill_1
XFILLER_0_281 VPWR VGND sg13cmos5l_decap_4
XFILLER_49_775 VPWR VGND sg13cmos5l_decap_8
XFILLER_37_926 VPWR VGND sg13cmos5l_decap_8
XFILLER_48_285 VPWR VGND sg13cmos5l_fill_2
XFILLER_24_609 VPWR VGND sg13cmos5l_decap_8
XFILLER_16_160 VPWR VGND sg13cmos5l_decap_4
XFILLER_17_683 VPWR VGND sg13cmos5l_fill_2
XFILLER_16_193 VPWR VGND sg13cmos5l_decap_8
X_2813_ _2813_/Y _2819_/S0 _3506_/Q _2832_/S1 VPWR VGND sg13cmos5l_o21ai_1
XFILLER_20_837 VPWR VGND sg13cmos5l_fill_2
XFILLER_31_185 VPWR VGND sg13cmos5l_fill_1
X_3793_ _3793_/Q clkload4/A _3793_/D _3793_/RESET_B VPWR VGND sg13cmos5l_dfrbpq_1
XFILLER_9_871 VPWR VGND sg13cmos5l_decap_8
XFILLER_31_196 VPWR VGND sg13cmos5l_fill_1
X_2744_ _2745_/D _3578_/Q _3626_/Q _3600_/Q _3687_/Q VPWR VGND sg13cmos5l_nor4_1
X_2675_ _3539_/D input8/X hold606/X _2681_/S VPWR VGND sg13cmos5l_mux2_1
X_3227_ _3227_/Y _3116_/Y _3207_/A _3225_/Y _3226_/Y VPWR VGND sg13cmos5l_a22oi_1
X_3158_ _3158_/Y _3652_/Q _3159_/B _3157_/Y _2009_/A VPWR VGND sg13cmos5l_a22oi_1
XFILLER_28_948 VPWR VGND sg13cmos5l_decap_8
XFILLER_39_296 VPWR VGND sg13cmos5l_decap_8
X_2109_ _3418_/B _2094_/Y _2108_/Y _2138_/B VPWR VGND sg13cmos5l_mux2_1
X_3693__328 _3693_/RESET_B VPWR VGND sg13cmos5l_tiehi
X_3089_ _3283_/A _3670_/Q _3090_/B VPWR VGND sg13cmos5l_xnor2_1
XFILLER_23_620 VPWR VGND sg13cmos5l_decap_8
XFILLER_35_480 VPWR VGND sg13cmos5l_decap_8
XFILLER_35_1028 VPWR VGND sg13cmos5l_fill_1
XFILLER_11_837 VPWR VGND sg13cmos5l_decap_8
XFILLER_46_734 VPWR VGND sg13cmos5l_fill_1
XFILLER_46_723 VPWR VGND sg13cmos5l_decap_8
X_3559__313 _3559_/RESET_B VPWR VGND sg13cmos5l_tiehi
XFILLER_27_992 VPWR VGND sg13cmos5l_decap_8
XFILLER_42_951 VPWR VGND sg13cmos5l_decap_8
X_3715__280 _3715_/RESET_B VPWR VGND sg13cmos5l_tiehi
XFILLER_6_841 VPWR VGND sg13cmos5l_decap_8
X_2460_ _2460_/Y _3782_/Q _3454_/A2 _3461_/A VPWR VGND sg13cmos5l_o21ai_1
X_2391_ _2411_/B _3794_/Q _2391_/B VPWR VGND sg13cmos5l_xnor2_1
XFILLER_3_53 VPWR VGND sg13cmos5l_decap_8
XFILLER_3_97 VPWR VGND sg13cmos5l_decap_8
XFILLER_49_583 VPWR VGND sg13cmos5l_decap_8
XFILLER_3_1004 VPWR VGND sg13cmos5l_decap_8
X_3012_ _3012_/X _3006_/B _3155_/B _3014_/S VPWR VGND sg13cmos5l_mux2_1
XFILLER_36_233 VPWR VGND sg13cmos5l_decap_4
XFILLER_18_981 VPWR VGND sg13cmos5l_decap_8
XFILLER_36_266 VPWR VGND sg13cmos5l_fill_2
XFILLER_17_480 VPWR VGND sg13cmos5l_decap_8
XFILLER_20_612 VPWR VGND sg13cmos5l_decap_8
XFILLER_32_483 VPWR VGND sg13cmos5l_decap_8
XFILLER_20_656 VPWR VGND sg13cmos5l_decap_4
X_3776_ _3776_/Q clkload1/A _3776_/D _3776_/RESET_B VPWR VGND sg13cmos5l_dfrbpq_1
X_2727_ _3561_/D _2363_/A _2434_/A _2726_/Y VPWR VGND sg13cmos5l_a21oi_1
X_2658_ _3525_/D input11/X hold602/X _2660_/S VPWR VGND sg13cmos5l_mux2_1
X_2589_ _2589_/Y _2592_/B _2588_/Y _2592_/A VPWR VGND sg13cmos5l_a21oi_1
XFILLER_28_723 VPWR VGND sg13cmos5l_decap_8
XFILLER_27_277 VPWR VGND sg13cmos5l_decap_8
XFILLER_43_759 VPWR VGND sg13cmos5l_decap_8
XFILLER_24_940 VPWR VGND sg13cmos5l_decap_8
XFILLER_42_258 VPWR VGND sg13cmos5l_decap_8
XFILLER_23_483 VPWR VGND sg13cmos5l_fill_1
XFILLER_7_638 VPWR VGND sg13cmos5l_decap_8
XFILLER_10_155 VPWR VGND sg13cmos5l_decap_8
XFILLER_10_188 VPWR VGND sg13cmos5l_decap_8
XFILLER_3_822 VPWR VGND sg13cmos5l_decap_8
XFILLER_2_321 VPWR VGND sg13cmos5l_decap_8
XFILLER_2_354 VPWR VGND sg13cmos5l_decap_8
XFILLER_3_899 VPWR VGND sg13cmos5l_decap_8
XFILLER_46_531 VPWR VGND sg13cmos5l_decap_8
XFILLER_18_233 VPWR VGND sg13cmos5l_fill_2
XFILLER_19_767 VPWR VGND sg13cmos5l_fill_2
XFILLER_46_597 VPWR VGND sg13cmos5l_fill_1
XFILLER_18_288 VPWR VGND sg13cmos5l_fill_1
XFILLER_15_962 VPWR VGND sg13cmos5l_decap_8
X_1960_ _2431_/B _3746_/Q VPWR VGND sg13cmos5l_inv_1
XFILLER_14_483 VPWR VGND sg13cmos5l_decap_8
XFILLER_18_1023 VPWR VGND sg13cmos5l_decap_4
XFILLER_41_280 VPWR VGND sg13cmos5l_decap_4
XFILLER_30_954 VPWR VGND sg13cmos5l_decap_8
X_3630_ _3630_/Q _3664_/CLK _3630_/D _3630_/RESET_B VPWR VGND sg13cmos5l_dfrbpq_1
X_3561_ _3561_/Q clkload1/A _3561_/D _3561_/RESET_B VPWR VGND sg13cmos5l_dfrbpq_1
X_2512_ _2512_/Y _2512_/A _2511_/X VPWR VGND sg13cmos5l_nor2b_1
X_3492_ _3492_/Q clkload8/A _3492_/D _3492_/RESET_B VPWR VGND sg13cmos5l_dfrbpq_1
XFILLER_6_682 VPWR VGND sg13cmos5l_fill_2
X_2443_ _2443_/Y _3794_/Q _2443_/B VPWR VGND sg13cmos5l_nand2b_1
X_2374_ _2406_/A _3791_/Q _2428_/B VPWR VGND sg13cmos5l_xnor2_1
XFILLER_49_391 VPWR VGND sg13cmos5l_decap_8
XFILLER_37_586 VPWR VGND sg13cmos5l_decap_8
XFILLER_40_729 VPWR VGND sg13cmos5l_decap_8
XFILLER_33_39 VPWR VGND sg13cmos5l_decap_4
XFILLER_32_1009 VPWR VGND sg13cmos5l_decap_8
XFILLER_21_987 VPWR VGND sg13cmos5l_decap_8
X_3759_ _3759_/Q _3783_/CLK _3759_/D _3759_/RESET_B VPWR VGND sg13cmos5l_dfrbpq_1
XFILLER_0_825 VPWR VGND sg13cmos5l_decap_8
XFILLER_43_578 VPWR VGND sg13cmos5l_fill_1
XFILLER_30_206 VPWR VGND sg13cmos5l_decap_8
XFILLER_12_954 VPWR VGND sg13cmos5l_decap_8
XFILLER_23_280 VPWR VGND sg13cmos5l_fill_1
XFILLER_8_947 VPWR VGND sg13cmos5l_decap_8
XFILLER_7_446 VPWR VGND sg13cmos5l_decap_8
XFILLER_7_479 VPWR VGND sg13cmos5l_decap_8
XFILLER_48_1027 VPWR VGND sg13cmos5l_fill_2
XFILLER_3_641 VPWR VGND sg13cmos5l_decap_8
X_2090_ _3467_/B _2152_/A _2090_/B VPWR VGND sg13cmos5l_nor2_1
XFILLER_19_531 VPWR VGND sg13cmos5l_fill_1
XFILLER_47_884 VPWR VGND sg13cmos5l_decap_8
XFILLER_0_21 VPWR VGND sg13cmos5l_decap_8
XFILLER_0_1007 VPWR VGND sg13cmos5l_decap_8
X_2992_ _2994_/B _2979_/A _2982_/A _2991_/Y VPWR VGND sg13cmos5l_a21oi_1
X_1943_ _1943_/Y _2844_/A VPWR VGND sg13cmos5l_inv_1
XFILLER_9_85 VPWR VGND sg13cmos5l_decap_8
XFILLER_30_784 VPWR VGND sg13cmos5l_decap_8
X_3613_ _3613_/Q _3665_/CLK _3613_/D _3613_/RESET_B VPWR VGND sg13cmos5l_dfrbpq_1
X_3544_ _3544_/Q clkload8/A _3544_/D _3544_/RESET_B VPWR VGND sg13cmos5l_dfrbpq_1
XFILLER_6_490 VPWR VGND sg13cmos5l_fill_1
X_3475_ _3733_/D _2161_/A _3469_/A _3474_/Y VPWR VGND sg13cmos5l_a21oi_1
X_2426_ _2426_/Y _3750_/Q _3793_/Q VPWR VGND sg13cmos5l_nor2_1
X_2357_ _3763_/D _2357_/A _2356_/Y VPWR VGND sg13cmos5l_nor2b_1
X_2288_ _2292_/A _3804_/Q _2286_/A _2022_/Y _2564_/A _2287_/Y VPWR VGND sg13cmos5l_a221oi_1
XFILLER_44_49 VPWR VGND sg13cmos5l_fill_1
XFILLER_44_38 VPWR VGND sg13cmos5l_decap_8
XFILLER_13_729 VPWR VGND sg13cmos5l_decap_8
XFILLER_4_449 VPWR VGND sg13cmos5l_decap_8
XFILLER_0_600 VPWR VGND sg13cmos5l_decap_8
XFILLER_0_633 VPWR VGND sg13cmos5l_decap_8
XFILLER_0_644 VPWR VGND sg13cmos5l_decap_8
XFILLER_47_158 VPWR VGND sg13cmos5l_decap_8
XFILLER_16_523 VPWR VGND sg13cmos5l_decap_8
XFILLER_29_884 VPWR VGND sg13cmos5l_decap_4
XFILLER_44_854 VPWR VGND sg13cmos5l_decap_8
XFILLER_43_331 VPWR VGND sg13cmos5l_fill_2
XFILLER_16_556 VPWR VGND sg13cmos5l_decap_8
XFILLER_43_397 VPWR VGND sg13cmos5l_fill_1
XFILLER_15_1004 VPWR VGND sg13cmos5l_decap_8
XFILLER_31_537 VPWR VGND sg13cmos5l_fill_1
XFILLER_8_711 VPWR VGND sg13cmos5l_decap_8
XFILLER_12_751 VPWR VGND sg13cmos5l_decap_8
XFILLER_8_733 VPWR VGND sg13cmos5l_decap_4
X_3788__424 _3788_/RESET_B VPWR VGND sg13cmos5l_tiehi
XFILLER_12_795 VPWR VGND sg13cmos5l_decap_8
XFILLER_8_788 VPWR VGND sg13cmos5l_decap_8
XFILLER_4_972 VPWR VGND sg13cmos5l_decap_8
X_3684__433 _3684_/RESET_B VPWR VGND sg13cmos5l_tiehi
X_3260_ _3261_/C _3265_/A _3260_/B VPWR VGND sg13cmos5l_nand2_1
XFILLER_39_604 VPWR VGND sg13cmos5l_fill_1
X_3191_ _3191_/Y _3104_/A _3104_/B _3108_/B _3139_/B _3135_/B VPWR VGND sg13cmos5l_a221oi_1
X_2211_ _2232_/B _2211_/A _2231_/A VPWR VGND sg13cmos5l_nand2_1
X_3567__297 _3567_/RESET_B VPWR VGND sg13cmos5l_tiehi
XFILLER_22_4 VPWR VGND sg13cmos5l_fill_2
X_2142_ _2142_/Y _2228_/B _2217_/A VPWR VGND sg13cmos5l_nand2_1
X_3795__417 _3795_/RESET_B VPWR VGND sg13cmos5l_tiehi
X_2073_ _2073_/Y _3720_/Q _3691_/Q VPWR VGND sg13cmos5l_xnor2_1
XFILLER_47_692 VPWR VGND sg13cmos5l_fill_1
XFILLER_46_180 VPWR VGND sg13cmos5l_fill_2
X_3754__136 _3754_/RESET_B VPWR VGND sg13cmos5l_tiehi
X_3771__450 _3771_/RESET_B VPWR VGND sg13cmos5l_tiehi
XFILLER_22_537 VPWR VGND sg13cmos5l_decap_8
XFILLER_22_548 VPWR VGND sg13cmos5l_fill_1
X_3539__344 _3539_/RESET_B VPWR VGND sg13cmos5l_tiehi
X_2975_ _2975_/Y _3611_/Q _3593_/Q VPWR VGND sg13cmos5l_nand2b_1
X_1926_ _1926_/Y _1926_/A VPWR VGND sg13cmos5l_inv_1
XFILLER_30_592 VPWR VGND sg13cmos5l_decap_8
Xhold700 _2274_/B _3749_/Q VPWR VGND sg13cmos5l_dlygate4sd3_1
Xhold711 _3684_/D _3335_/Y VPWR VGND sg13cmos5l_dlygate4sd3_1
X_3527_ _3527_/Q clkload8/A _3527_/D _3527_/RESET_B VPWR VGND sg13cmos5l_dfrbpq_1
Xhold733 _2869_/B _2913_/A VPWR VGND sg13cmos5l_dlygate4sd3_1
Xhold755 _2405_/B _2404_/Y VPWR VGND sg13cmos5l_dlygate4sd3_1
Xhold744 hold744/X _2150_/A VPWR VGND sg13cmos5l_dlygate4sd3_1
Xhold722 _3652_/D _3172_/Y VPWR VGND sg13cmos5l_dlygate4sd3_1
Xhold777 _1961_/A _3614_/Q VPWR VGND sg13cmos5l_dlygate4sd3_1
Xhold766 _2041_/B _2040_/Y VPWR VGND sg13cmos5l_dlygate4sd3_1
Xhold788 _3380_/A _3695_/Q VPWR VGND sg13cmos5l_dlygate4sd3_1
Xhold799 _1981_/A _3618_/Q VPWR VGND sg13cmos5l_dlygate4sd3_1
XFILLER_39_38 VPWR VGND sg13cmos5l_decap_4
X_3546__337 _3546_/RESET_B VPWR VGND sg13cmos5l_tiehi
X_3458_ _3458_/Y _1925_/Y _3458_/A2 _3457_/Y VPWR VGND sg13cmos5l_a21oi_1
X_2409_ _2410_/B _2399_/S _2406_/X _2407_/Y VPWR VGND sg13cmos5l_a21oi_1
X_3389_ _3390_/C _3389_/A _3389_/B _3389_/C VPWR VGND sg13cmos5l_and3_1
XFILLER_29_114 VPWR VGND sg13cmos5l_decap_4
XFILLER_29_136 VPWR VGND sg13cmos5l_fill_1
XFILLER_25_320 VPWR VGND sg13cmos5l_decap_8
XFILLER_25_331 VPWR VGND sg13cmos5l_fill_1
XFILLER_25_342 VPWR VGND sg13cmos5l_decap_4
XFILLER_38_1026 VPWR VGND sg13cmos5l_fill_2
XFILLER_41_879 VPWR VGND sg13cmos5l_decap_8
XFILLER_40_367 VPWR VGND sg13cmos5l_decap_8
XFILLER_40_356 VPWR VGND sg13cmos5l_decap_8
XFILLER_5_769 VPWR VGND sg13cmos5l_decap_8
XFILLER_45_1008 VPWR VGND sg13cmos5l_decap_8
XFILLER_1_920 VPWR VGND sg13cmos5l_decap_8
XFILLER_0_452 VPWR VGND sg13cmos5l_decap_8
XFILLER_1_997 VPWR VGND sg13cmos5l_decap_8
XFILLER_49_957 VPWR VGND sg13cmos5l_decap_8
XFILLER_48_412 VPWR VGND sg13cmos5l_fill_1
XFILLER_29_681 VPWR VGND sg13cmos5l_decap_8
XFILLER_44_640 VPWR VGND sg13cmos5l_decap_8
X_3597__257 _3597_/RESET_B VPWR VGND sg13cmos5l_tiehi
XFILLER_16_320 VPWR VGND sg13cmos5l_decap_4
XFILLER_16_342 VPWR VGND sg13cmos5l_decap_8
XFILLER_17_843 VPWR VGND sg13cmos5l_decap_8
X_2760_ _2912_/B _2911_/A _2876_/A VPWR VGND sg13cmos5l_nor2b_1
X_2691_ _2698_/B _2692_/A _2691_/B VPWR VGND sg13cmos5l_nor2_1
X_3312_ _3312_/Y _3703_/Q _3699_/Q VPWR VGND sg13cmos5l_nor2b_1
XFILLER_6_1002 VPWR VGND sg13cmos5l_decap_8
X_3243_ _3243_/Y _3699_/Q _3672_/Q VPWR VGND sg13cmos5l_nand2_1
XFILLER_39_434 VPWR VGND sg13cmos5l_decap_8
X_3174_ _3653_/D _3162_/Y _3168_/Y _3173_/Y VPWR VGND sg13cmos5l_a21oi_1
X_2125_ _2143_/S _2135_/A _2135_/B VPWR VGND sg13cmos5l_nor2_1
X_2056_ _2058_/B _2056_/A _3252_/A VPWR VGND sg13cmos5l_nor2_1
XFILLER_19_180 VPWR VGND sg13cmos5l_decap_8
XFILLER_35_651 VPWR VGND sg13cmos5l_fill_1
XFILLER_23_857 VPWR VGND sg13cmos5l_fill_2
XFILLER_35_695 VPWR VGND sg13cmos5l_decap_4
X_2958_ _2958_/Y _2964_/B _2964_/C VPWR VGND sg13cmos5l_nor2_1
XFILLER_22_389 VPWR VGND sg13cmos5l_decap_8
X_2889_ _2890_/B _2888_/B _2887_/Y _2888_/Y VPWR VGND sg13cmos5l_a21oi_1
XFILLER_2_706 VPWR VGND sg13cmos5l_decap_8
Xhold530 _1952_/A _3774_/Q VPWR VGND sg13cmos5l_dlygate4sd3_1
Xhold552 hold552/X _3499_/Q VPWR VGND sg13cmos5l_dlygate4sd3_1
Xhold563 hold563/X _3538_/Q VPWR VGND sg13cmos5l_dlygate4sd3_1
Xhold541 _2014_/A _3800_/Q VPWR VGND sg13cmos5l_dlygate4sd3_1
Xhold585 hold585/X _3483_/Q VPWR VGND sg13cmos5l_dlygate4sd3_1
Xhold596 hold596/X _3504_/Q VPWR VGND sg13cmos5l_dlygate4sd3_1
XFILLER_1_249 VPWR VGND sg13cmos5l_fill_2
Xhold574 hold574/X _3512_/Q VPWR VGND sg13cmos5l_dlygate4sd3_1
XFILLER_46_916 VPWR VGND sg13cmos5l_decap_8
XFILLER_26_651 VPWR VGND sg13cmos5l_decap_8
XFILLER_13_323 VPWR VGND sg13cmos5l_decap_8
XFILLER_9_305 VPWR VGND sg13cmos5l_decap_8
XFILLER_9_316 VPWR VGND sg13cmos5l_fill_2
XFILLER_40_164 VPWR VGND sg13cmos5l_decap_4
XFILLER_5_500 VPWR VGND sg13cmos5l_fill_1
XFILLER_5_544 VPWR VGND sg13cmos5l_decap_8
X_3785__427 _3785_/RESET_B VPWR VGND sg13cmos5l_tiehi
X_3529__354 _3529_/RESET_B VPWR VGND sg13cmos5l_tiehi
XFILLER_0_260 VPWR VGND sg13cmos5l_decap_8
XFILLER_1_794 VPWR VGND sg13cmos5l_decap_8
X_3761__460 _3761_/RESET_B VPWR VGND sg13cmos5l_tiehi
XFILLER_49_754 VPWR VGND sg13cmos5l_decap_8
XFILLER_44_481 VPWR VGND sg13cmos5l_decap_8
X_3536__347 _3536_/RESET_B VPWR VGND sg13cmos5l_tiehi
X_2812_ _2812_/Y _3489_/Q _2819_/S0 VPWR VGND sg13cmos5l_nor2b_1
X_3792_ _3792_/Q clkload4/A _3792_/D _3792_/RESET_B VPWR VGND sg13cmos5l_dfrbpq_1
XFILLER_9_850 VPWR VGND sg13cmos5l_decap_8
X_2743_ _2745_/C _3656_/Q _3751_/Q _3719_/Q VPWR VGND sg13cmos5l_nor3_1
X_2674_ _3538_/D input7/X hold563/X _2681_/S VPWR VGND sg13cmos5l_mux2_1
XFILLER_28_1025 VPWR VGND sg13cmos5l_decap_4
X_3723__219 _3723_/RESET_B VPWR VGND sg13cmos5l_tiehi
X_3226_ _3226_/Y _3117_/B _3207_/Y _3220_/A _3223_/Y VPWR VGND sg13cmos5l_a22oi_1
XFILLER_39_264 VPWR VGND sg13cmos5l_decap_8
X_3157_ _3157_/Y _3160_/B _3156_/Y _3155_/Y VPWR VGND sg13cmos5l_a21oi_1
XFILLER_28_927 VPWR VGND sg13cmos5l_decap_8
X_2108_ _2108_/Y _2108_/A _3252_/A VPWR VGND sg13cmos5l_nor2_1
X_3088_ _3095_/B _3088_/A _3669_/Q _3670_/Q VPWR VGND sg13cmos5l_nor3_1
X_2039_ _2039_/Y _2698_/A _2564_/A hold765/X VPWR VGND sg13cmos5l_a21oi_1
XFILLER_22_131 VPWR VGND sg13cmos5l_decap_8
XFILLER_23_654 VPWR VGND sg13cmos5l_decap_8
XFILLER_35_1007 VPWR VGND sg13cmos5l_decap_8
XFILLER_22_164 VPWR VGND sg13cmos5l_decap_8
XFILLER_23_698 VPWR VGND sg13cmos5l_fill_2
X_3587__267 _3587_/RESET_B VPWR VGND sg13cmos5l_tiehi
XFILLER_46_702 VPWR VGND sg13cmos5l_decap_8
XFILLER_18_415 VPWR VGND sg13cmos5l_decap_8
XFILLER_34_908 VPWR VGND sg13cmos5l_decap_8
XFILLER_27_971 VPWR VGND sg13cmos5l_decap_8
XFILLER_33_418 VPWR VGND sg13cmos5l_decap_8
XFILLER_42_930 VPWR VGND sg13cmos5l_decap_8
XFILLER_26_481 VPWR VGND sg13cmos5l_decap_8
XFILLER_26_492 VPWR VGND sg13cmos5l_fill_2
XFILLER_13_131 VPWR VGND sg13cmos5l_decap_8
XFILLER_9_113 VPWR VGND sg13cmos5l_fill_2
XFILLER_13_164 VPWR VGND sg13cmos5l_decap_8
XFILLER_9_157 VPWR VGND sg13cmos5l_decap_8
XFILLER_6_820 VPWR VGND sg13cmos5l_decap_8
XFILLER_6_897 VPWR VGND sg13cmos5l_decap_8
X_2390_ _2390_/Y _2381_/Y _2383_/Y _2389_/Y VPWR VGND sg13cmos5l_o21ai_1
XFILLER_3_32 VPWR VGND sg13cmos5l_decap_8
XFILLER_49_573 VPWR VGND sg13cmos5l_fill_2
XFILLER_49_562 VPWR VGND sg13cmos5l_decap_8
X_3011_ _3014_/S _3625_/Q _3011_/B VPWR VGND sg13cmos5l_nor2_1
XFILLER_18_960 VPWR VGND sg13cmos5l_decap_8
XFILLER_24_429 VPWR VGND sg13cmos5l_decap_4
XFILLER_33_985 VPWR VGND sg13cmos5l_decap_8
X_3775_ _3775_/Q clkload1/A _3775_/D _3775_/RESET_B VPWR VGND sg13cmos5l_dfrbpq_1
X_2726_ _2726_/Y _2363_/A _2693_/A _2597_/C VPWR VGND sg13cmos5l_o21ai_1
X_2657_ _3524_/D input10/X hold566/X _2660_/S VPWR VGND sg13cmos5l_mux2_1
X_2588_ _2588_/Y _2593_/A _2587_/X _3806_/Q VPWR VGND sg13cmos5l_o21ai_1
XFILLER_47_16 VPWR VGND sg13cmos5l_decap_4
X_3209_ _3209_/X _3665_/Q _3216_/B _3206_/B VPWR VGND sg13cmos5l_a21o_1
XFILLER_27_256 VPWR VGND sg13cmos5l_fill_2
XFILLER_11_602 VPWR VGND sg13cmos5l_decap_8
XFILLER_24_996 VPWR VGND sg13cmos5l_decap_8
X_3519__364 _3519_/RESET_B VPWR VGND sg13cmos5l_tiehi
XFILLER_10_112 VPWR VGND sg13cmos5l_fill_2
XFILLER_6_116 VPWR VGND sg13cmos5l_decap_4
XFILLER_3_801 VPWR VGND sg13cmos5l_decap_8
XFILLER_3_878 VPWR VGND sg13cmos5l_decap_8
X_3526__357 _3526_/RESET_B VPWR VGND sg13cmos5l_tiehi
XFILLER_37_82 VPWR VGND sg13cmos5l_fill_1
XFILLER_18_256 VPWR VGND sg13cmos5l_decap_8
XFILLER_46_587 VPWR VGND sg13cmos5l_decap_4
XFILLER_15_941 VPWR VGND sg13cmos5l_decap_8
XFILLER_18_1002 VPWR VGND sg13cmos5l_decap_8
XFILLER_42_760 VPWR VGND sg13cmos5l_decap_8
XFILLER_30_933 VPWR VGND sg13cmos5l_decap_8
XFILLER_42_793 VPWR VGND sg13cmos5l_decap_8
X_3560_ _3560_/Q clkload6/A _3560_/D _3560_/RESET_B VPWR VGND sg13cmos5l_dfrbpq_1
X_2511_ _2511_/X _2511_/A _3745_/Q _2511_/C VPWR VGND sg13cmos5l_or3_1
X_3491_ _3491_/Q clkload8/A _3491_/D _3491_/RESET_B VPWR VGND sg13cmos5l_dfrbpq_1
X_2442_ _2442_/Y _2442_/A _2442_/B VPWR VGND sg13cmos5l_nor2_1
X_2373_ _2373_/X _3771_/Q _2376_/A VPWR VGND sg13cmos5l_xor2_1
XFILLER_49_381 VPWR VGND sg13cmos5l_fill_1
XFILLER_37_543 VPWR VGND sg13cmos5l_decap_8
XFILLER_37_565 VPWR VGND sg13cmos5l_decap_8
XFILLER_25_727 VPWR VGND sg13cmos5l_fill_1
XFILLER_40_708 VPWR VGND sg13cmos5l_decap_4
XFILLER_24_248 VPWR VGND sg13cmos5l_decap_8
XFILLER_33_760 VPWR VGND sg13cmos5l_decap_8
XFILLER_21_966 VPWR VGND sg13cmos5l_decap_8
XFILLER_20_476 VPWR VGND sg13cmos5l_decap_8
X_3758_ _3758_/Q _3783_/CLK _3758_/D _3758_/RESET_B VPWR VGND sg13cmos5l_dfrbpq_1
X_2709_ _2709_/Y _2711_/B _2708_/X _2457_/A VPWR VGND sg13cmos5l_o21ai_1
X_3689_ _3689_/Q _3722_/CLK _3689_/D _3689_/RESET_B VPWR VGND sg13cmos5l_dfrbpq_1
XFILLER_0_804 VPWR VGND sg13cmos5l_decap_8
X_3625__223 _3625_/RESET_B VPWR VGND sg13cmos5l_tiehi
XFILLER_16_749 VPWR VGND sg13cmos5l_decap_8
XFILLER_43_568 VPWR VGND sg13cmos5l_fill_2
XFILLER_43_546 VPWR VGND sg13cmos5l_decap_4
XFILLER_8_926 VPWR VGND sg13cmos5l_decap_8
XFILLER_7_403 VPWR VGND sg13cmos5l_decap_8
XFILLER_7_425 VPWR VGND sg13cmos5l_decap_8
XFILLER_11_476 VPWR VGND sg13cmos5l_fill_1
XFILLER_48_1006 VPWR VGND sg13cmos5l_decap_8
XFILLER_3_697 VPWR VGND sg13cmos5l_decap_8
XFILLER_3_675 VPWR VGND sg13cmos5l_decap_8
XFILLER_47_863 VPWR VGND sg13cmos5l_decap_8
XFILLER_0_77 VPWR VGND sg13cmos5l_decap_8
XFILLER_0_99 VPWR VGND sg13cmos5l_decap_8
X_2991_ _2991_/Y _2979_/B _2979_/C _2987_/A VPWR VGND sg13cmos5l_a21oi_1
XFILLER_14_281 VPWR VGND sg13cmos5l_decap_8
XFILLER_14_292 VPWR VGND sg13cmos5l_fill_1
XFILLER_30_730 VPWR VGND sg13cmos5l_fill_2
XFILLER_30_741 VPWR VGND sg13cmos5l_decap_4
X_1942_ _1942_/Y _2843_/A VPWR VGND sg13cmos5l_inv_1
XFILLER_9_64 VPWR VGND sg13cmos5l_decap_8
X_3612_ _3612_/Q _3665_/CLK _3612_/D _3612_/RESET_B VPWR VGND sg13cmos5l_dfrbpq_1
X_3543_ _3543_/Q clkload7/A _3543_/D _3543_/RESET_B VPWR VGND sg13cmos5l_dfrbpq_1
XFILLER_7_981 VPWR VGND sg13cmos5l_decap_8
X_3474_ _3474_/Y _2161_/B _3469_/A _3463_/B VPWR VGND sg13cmos5l_o21ai_1
X_2425_ _2425_/Y _2420_/Y _2422_/Y _2424_/Y VPWR VGND sg13cmos5l_o21ai_1
XFILLER_9_1011 VPWR VGND sg13cmos5l_decap_8
X_2356_ _2356_/Y _2317_/X _2360_/S _2307_/B VPWR VGND sg13cmos5l_a21oi_1
X_3509__374 _3509_/RESET_B VPWR VGND sg13cmos5l_tiehi
X_2287_ _2287_/Y _2287_/A _2287_/B _2287_/C VPWR VGND sg13cmos5l_nor3_1
XFILLER_44_17 VPWR VGND sg13cmos5l_decap_8
XFILLER_40_516 VPWR VGND sg13cmos5l_decap_8
XFILLER_13_719 VPWR VGND sg13cmos5l_decap_4
XFILLER_40_549 VPWR VGND sg13cmos5l_decap_8
XFILLER_40_538 VPWR VGND sg13cmos5l_decap_4
XFILLER_21_785 VPWR VGND sg13cmos5l_decap_8
XFILLER_21_796 VPWR VGND sg13cmos5l_fill_2
X_3516__367 _3516_/RESET_B VPWR VGND sg13cmos5l_tiehi
XFILLER_5_929 VPWR VGND sg13cmos5l_decap_8
XFILLER_4_428 VPWR VGND sg13cmos5l_decap_8
XFILLER_0_612 VPWR VGND sg13cmos5l_decap_8
XFILLER_0_689 VPWR VGND sg13cmos5l_decap_8
XFILLER_18_51 VPWR VGND sg13cmos5l_decap_8
XFILLER_28_340 VPWR VGND sg13cmos5l_decap_4
XFILLER_44_833 VPWR VGND sg13cmos5l_decap_8
XFILLER_18_95 VPWR VGND sg13cmos5l_decap_8
XFILLER_43_376 VPWR VGND sg13cmos5l_decap_8
XFILLER_34_50 VPWR VGND sg13cmos5l_fill_2
XFILLER_11_251 VPWR VGND sg13cmos5l_decap_8
XFILLER_11_262 VPWR VGND sg13cmos5l_fill_1
XFILLER_7_299 VPWR VGND sg13cmos5l_fill_2
XFILLER_7_288 VPWR VGND sg13cmos5l_decap_8
XFILLER_4_951 VPWR VGND sg13cmos5l_decap_8
X_2210_ _2210_/X _3713_/Q _2210_/B VPWR VGND sg13cmos5l_xor2_1
X_3190_ _3666_/D _3190_/A _3190_/B VPWR VGND sg13cmos5l_nor2_1
XFILLER_39_649 VPWR VGND sg13cmos5l_decap_8
X_2141_ _2141_/X _2228_/B _2217_/A VPWR VGND sg13cmos5l_and2_1
XFILLER_15_4 VPWR VGND sg13cmos5l_decap_8
XFILLER_22_1009 VPWR VGND sg13cmos5l_decap_8
X_2072_ _2072_/Y _2072_/A _3461_/B VPWR VGND sg13cmos5l_nand2_1
XFILLER_47_660 VPWR VGND sg13cmos5l_fill_2
XFILLER_34_354 VPWR VGND sg13cmos5l_decap_8
XFILLER_35_877 VPWR VGND sg13cmos5l_decap_4
XFILLER_35_899 VPWR VGND sg13cmos5l_decap_8
X_2974_ _2974_/Y _3592_/Q _3593_/Q VPWR VGND sg13cmos5l_xnor2_1
XFILLER_15_590 VPWR VGND sg13cmos5l_decap_8
X_1925_ _1925_/Y _1925_/A VPWR VGND sg13cmos5l_inv_1
Xhold712 _1963_/A _3637_/Q VPWR VGND sg13cmos5l_dlygate4sd3_1
Xhold701 hold701/X _2274_/Y VPWR VGND sg13cmos5l_dlygate4sd3_1
X_3526_ _3526_/Q clkload7/A _3526_/D _3526_/RESET_B VPWR VGND sg13cmos5l_dfrbpq_1
Xhold734 _1987_/A _3639_/Q VPWR VGND sg13cmos5l_dlygate4sd3_1
Xhold745 _2271_/A _3750_/Q VPWR VGND sg13cmos5l_dlygate4sd3_1
Xhold723 _2268_/B _3747_/Q VPWR VGND sg13cmos5l_dlygate4sd3_1
Xhold756 _3136_/B _3640_/Q VPWR VGND sg13cmos5l_dlygate4sd3_1
Xhold767 _2151_/A _3726_/Q VPWR VGND sg13cmos5l_dlygate4sd3_1
Xhold778 _3212_/A _3664_/Q VPWR VGND sg13cmos5l_dlygate4sd3_1
XFILLER_39_17 VPWR VGND sg13cmos5l_decap_8
X_3457_ _3457_/Y _3722_/Q _3458_/A2 _3347_/A VPWR VGND sg13cmos5l_o21ai_1
Xhold789 _3381_/B _3380_/Y VPWR VGND sg13cmos5l_dlygate4sd3_1
X_2408_ _2408_/X _2399_/S _2406_/X _2407_/Y VPWR VGND sg13cmos5l_a21o_1
X_3388_ _3388_/Y _3388_/A _3388_/B _3388_/C VPWR VGND sg13cmos5l_nor3_1
X_2339_ _2345_/A _2340_/A _2340_/B _2338_/Y _2341_/A _2317_/X VPWR VGND sg13cmos5l_a221oi_1
XFILLER_38_1005 VPWR VGND sg13cmos5l_decap_8
XFILLER_37_181 VPWR VGND sg13cmos5l_decap_4
XFILLER_26_888 VPWR VGND sg13cmos5l_decap_8
XFILLER_41_836 VPWR VGND sg13cmos5l_decap_8
XFILLER_13_538 VPWR VGND sg13cmos5l_decap_8
XFILLER_5_726 VPWR VGND sg13cmos5l_decap_8
XFILLER_4_203 VPWR VGND sg13cmos5l_decap_8
XFILLER_20_41 VPWR VGND sg13cmos5l_decap_8
XFILLER_4_269 VPWR VGND sg13cmos5l_decap_8
XFILLER_0_431 VPWR VGND sg13cmos5l_decap_8
XFILLER_1_976 VPWR VGND sg13cmos5l_decap_8
XFILLER_49_936 VPWR VGND sg13cmos5l_decap_8
XFILLER_17_822 VPWR VGND sg13cmos5l_decap_8
XFILLER_29_660 VPWR VGND sg13cmos5l_decap_8
XFILLER_16_398 VPWR VGND sg13cmos5l_fill_1
XFILLER_31_313 VPWR VGND sg13cmos5l_decap_4
XFILLER_31_346 VPWR VGND sg13cmos5l_decap_4
XFILLER_31_357 VPWR VGND sg13cmos5l_decap_8
XFILLER_31_379 VPWR VGND sg13cmos5l_decap_8
X_2690_ _3547_/D _3477_/A _3477_/B _3477_/C VPWR VGND sg13cmos5l_nor3_1
XFILLER_6_76 VPWR VGND sg13cmos5l_fill_1
XFILLER_6_65 VPWR VGND sg13cmos5l_decap_8
X_3311_ _3320_/C _3703_/Q _3175_/A _3319_/B VPWR VGND sg13cmos5l_o21ai_1
X_3242_ _3265_/B _3249_/B _3249_/C VPWR VGND sg13cmos5l_nand2_1
X_3173_ _3173_/Y hold720/X _3168_/Y _3108_/A VPWR VGND sg13cmos5l_o21ai_1
X_2124_ _2135_/B _2064_/X _2069_/A _2121_/Y _2123_/Y _2069_/B VPWR VGND sg13cmos5l_a221oi_1
X_3506__377 _3506_/RESET_B VPWR VGND sg13cmos5l_tiehi
XFILLER_39_479 VPWR VGND sg13cmos5l_fill_1
XFILLER_27_619 VPWR VGND sg13cmos5l_fill_1
X_2055_ _2130_/B _3703_/Q _2055_/B VPWR VGND sg13cmos5l_xnor2_1
XFILLER_26_129 VPWR VGND sg13cmos5l_decap_4
XFILLER_34_140 VPWR VGND sg13cmos5l_decap_8
XFILLER_35_674 VPWR VGND sg13cmos5l_decap_8
XFILLER_23_836 VPWR VGND sg13cmos5l_fill_1
XFILLER_22_357 VPWR VGND sg13cmos5l_fill_2
X_2957_ _2964_/C _2944_/A _2944_/B _2953_/X _2955_/Y _2956_/X VPWR VGND sg13cmos5l_a221oi_1
XFILLER_22_379 VPWR VGND sg13cmos5l_decap_4
X_2888_ _2888_/Y _2888_/A _2888_/B VPWR VGND sg13cmos5l_nor2_1
XFILLER_30_390 VPWR VGND sg13cmos5l_fill_2
Xhold520 _2738_/B _3567_/Q VPWR VGND sg13cmos5l_dlygate4sd3_1
Xhold553 hold553/X _3534_/Q VPWR VGND sg13cmos5l_dlygate4sd3_1
Xhold531 _3774_/D _2448_/Y VPWR VGND sg13cmos5l_dlygate4sd3_1
Xhold542 hold542/X _2594_/Y VPWR VGND sg13cmos5l_dlygate4sd3_1
Xhold564 hold564/X _3517_/Q VPWR VGND sg13cmos5l_dlygate4sd3_1
Xhold586 hold586/X _3535_/Q VPWR VGND sg13cmos5l_dlygate4sd3_1
X_3509_ _3509_/Q _3574_/CLK _3509_/D _3509_/RESET_B VPWR VGND sg13cmos5l_dfrbpq_1
XFILLER_1_217 VPWR VGND sg13cmos5l_decap_8
Xhold597 _2291_/A _3802_/Q VPWR VGND sg13cmos5l_dlygate4sd3_1
Xhold575 hold575/X _3481_/Q VPWR VGND sg13cmos5l_dlygate4sd3_1
XFILLER_39_980 VPWR VGND sg13cmos5l_decap_8
XFILLER_13_302 VPWR VGND sg13cmos5l_decap_8
XFILLER_14_836 VPWR VGND sg13cmos5l_fill_2
XFILLER_26_685 VPWR VGND sg13cmos5l_decap_8
XFILLER_41_677 VPWR VGND sg13cmos5l_decap_8
XFILLER_14_869 VPWR VGND sg13cmos5l_decap_4
XFILLER_22_891 VPWR VGND sg13cmos5l_decap_8
XFILLER_5_512 VPWR VGND sg13cmos5l_decap_4
XFILLER_1_773 VPWR VGND sg13cmos5l_decap_8
XFILLER_48_287 VPWR VGND sg13cmos5l_fill_1
XFILLER_48_265 VPWR VGND sg13cmos5l_fill_2
XFILLER_36_416 VPWR VGND sg13cmos5l_fill_1
XFILLER_45_994 VPWR VGND sg13cmos5l_decap_8
XFILLER_44_460 VPWR VGND sg13cmos5l_decap_8
XFILLER_31_143 VPWR VGND sg13cmos5l_decap_4
XFILLER_32_644 VPWR VGND sg13cmos5l_fill_2
X_2811_ _2811_/Y _2819_/S0 _3540_/Q _2810_/Y VPWR VGND sg13cmos5l_o21ai_1
X_3791_ _3791_/Q clkload4/A _3791_/D _3791_/RESET_B VPWR VGND sg13cmos5l_dfrbpq_1
XFILLER_20_839 VPWR VGND sg13cmos5l_fill_1
XFILLER_32_688 VPWR VGND sg13cmos5l_decap_8
X_2742_ _2745_/B _2742_/A _2742_/B _2742_/C VPWR VGND sg13cmos5l_nand3_1
X_2673_ _3537_/D input6/X hold581/X _2681_/S VPWR VGND sg13cmos5l_mux2_1
XFILLER_28_1004 VPWR VGND sg13cmos5l_decap_8
XFILLER_39_210 VPWR VGND sg13cmos5l_decap_8
X_3225_ _3225_/Y _3215_/Y _3218_/Y _3224_/Y VPWR VGND sg13cmos5l_o21ai_1
XFILLER_28_906 VPWR VGND sg13cmos5l_fill_2
X_3156_ _3156_/Y _3671_/Q _3348_/A VPWR VGND sg13cmos5l_nor2b_1
X_3087_ _3087_/Y _3087_/A _3087_/B _3087_/C VPWR VGND sg13cmos5l_nand3_1
X_2107_ _2138_/B _2105_/Y _2106_/Y _2048_/Y VPWR VGND sg13cmos5l_o21ai_1
Xclkbuf_leaf_19_clk _3783_/CLK clkbuf_leaf_2_clk/A VPWR VGND sg13cmos5l_buf_8
X_2038_ _3808_/D _3806_/D _3803_/D VPWR VGND sg13cmos5l_or2_1
XFILLER_36_994 VPWR VGND sg13cmos5l_decap_8
XFILLER_10_316 VPWR VGND sg13cmos5l_decap_8
XFILLER_10_338 VPWR VGND sg13cmos5l_decap_8
XFILLER_19_906 VPWR VGND sg13cmos5l_fill_2
XFILLER_19_928 VPWR VGND sg13cmos5l_fill_1
XFILLER_46_769 VPWR VGND sg13cmos5l_decap_8
XFILLER_18_427 VPWR VGND sg13cmos5l_fill_1
XFILLER_27_950 VPWR VGND sg13cmos5l_decap_8
X_3791__421 _3791_/RESET_B VPWR VGND sg13cmos5l_tiehi
XFILLER_14_622 VPWR VGND sg13cmos5l_decap_8
XFILLER_41_430 VPWR VGND sg13cmos5l_decap_8
XFILLER_13_121 VPWR VGND sg13cmos5l_decap_8
XFILLER_42_986 VPWR VGND sg13cmos5l_decap_8
XFILLER_41_485 VPWR VGND sg13cmos5l_decap_8
XFILLER_41_496 VPWR VGND sg13cmos5l_fill_2
XFILLER_13_187 VPWR VGND sg13cmos5l_decap_8
XFILLER_10_872 VPWR VGND sg13cmos5l_decap_8
XFILLER_5_331 VPWR VGND sg13cmos5l_decap_4
XFILLER_10_883 VPWR VGND sg13cmos5l_decap_8
XFILLER_6_876 VPWR VGND sg13cmos5l_decap_8
XFILLER_5_397 VPWR VGND sg13cmos5l_fill_1
XFILLER_49_541 VPWR VGND sg13cmos5l_decap_8
XFILLER_37_725 VPWR VGND sg13cmos5l_fill_2
XFILLER_37_714 VPWR VGND sg13cmos5l_fill_1
X_3010_ _3011_/B _3016_/B _3007_/Y _3009_/Y VPWR VGND sg13cmos5l_o21ai_1
X_3542__341 _3542_/RESET_B VPWR VGND sg13cmos5l_tiehi
XFILLER_45_791 VPWR VGND sg13cmos5l_decap_8
XFILLER_17_460 VPWR VGND sg13cmos5l_fill_2
X_3692__330 _3692_/RESET_B VPWR VGND sg13cmos5l_tiehi
XFILLER_33_964 VPWR VGND sg13cmos5l_decap_8
XFILLER_32_463 VPWR VGND sg13cmos5l_fill_1
XFILLER_20_636 VPWR VGND sg13cmos5l_decap_8
X_3774_ _3774_/Q clkload1/A _3774_/D _3774_/RESET_B VPWR VGND sg13cmos5l_dfrbpq_1
X_2725_ _3560_/D _2725_/A _2725_/B VPWR VGND sg13cmos5l_nand2_1
Xclkbuf_leaf_8_clk clkload9/A clkbuf_leaf_9_clk/A VPWR VGND sg13cmos5l_buf_8
X_2656_ _3523_/D _1993_/Y _2725_/A _2655_/Y VPWR VGND sg13cmos5l_a21oi_1
X_2587_ _2587_/X _2587_/A _3798_/Q VPWR VGND sg13cmos5l_and2_1
X_3727__175 _3727_/RESET_B VPWR VGND sg13cmos5l_tiehi
XFILLER_41_1012 VPWR VGND sg13cmos5l_decap_8
X_3208_ _3208_/Y _3208_/A _3216_/B VPWR VGND sg13cmos5l_nand2_1
X_3139_ _3647_/D _3143_/A _3139_/B VPWR VGND sg13cmos5l_nor2_1
XFILLER_27_235 VPWR VGND sg13cmos5l_decap_8
XFILLER_42_216 VPWR VGND sg13cmos5l_decap_8
XFILLER_36_791 VPWR VGND sg13cmos5l_decap_8
XFILLER_24_920 VPWR VGND sg13cmos5l_fill_1
X_3593__261 _3593_/RESET_B VPWR VGND sg13cmos5l_tiehi
XFILLER_24_975 VPWR VGND sg13cmos5l_decap_8
XFILLER_6_139 VPWR VGND sg13cmos5l_fill_1
XFILLER_10_179 VPWR VGND sg13cmos5l_decap_4
XFILLER_12_75 VPWR VGND sg13cmos5l_decap_8
XFILLER_2_301 VPWR VGND sg13cmos5l_decap_8
XFILLER_3_857 VPWR VGND sg13cmos5l_decap_8
XFILLER_46_500 VPWR VGND sg13cmos5l_fill_2
XFILLER_46_522 VPWR VGND sg13cmos5l_decap_4
XFILLER_19_736 VPWR VGND sg13cmos5l_decap_8
XFILLER_19_747 VPWR VGND sg13cmos5l_fill_2
XFILLER_46_566 VPWR VGND sg13cmos5l_decap_8
XFILLER_18_235 VPWR VGND sg13cmos5l_fill_1
XFILLER_19_769 VPWR VGND sg13cmos5l_fill_1
XFILLER_15_997 VPWR VGND sg13cmos5l_decap_8
XFILLER_30_912 VPWR VGND sg13cmos5l_decap_8
XFILLER_30_989 VPWR VGND sg13cmos5l_decap_8
X_3490_ _3490_/Q clkload7/A _3490_/D _3490_/RESET_B VPWR VGND sg13cmos5l_dfrbpq_1
XFILLER_6_640 VPWR VGND sg13cmos5l_decap_8
X_2510_ _2510_/Y _2403_/X _2527_/A _2508_/Y _2408_/X VPWR VGND sg13cmos5l_a22oi_1
X_2441_ _2441_/Y _2442_/A _2442_/B _2437_/Y VPWR VGND sg13cmos5l_a21oi_1
XFILLER_45_4 VPWR VGND sg13cmos5l_fill_2
XFILLER_5_183 VPWR VGND sg13cmos5l_decap_8
X_2372_ _2372_/Y _3771_/Q _2376_/A VPWR VGND sg13cmos5l_nand2_1
X_3800__203 _3800_/RESET_B VPWR VGND sg13cmos5l_tiehi
XFILLER_24_205 VPWR VGND sg13cmos5l_decap_8
XFILLER_33_783 VPWR VGND sg13cmos5l_fill_2
XFILLER_21_945 VPWR VGND sg13cmos5l_decap_8
XFILLER_32_293 VPWR VGND sg13cmos5l_decap_4
XFILLER_20_455 VPWR VGND sg13cmos5l_decap_8
X_3757_ _3757_/Q clkload3/A _3757_/D _3757_/RESET_B VPWR VGND sg13cmos5l_dfrbpq_1
X_2708_ _2708_/X _2708_/A _2717_/B VPWR VGND sg13cmos5l_xor2_1
X_3688_ _3688_/Q _3722_/CLK _3688_/D _3688_/RESET_B VPWR VGND sg13cmos5l_dfrbpq_1
X_2639_ _2648_/S _2663_/A _2650_/C VPWR VGND sg13cmos5l_nand2_1
XFILLER_43_525 VPWR VGND sg13cmos5l_decap_8
XFILLER_28_599 VPWR VGND sg13cmos5l_fill_2
XFILLER_24_761 VPWR VGND sg13cmos5l_fill_2
XFILLER_8_905 VPWR VGND sg13cmos5l_decap_8
XFILLER_11_411 VPWR VGND sg13cmos5l_decap_8
XFILLER_11_422 VPWR VGND sg13cmos5l_fill_2
XFILLER_12_945 VPWR VGND sg13cmos5l_fill_2
XFILLER_11_455 VPWR VGND sg13cmos5l_decap_4
XFILLER_12_989 VPWR VGND sg13cmos5l_decap_8
XFILLER_23_293 VPWR VGND sg13cmos5l_decap_4
X_3532__351 _3532_/RESET_B VPWR VGND sg13cmos5l_tiehi
XFILLER_3_632 VPWR VGND sg13cmos5l_fill_2
XFILLER_2_164 VPWR VGND sg13cmos5l_decap_8
XFILLER_39_809 VPWR VGND sg13cmos5l_fill_2
XFILLER_2_175 VPWR VGND sg13cmos5l_fill_1
XFILLER_2_197 VPWR VGND sg13cmos5l_fill_2
XFILLER_47_842 VPWR VGND sg13cmos5l_decap_8
XFILLER_19_500 VPWR VGND sg13cmos5l_fill_2
XFILLER_46_341 VPWR VGND sg13cmos5l_fill_1
XFILLER_0_56 VPWR VGND sg13cmos5l_decap_8
XFILLER_19_577 VPWR VGND sg13cmos5l_decap_8
X_2990_ _3619_/D _3030_/B _3055_/A VPWR VGND sg13cmos5l_and2_1
XFILLER_15_750 VPWR VGND sg13cmos5l_decap_8
XFILLER_42_591 VPWR VGND sg13cmos5l_decap_8
XFILLER_9_32 VPWR VGND sg13cmos5l_decap_8
XFILLER_14_260 VPWR VGND sg13cmos5l_decap_8
X_1941_ _1941_/Y _2846_/A VPWR VGND sg13cmos5l_inv_1
X_3611_ _3611_/Q clkload9/A _3611_/D _3611_/RESET_B VPWR VGND sg13cmos5l_dfrbpq_1
XFILLER_7_960 VPWR VGND sg13cmos5l_decap_8
X_3542_ _3542_/Q clkload8/A _3542_/D _3542_/RESET_B VPWR VGND sg13cmos5l_dfrbpq_1
X_3473_ _3732_/D hold744/X _3469_/A _3472_/Y VPWR VGND sg13cmos5l_a21oi_1
X_2424_ _2424_/Y _3749_/Q _1965_/Y _3794_/Q _2423_/Y VPWR VGND sg13cmos5l_a22oi_1
X_2355_ _2357_/A _2341_/A _2338_/Y _2360_/S VPWR VGND sg13cmos5l_a21oi_1
XFILLER_36_0 VPWR VGND sg13cmos5l_fill_2
X_3583__271 _3583_/RESET_B VPWR VGND sg13cmos5l_tiehi
X_2286_ _2287_/C _2286_/A _2286_/B VPWR VGND sg13cmos5l_nor2_1
XFILLER_38_886 VPWR VGND sg13cmos5l_decap_8
XFILLER_21_720 VPWR VGND sg13cmos5l_fill_1
XFILLER_20_241 VPWR VGND sg13cmos5l_decap_8
XFILLER_21_753 VPWR VGND sg13cmos5l_fill_1
XFILLER_21_764 VPWR VGND sg13cmos5l_decap_8
X_3590__264 _3590_/RESET_B VPWR VGND sg13cmos5l_tiehi
X_3809_ _3809_/Q _3809_/CLK _3809_/D _3809_/RESET_B VPWR VGND sg13cmos5l_dfrbpq_1
XFILLER_5_908 VPWR VGND sg13cmos5l_decap_8
XFILLER_28_330 VPWR VGND sg13cmos5l_fill_1
XFILLER_44_812 VPWR VGND sg13cmos5l_decap_8
X_3595__120 _3595_/D VPWR VGND sg13cmos5l_tielo
XFILLER_43_333 VPWR VGND sg13cmos5l_fill_1
XFILLER_28_385 VPWR VGND sg13cmos5l_decap_4
XFILLER_44_889 VPWR VGND sg13cmos5l_decap_8
XFILLER_11_230 VPWR VGND sg13cmos5l_decap_8
XFILLER_7_234 VPWR VGND sg13cmos5l_decap_4
XFILLER_4_930 VPWR VGND sg13cmos5l_decap_8
XFILLER_3_484 VPWR VGND sg13cmos5l_decap_8
X_2140_ _2140_/Y _3419_/B VPWR VGND sg13cmos5l_inv_1
X_2071_ _3467_/A _2146_/B _3416_/B VPWR VGND sg13cmos5l_nor2_1
XFILLER_47_683 VPWR VGND sg13cmos5l_decap_8
XFILLER_19_363 VPWR VGND sg13cmos5l_fill_2
XFILLER_35_801 VPWR VGND sg13cmos5l_decap_8
XFILLER_35_812 VPWR VGND sg13cmos5l_decap_8
XFILLER_46_182 VPWR VGND sg13cmos5l_fill_1
XFILLER_35_845 VPWR VGND sg13cmos5l_decap_8
XFILLER_35_856 VPWR VGND sg13cmos5l_fill_2
X_2973_ _2973_/X _2979_/B _2979_/C _2979_/A VPWR VGND sg13cmos5l_a21o_1
X_1924_ _1924_/Y _2072_/A VPWR VGND sg13cmos5l_inv_1
Xhold702 _2899_/B _3598_/Q VPWR VGND sg13cmos5l_dlygate4sd3_1
X_3525_ _3525_/Q clkload8/A _3525_/D _3525_/RESET_B VPWR VGND sg13cmos5l_dfrbpq_1
Xhold724 hold724/X _2268_/Y VPWR VGND sg13cmos5l_dlygate4sd3_1
Xhold746 hold746/X _2269_/S VPWR VGND sg13cmos5l_dlygate4sd3_1
Xhold735 _2019_/B _3806_/Q VPWR VGND sg13cmos5l_dlygate4sd3_1
Xhold713 _3016_/B _3624_/Q VPWR VGND sg13cmos5l_dlygate4sd3_1
Xhold757 hold757/X _3611_/Q VPWR VGND sg13cmos5l_dlygate4sd3_1
Xhold768 _3470_/A _2154_/A VPWR VGND sg13cmos5l_dlygate4sd3_1
Xhold779 _3213_/B _3212_/Y VPWR VGND sg13cmos5l_dlygate4sd3_1
X_3456_ _3456_/Y _1927_/Y _3458_/A2 _3455_/Y VPWR VGND sg13cmos5l_a21oi_1
X_2407_ _2407_/Y _2376_/A _2376_/B _2390_/Y _2394_/Y _2396_/A VPWR VGND sg13cmos5l_a221oi_1
X_3387_ _3388_/C _3398_/A _3387_/B VPWR VGND sg13cmos5l_nor2_1
X_2338_ _2338_/Y _2342_/B _2338_/B VPWR VGND sg13cmos5l_nor2_1
X_2269_ _2270_/B hold724/X _2254_/Y _2269_/S VPWR VGND sg13cmos5l_mux2_1
XFILLER_38_683 VPWR VGND sg13cmos5l_decap_8
XFILLER_38_694 VPWR VGND sg13cmos5l_fill_2
X_3522__361 _3522_/RESET_B VPWR VGND sg13cmos5l_tiehi
XFILLER_38_1028 VPWR VGND sg13cmos5l_fill_1
XFILLER_21_583 VPWR VGND sg13cmos5l_decap_8
XFILLER_4_248 VPWR VGND sg13cmos5l_decap_8
XFILLER_0_410 VPWR VGND sg13cmos5l_fill_2
XFILLER_49_915 VPWR VGND sg13cmos5l_decap_8
XFILLER_1_955 VPWR VGND sg13cmos5l_decap_8
XFILLER_17_801 VPWR VGND sg13cmos5l_decap_8
XFILLER_35_108 VPWR VGND sg13cmos5l_decap_4
XFILLER_44_697 VPWR VGND sg13cmos5l_decap_8
XFILLER_43_185 VPWR VGND sg13cmos5l_fill_1
XFILLER_43_174 VPWR VGND sg13cmos5l_decap_8
XFILLER_31_325 VPWR VGND sg13cmos5l_fill_1
XFILLER_12_572 VPWR VGND sg13cmos5l_fill_2
XFILLER_6_44 VPWR VGND sg13cmos5l_decap_8
X_3310_ _3310_/Y _3655_/Q _3310_/B VPWR VGND sg13cmos5l_nor2_1
X_3241_ _3249_/C _3672_/Q _3673_/Q _3674_/Q VPWR VGND sg13cmos5l_o21ai_1
XFILLER_39_414 VPWR VGND sg13cmos5l_decap_8
X_3172_ _3172_/Y _3159_/B _3168_/Y _3171_/Y VPWR VGND sg13cmos5l_a21oi_1
XFILLER_39_469 VPWR VGND sg13cmos5l_decap_4
XFILLER_39_458 VPWR VGND sg13cmos5l_fill_2
X_2123_ _2123_/Y _2211_/A _2123_/B VPWR VGND sg13cmos5l_nor2_1
XFILLER_27_609 VPWR VGND sg13cmos5l_fill_1
XFILLER_48_992 VPWR VGND sg13cmos5l_decap_8
X_2054_ _3252_/A _3466_/A _2055_/B VPWR VGND sg13cmos5l_xnor2_1
XFILLER_19_171 VPWR VGND sg13cmos5l_fill_1
XFILLER_35_631 VPWR VGND sg13cmos5l_decap_8
XFILLER_23_815 VPWR VGND sg13cmos5l_decap_8
XFILLER_22_336 VPWR VGND sg13cmos5l_fill_2
X_2956_ _2956_/X _2956_/A _2956_/B _2956_/C VPWR VGND sg13cmos5l_and3_1
X_2887_ _2887_/Y _3031_/A _3028_/A VPWR VGND sg13cmos5l_nand2_1
XFILLER_31_892 VPWR VGND sg13cmos5l_decap_4
Xhold510 _1932_/A _3657_/Q VPWR VGND sg13cmos5l_dlygate4sd3_1
Xhold521 _3567_/D _2739_/Y VPWR VGND sg13cmos5l_dlygate4sd3_1
Xhold543 _3800_/D _2595_/Y VPWR VGND sg13cmos5l_dlygate4sd3_1
Xhold554 hold554/X _3528_/Q VPWR VGND sg13cmos5l_dlygate4sd3_1
Xhold532 _3203_/A _3659_/Q VPWR VGND sg13cmos5l_dlygate4sd3_1
X_3508_ _3508_/Q clkload8/A _3508_/D _3508_/RESET_B VPWR VGND sg13cmos5l_dfrbpq_1
Xhold576 hold576/X _3480_/Q VPWR VGND sg13cmos5l_dlygate4sd3_1
Xhold565 hold565/X _3521_/Q VPWR VGND sg13cmos5l_dlygate4sd3_1
Xhold587 hold587/X _3498_/Q VPWR VGND sg13cmos5l_dlygate4sd3_1
X_3439_ _3439_/Y _3439_/A VPWR VGND sg13cmos5l_inv_1
Xhold598 hold598/X _3520_/Q VPWR VGND sg13cmos5l_dlygate4sd3_1
XFILLER_45_417 VPWR VGND sg13cmos5l_decap_4
XFILLER_14_859 VPWR VGND sg13cmos5l_fill_1
XFILLER_15_53 VPWR VGND sg13cmos5l_decap_8
XFILLER_22_870 VPWR VGND sg13cmos5l_decap_8
XFILLER_40_188 VPWR VGND sg13cmos5l_fill_2
XFILLER_5_579 VPWR VGND sg13cmos5l_decap_4
XFILLER_1_752 VPWR VGND sg13cmos5l_decap_8
XFILLER_49_789 VPWR VGND sg13cmos5l_decap_8
XFILLER_45_973 VPWR VGND sg13cmos5l_decap_8
XFILLER_32_623 VPWR VGND sg13cmos5l_fill_1
XFILLER_20_807 VPWR VGND sg13cmos5l_decap_8
XFILLER_31_122 VPWR VGND sg13cmos5l_decap_8
XFILLER_32_667 VPWR VGND sg13cmos5l_decap_8
X_3790_ _3790_/Q clkload3/A _3790_/D _3790_/RESET_B VPWR VGND sg13cmos5l_dfrbpq_1
XFILLER_13_881 VPWR VGND sg13cmos5l_fill_2
X_2810_ _2810_/Y _2810_/A1 _1993_/Y _2810_/B1 VPWR VGND sg13cmos5l_a21oi_1
XFILLER_13_892 VPWR VGND sg13cmos5l_decap_8
X_2741_ _2742_/C _2741_/A _2015_/B VPWR VGND sg13cmos5l_nor2b_1
XFILLER_8_340 VPWR VGND sg13cmos5l_decap_4
XFILLER_9_885 VPWR VGND sg13cmos5l_decap_8
X_2672_ _2680_/S _2672_/A _2708_/A _2672_/C VPWR VGND sg13cmos5l_nand3_1
X_3512__371 _3512_/RESET_B VPWR VGND sg13cmos5l_tiehi
X_3224_ _3224_/Y _3215_/A _3215_/B _3220_/Y _3223_/A VPWR VGND sg13cmos5l_a22oi_1
.ends
